* NGSPICE file created from CP_lvs.ext - technology: ihp-sg13g2

.subckt CP_lvs CTRL2 CTRL VDD CTRL1 GND Vbn Ibias UP DN
X0 a_n15995_15200# a_4075_15440# rsil l=100u w=0.5u
X1 a_n12027_n1680# VDD GND GND sg13_lv_nmos ad=1.02p pd=6.68u as=1.02p ps=6.68u w=3u l=2u
X2 Vbn Vbn a_n12027_n1680# GND sg13_lv_nmos ad=1.02p pd=6.68u as=1.02p ps=6.68u w=3u l=2u
X3 a_n15985_11101# a_4085_11341# rsil l=100u w=0.5u
X4 a_n15995_15680# a_4075_15920# rsil l=100u w=0.5u
X5 CTRL GND cap_cmim l=60u w=60u
X6 a_n15995_12800# CTRL1 rsil l=100u w=0.5u
X7 a_n15985_11581# a_4085_11821# rsil l=100u w=0.5u
X8 CTRL1 GND cap_cmim l=15u w=20u
X9 a_n15995_15680# a_4075_15440# rsil l=100u w=0.5u
X10 a_n15995_16160# a_4075_16400# rsil l=100u w=0.5u
X11 a_n15985_11581# a_4085_11341# rsil l=100u w=0.5u
X12 Vbn Ibias a_n12027_1365# VDD sg13_lv_pmos ad=3.4p pd=20.68u as=3.4p ps=20.68u w=10u l=2u
X13 CTRL2 GND cap_cmim l=40u w=40u
X14 a_n15985_12061# CTRL1 rsil l=100u w=0.5u
X15 a_n15031_1369# GND VDD VDD sg13_lv_pmos ad=3.4p pd=20.68u as=3.4p ps=20.68u w=10u l=2u
X16 Ibias Ibias a_n15031_1369# VDD sg13_lv_pmos ad=3.4p pd=20.68u as=3.4p ps=20.68u w=10u l=2u
X17 CTRL1 Ibias a_n9531_1359# VDD sg13_lv_pmos ad=3.4p pd=20.68u as=3.4p ps=20.68u w=10u l=2u
X18 a_n15995_16160# a_4075_15920# rsil l=100u w=0.5u
X19 a_n15995_12800# a_4075_13040# rsil l=100u w=0.5u
X20 a_n15985_12061# a_4085_11821# rsil l=100u w=0.5u
X21 CTRL1 GND cap_cmim l=15u w=20u
X22 a_n15995_16640# a_4075_16400# rsil l=100u w=0.5u
X23 a_n15995_13280# a_4075_13520# rsil l=100u w=0.5u
X24 a_n15995_17120# a_4075_16880# rsil l=100u w=0.5u
X25 a_n15995_13280# a_4075_13040# rsil l=100u w=0.5u
X26 a_n15995_16640# a_4075_16880# rsil l=100u w=0.5u
X27 a_n15995_13760# a_4075_14000# rsil l=100u w=0.5u
X28 a_n15995_17600# a_4075_17360# rsil l=100u w=0.5u
X29 a_n15995_13760# a_4075_13520# rsil l=100u w=0.5u
X30 CTRL1 Vbn a_n9528_n1680# GND sg13_lv_nmos ad=1.02p pd=6.68u as=1.02p ps=6.68u w=3u l=2u
X31 a_n15995_17120# a_4075_17360# rsil l=100u w=0.5u
X32 CTRL1 GND cap_cmim l=15u w=20u
X33 a_n15995_14240# a_4075_14000# rsil l=100u w=0.5u
X34 a_n15995_17600# a_4075_17840# rsil l=100u w=0.5u
X35 a_n15985_10141# CTRL rsil l=100u w=0.5u
X36 a_n15995_14720# a_4075_14480# rsil l=100u w=0.5u
X37 CTRL2 GND cap_cmim l=40u w=40u
X38 a_n15985_10621# a_4085_10381# rsil l=100u w=0.5u
X39 CTRL2 GND cap_cmim l=40u w=40u
X40 a_n15995_18080# a_4075_18320# rsil l=100u w=0.5u
X41 a_n15995_14240# a_4075_14480# rsil l=100u w=0.5u
X42 CTRL1 GND cap_cmim l=15u w=20u
X43 a_n15995_15200# a_4075_14960# rsil l=100u w=0.5u
X44 a_n15985_10141# a_4085_10381# rsil l=100u w=0.5u
X45 a_n15995_14720# a_4075_14960# rsil l=100u w=0.5u
X46 a_n15985_11101# a_4085_10861# rsil l=100u w=0.5u
X47 a_n9531_1359# UP VDD VDD sg13_lv_pmos ad=3.4p pd=20.68u as=3.4p ps=20.68u w=10u l=2u
X48 a_n15995_18080# a_4075_17840# rsil l=100u w=0.5u
X49 a_n15985_10621# a_4085_10861# rsil l=100u w=0.5u
X50 a_n12027_1365# GND VDD VDD sg13_lv_pmos ad=3.4p pd=20.68u as=3.4p ps=20.68u w=10u l=2u
X51 a_n9528_n1680# DN GND GND sg13_lv_nmos ad=1.02p pd=6.68u as=1.02p ps=6.68u w=3u l=2u
X52 CTRL2 GND cap_cmim l=40u w=40u
X53 CTRL2 a_4075_18320# rsil l=100u w=0.5u
C0 CTRL1 a_4085_11821# 0.04484f
C1 a_n15985_10141# a_n15985_10621# 0.05154f
C2 a_n15925_15920# a_n15925_15680# 1.72382f
C3 a_n15995_12800# CTRL1 0.30878f
C4 a_n15925_14480# a_n15925_14240# 1.72382f
C5 a_n15925_14000# a_4075_14000# 0.02486f
C6 a_n15925_14480# a_n15925_14720# 1.72382f
C7 CTRL CTRL1 0.17732f
C8 a_n15915_11821# a_n15985_11581# 0.02221f
C9 a_n15985_10621# a_n15915_10861# 0.02282f
C10 a_4075_15440# a_4075_15920# 0.07828f
C11 a_n15925_18080# a_n15995_18080# 0.02372f
C12 a_n15985_12061# CTRL1 0.23412f
C13 a_n15925_18080# a_n15925_17840# 1.72382f
C14 a_n15925_14000# a_n15995_13760# 0.02258f
C15 a_4085_10861# a_n15915_10861# 0.02401f
C16 a_n15925_18080# CTRL2 0.01662f
C17 VDD UP 3.42112f
C18 a_4075_17840# a_n15925_18080# 0.02295f
C19 a_n15995_13760# a_n15925_13760# 0.02258f
C20 m2_n11062_3177# UP 0.12521f
C21 a_n15925_13760# a_n15925_13520# 1.72382f
C22 a_n15915_10621# a_n15915_10861# 1.72382f
C23 a_n15925_18080# a_n15925_18320# 1.72382f
C24 DN Ibias 0.10776f
C25 a_n15915_12061# a_4085_11821# 0.0251f
C26 a_n15925_15200# a_n15995_15200# 0.0227f
C27 a_n12027_n1680# VDD 0.07895f
C28 a_n15925_17120# a_n15925_17360# 1.72382f
C29 a_4075_17360# a_n15925_17360# 0.02457f
C30 a_n15915_12301# a_n15985_12061# 0.02319f
C31 CTRL1 a_n15995_13280# 0.26946f
C32 a_4085_10381# a_n15915_10381# 0.0243f
C33 a_n9528_n1680# Vbn 0.08131f
C34 a_n15915_11101# CTRL1 0.03004f
C35 DN Vbn 0.24272f
C36 a_n9531_1359# VDD 0.45036f
C37 a_n15995_18080# CTRL2 0.06662f
C38 a_n15985_10141# a_n15915_10141# 0.0227f
C39 a_n15925_15200# a_n15925_14960# 1.72382f
C40 a_4075_17840# a_n15925_17840# 0.02295f
C41 a_n15985_12061# a_n15915_12061# 0.02319f
C42 a_n15995_17120# a_n15995_17600# 0.04454f
C43 a_n15995_14720# CTRL1 0.26381f
C44 a_n15915_10621# a_n15915_10381# 1.72382f
C45 VDD Ibias 8.12047f
C46 a_n15925_18320# a_n15995_18080# 0.02372f
C47 CTRL2 CTRL1 2.72178f
C48 a_n15925_14720# a_n15995_14720# 0.02258f
C49 a_n15915_11581# a_n15985_11581# 0.02221f
C50 a_n15995_16640# CTRL2 0.02902f
C51 a_n15925_17600# a_n15995_17600# 0.024f
C52 a_n15925_14240# CTRL1 0.01237f
C53 a_4075_14480# a_4075_14000# 0.0641f
C54 m2_n11062_3177# Ibias 0.01138f
C55 a_n15925_18320# CTRL2 0.08539f
C56 a_n15925_13040# a_n15925_12800# 1.72382f
C57 a_n15915_11581# a_n15915_11341# 1.72382f
C58 a_n15915_11101# a_n15985_11101# 0.02184f
C59 VDD Vbn 0.55842f
C60 a_n15995_14240# a_n15995_13760# 0.0643f
C61 a_4085_11341# a_4085_10861# 0.05739f
C62 a_n15985_10141# a_n15915_10381# 0.0227f
C63 a_4075_13520# a_n15925_13760# 0.02233f
C64 a_n15925_16160# a_n15995_16160# 0.02245f
C65 a_4075_13040# a_n15925_13280# 0.02344f
C66 a_4085_11341# a_n15915_11341# 0.02626f
C67 a_4085_10381# CTRL 0.04614f
C68 CTRL Ibias 0.01958f
C69 a_n15995_12800# a_n15925_12800# 0.02319f
C70 a_n15985_11101# CTRL1 0.23445f
C71 a_n15925_14480# a_n15995_14240# 0.02332f
C72 a_n15915_10381# a_n15915_10141# 1.72382f
C73 a_4075_17840# a_4075_17360# 0.04579f
C74 a_n15985_12061# a_n15985_11581# 0.04592f
C75 a_n15925_14480# a_4075_14480# 0.02332f
C76 a_n15925_14000# CTRL1 0.02228f
C77 a_n15925_14000# a_n15925_14240# 1.72382f
C78 a_n15925_15200# a_n15925_15440# 1.72382f
C79 a_n15915_12301# CTRL1 1.65753f
C80 a_n9528_n1680# DN 0.07895f
C81 a_n15915_11581# a_n15915_11821# 1.72382f
C82 a_n15915_10621# CTRL 0.06256f
C83 CTRL2 UP 0.01364f
C84 m2_n14066_3181# Ibias 0.10361f
C85 a_4075_15920# a_n15925_15920# 0.02344f
C86 CTRL1 a_n15915_12061# 0.2262f
C87 a_n15925_15920# a_n15995_15680# 0.02319f
C88 a_n15925_13760# CTRL1 0.03302f
C89 a_4075_18320# a_n15925_18560# 0.02307f
C90 a_n15915_11821# a_4085_11821# 0.02512f
C91 a_n15925_13040# a_n15925_13280# 1.72382f
C92 a_n15925_13280# a_n15925_13520# 1.72382f
C93 a_n15915_11101# a_4085_10861# 0.02401f
C94 Ibias a_n12027_1365# 0.2108f
C95 VDD DN 1.96396f
C96 a_n15995_15200# a_n15925_15440# 0.0227f
C97 a_4075_14960# a_4075_14480# 0.0641f
C98 a_n15925_16880# a_n15995_16640# 0.02258f
C99 a_n15925_13040# a_4075_13040# 0.02344f
C100 a_n9531_1359# CTRL1 0.1388f
C101 a_n15925_15200# a_4075_14960# 0.02488f
C102 a_4075_16400# a_n15925_16400# 0.02516f
C103 a_n15915_10141# CTRL 0.16036f
C104 a_n15915_10861# CTRL 0.0208f
C105 a_n15915_11101# a_n15915_11341# 1.72382f
C106 Vbn a_n12027_1365# 0.13817f
C107 a_n15985_10621# CTRL1 0.21315f
C108 a_n15915_12301# a_n15915_12061# 1.72382f
C109 a_n15925_14000# a_n15925_13760# 1.72382f
C110 CTRL2 Ibias 0.0216f
C111 a_n15031_1369# Ibias 0.34959f
C112 a_n15995_17120# a_n15925_17360# 0.0227f
C113 a_4075_16400# a_4075_15920# 0.06405f
C114 a_n15925_16640# CTRL2 0.01664f
C115 Ibias CTRL1 0.49526f
C116 a_n15995_14240# a_n15995_14720# 0.06447f
C117 a_n15985_11581# CTRL1 0.2205f
C118 a_n15925_16640# a_n15925_16400# 1.72382f
C119 a_n15925_17600# a_n15925_17360# 1.72382f
C120 a_n15925_16640# a_n15995_16640# 0.02258f
C121 a_n15925_12800# CTRL1 2.06597f
C122 a_n15925_16880# a_n15925_17120# 1.72382f
C123 a_n15915_11341# CTRL1 0.03516f
C124 a_n15995_14240# CTRL1 0.23607f
C125 a_n15995_14240# a_n15925_14240# 0.02332f
C126 a_n15915_10621# CTRL1 0.02078f
C127 a_n15925_15680# a_n15925_15440# 1.72382f
C128 Vbn CTRL1 0.27623f
C129 m2_n11062_3177# VDD 0.30981f
C130 a_4075_15440# a_n15925_15680# 0.02457f
C131 a_n15915_10381# CTRL 0.07694f
C132 a_n15985_10621# a_n15985_11101# 0.05781f
C133 a_n15925_14720# a_4075_14480# 0.02332f
C134 a_n15995_18080# a_n15995_17600# 0.04771f
C135 a_n15995_17600# a_n15925_17840# 0.02401f
C136 a_n15915_11581# a_4085_11341# 0.02622f
C137 a_n9531_1359# UP 0.21266f
C138 a_n15915_11101# a_n15915_10861# 1.72382f
C139 a_n15985_11101# a_n15985_11581# 0.04807f
C140 a_n15995_17600# CTRL2 0.02273f
C141 a_n15995_12800# a_n15925_13040# 0.02319f
C142 a_4075_14960# a_n15925_14960# 0.02485f
C143 a_n15925_13280# a_n15995_13280# 0.02245f
C144 a_n15985_10141# CTRL1 0.2258f
C145 VDD CTRL 0.08122f
C146 a_4075_13520# a_4075_13040# 0.06375f
C147 a_4085_11341# a_4085_11821# 0.04764f
C148 a_n15915_11341# a_n15985_11101# 0.02184f
C149 a_n15915_11821# CTRL1 0.09333f
C150 a_n15995_15200# a_n15995_14720# 0.09779f
C151 Ibias UP 2.79421f
C152 a_n15915_12301# a_n15925_12800# 0.59322f
C153 a_n15925_16160# a_n15925_16400# 1.72382f
C154 a_4075_16880# a_4075_17360# 0.04842f
C155 a_4075_16880# a_n15925_17120# 0.02483f
C156 a_4075_15440# a_n15925_15440# 0.02459f
C157 m2_n14066_3181# VDD 0.31084f
C158 a_n15995_17120# CTRL2 0.02236f
C159 a_n15995_15200# CTRL1 0.16328f
C160 a_n15915_10861# CTRL1 0.0202f
C161 a_4075_15920# a_n15925_16160# 0.02344f
C162 a_n15915_10141# CTRL1 0.17519f
C163 a_n15925_17600# a_n15925_17840# 1.72382f
C164 a_n15925_13280# CTRL1 0.10232f
C165 Vbn UP 0.03286f
C166 a_n15995_14720# a_n15925_14960# 0.02258f
C167 a_4075_13520# a_4075_14000# 0.06139f
C168 a_n15995_17120# a_n15995_16640# 0.04835f
C169 a_n15995_15200# a_n15995_15680# 0.07841f
C170 DN CTRL2 0.02112f
C171 a_n15925_16880# a_n15925_16640# 1.72382f
C172 a_n9528_n1680# CTRL1 0.04234f
C173 a_n15995_16160# CTRL2 0.01217f
C174 a_n15925_18560# CTRL2 0.37007f
C175 a_4075_13040# CTRL1 0.05805f
C176 a_4075_13520# a_n15925_13520# 0.02233f
C177 a_n9531_1359# Ibias 0.20827f
C178 a_n15925_14720# a_n15925_14960# 1.72382f
C179 a_n15925_16160# a_n15925_15920# 1.72382f
C180 a_n12027_n1680# Vbn 0.12022f
C181 VDD a_n12027_1365# 0.4504f
C182 a_n15925_16400# a_n15995_16160# 0.02245f
C183 a_4075_17840# a_4075_18320# 0.04768f
C184 a_4075_16400# a_n15925_16640# 0.02514f
C185 a_n15995_13760# a_n15995_13280# 0.06607f
C186 a_n15995_16640# a_n15995_16160# 0.09773f
C187 a_n15925_16880# a_4075_16880# 0.0249f
C188 a_n15925_13520# a_n15995_13280# 0.02245f
C189 a_n15915_10381# CTRL1 0.03899f
C190 a_n15925_18320# a_n15925_18560# 1.72382f
C191 a_4085_10381# a_4085_10861# 0.07465f
C192 a_n15915_11821# a_n15915_12061# 1.72382f
C193 a_4075_18320# a_n15925_18320# 0.02307f
C194 a_n15995_17120# a_n15925_17120# 0.0227f
C195 a_4075_16880# a_4075_16400# 0.09793f
C196 a_4075_15440# a_4075_14960# 0.09792f
C197 a_n15995_15680# a_n15995_16160# 0.06434f
C198 a_n15925_14240# a_4075_14000# 0.02487f
C199 a_n15985_10621# a_n15915_10621# 0.02282f
C200 VDD CTRL2 0.15914f
C201 a_n15031_1369# VDD 0.46374f
C202 a_4075_17360# a_n15925_17600# 0.02456f
C203 a_n15995_12800# a_n15995_13280# 0.07087f
C204 a_n15915_10621# a_4085_10381# 0.0243f
C205 VDD CTRL1 0.90507f
C206 Vbn Ibias 0.51708f
C207 a_n15915_11581# CTRL1 0.05025f
C208 a_n15925_15680# a_n15995_15680# 0.02319f
C209 a_n15995_13760# CTRL1 0.26382f
C210 a_n15925_13040# CTRL1 0.26013f
C211 a_n15925_13520# CTRL1 0.0538f
C212 a_n15915_11101# CTRL 0.0169f
R0 CTRL2 CTRL2.n8 13.0137
R1 CTRL2.n7 CTRL2.n6 0.0421776
R2 CTRL2.n6 CTRL2.n0 0.0367944
R3 CTRL2.n6 CTRL2.n3 0.0362477
R4 CTRL2.n6 CTRL2.n5 0.0351121
R5 CTRL2.n2 CTRL2.n0 0.000790323
R6 CTRL2.n5 CTRL2.n4 0.000790323
R7 CTRL2.n5 CTRL2.n1 0.000790323
R8 CTRL2.n8 CTRL2.n7 0.000790323
R9 CTRL2.n7 CTRL2.n1 0.000642519
R10 CTRL2.n3 CTRL2.n2 0.00056437
R11 CTRL2.n4 CTRL2.n3 0.00056437
R12 CTRL2.n8 CTRL2.n0 0.000540478
R13 CTRL.n2 CTRL.n0 38.2245
R14 CTRL CTRL.n2 19.1912
R15 CTRL.n0 CTRL 0.250043
R16 CTRL CTRL.n0 0.117354
R17 CTRL.n2 CTRL.n1 0.000691489
R18 VDD VDD.n41 29.289
R19 VDD.n22 VDD.n21 28.9753
R20 VDD.n39 VDD.n38 17.0005
R21 VDD.n38 VDD.n16 17.0005
R22 VDD.n38 VDD.n18 17.0005
R23 VDD.n38 VDD.n20 17.0005
R24 VDD.n35 VDD.n13 9.2095
R25 VDD.n22 VDD.n14 9.03413
R26 VDD.n36 VDD.n35 9.0005
R27 VDD.n32 VDD.n31 9.0005
R28 VDD.n30 VDD.n29 9.0005
R29 VDD.n28 VDD.n27 9.0005
R30 VDD.n26 VDD.n25 9.0005
R31 VDD.n24 VDD.n23 9.0005
R32 VDD.n34 VDD.n33 9.0005
R33 VDD.n38 VDD.n14 8.5119
R34 VDD.n38 VDD.n37 8.46715
R35 VDD.n38 VDD.n15 8.45718
R36 VDD.n38 VDD.n17 8.45696
R37 VDD.n38 VDD.n19 8.45497
R38 VDD.n1 VDD 6.24809
R39 VDD.n2 VDD 5.528
R40 VDD.n5 VDD 5.11861
R41 VDD.n8 VDD 3.1905
R42 VDD.n3 VDD.n0 2.43467
R43 VDD.n9 VDD.n6 2.42918
R44 VDD.n11 VDD 2.00125
R45 VDD.n38 VDD.n12 1.77666
R46 VDD.n8 VDD.n7 1.70346
R47 VDD.n41 VDD.n12 1.49467
R48 VDD.n1 VDD.n0 1.18809
R49 VDD.n11 VDD.n10 1.1171
R50 VDD.n5 VDD.n4 0.589934
R51 VDD.n2 VDD.n1 0.497464
R52 VDD.n41 VDD.n40 0.342722
R53 VDD.n0 VDD 0.288727
R54 VDD.n4 VDD 0.217113
R55 VDD.n23 VDD.n14 0.211886
R56 VDD.n26 VDD.n24 0.204
R57 VDD.n30 VDD.n28 0.199187
R58 VDD.n32 VDD.n30 0.197125
R59 VDD.n35 VDD.n34 0.193688
R60 VDD.n7 VDD 0.190177
R61 VDD.n24 VDD.n22 0.188188
R62 VDD.n34 VDD.n32 0.186812
R63 VDD.n28 VDD.n26 0.18475
R64 VDD.n25 VDD.n15 0.171806
R65 VDD.n33 VDD.n20 0.170419
R66 VDD.n37 VDD.n13 0.150973
R67 VDD.n31 VDD.n19 0.146718
R68 VDD.n27 VDD.n16 0.146272
R69 VDD.n29 VDD.n17 0.133793
R70 VDD.n29 VDD.n18 0.131069
R71 VDD.n27 VDD.n17 0.125745
R72 VDD.n31 VDD.n18 0.125703
R73 VDD.n37 VDD.n36 0.122355
R74 VDD.n10 VDD 0.11898
R75 VDD.n33 VDD.n19 0.096637
R76 VDD.n25 VDD.n16 0.0944024
R77 VDD.n23 VDD.n15 0.0940012
R78 VDD.n36 VDD.n20 0.0818821
R79 VDD.n12 VDD.n11 0.0656852
R80 VDD.n40 VDD 0.0626296
R81 VDD.n39 VDD.n13 0.0505813
R82 VDD.n6 VDD.n5 0.0092419
R83 VDD.n7 VDD.n6 0.00780619
R84 VDD.n9 VDD.n8 0.00775193
R85 VDD.n3 VDD.n2 0.00747225
R86 VDD.n40 VDD.n39 0.00676016
R87 VDD.n4 VDD.n3 0.00656612
R88 VDD.n10 VDD.n9 0.00629367
R89 CTRL1 CTRL1.n6 38.2365
R90 CTRL1 CTRL1.n6 19.1905
R91 CTRL1.n4 CTRL1.n3 0.00564933
R92 CTRL1.n4 CTRL1.n0 0.0024318
R93 CTRL1.n3 CTRL1.n1 0.00240502
R94 CTRL1.n3 CTRL1.n2 0.00188829
R95 CTRL1.n5 CTRL1.n4 0.00186104
R96 CTRL1.n6 CTRL1.n5 0.00131818
R97 GND.n7 GND.n6 632047
R98 GND.n8 GND.n7 116.061
R99 GND.n7 GND.n3 57.9309
R100 GND GND.n0 19.1463
R101 GND.n9 GND.n5 17.0005
R102 GND.n10 GND.n5 17.0005
R103 GND.n2 GND.n1 16.7268
R104 GND.n11 GND.n9 8.56208
R105 GND.n12 GND.n8 8.34518
R106 GND.n11 GND.n10 6.55757
R107 GND.n12 GND.n6 5.04043
R108 GND.n14 GND.n13 4.90358
R109 GND.n15 GND.n3 3.1756
R110 GND.n14 GND.n4 3.16623
R111 GND.n17 GND.n3 2.67377
R112 GND.n9 GND.n6 1.57726
R113 GND GND.n17 1.17718
R114 GND.n16 GND.n15 1.03824
R115 GND.n15 GND.n14 0.593047
R116 GND.n17 GND.n16 0.560605
R117 GND.n16 GND 0.321772
R118 GND.n10 GND.n8 0.312641
R119 GND.n2 GND 0.148389
R120 GND GND.n2 0.05
R121 GND.n12 GND.n11 0.0380928
R122 GND.n2 GND 0.0261667
R123 GND.n13 GND.n5 0.00387133
R124 GND.n5 GND.n4 0.00311042
R125 GND.n13 GND.n12 0.00212848
R126 GND.n12 GND.n4 0.00188948
R127 Vbn Vbn.n0 17.8429
R128 Vbn.n3 Vbn.n2 15.7352
R129 Vbn.n3 Vbn.n1 4.29615
R130 Vbn Vbn.n3 1.64867
R131 Ibias Ibias.n0 24.6733
R132 Ibias.n2 Ibias.n1 24.5966
R133 Ibias.n7 Ibias 16.9578
R134 Ibias.n5 Ibias.n4 15.032
R135 Ibias.n6 Ibias.n5 9.32157
R136 Ibias.n5 Ibias.n3 2.53609
R137 Ibias.n2 Ibias 1.8023
R138 Ibias Ibias.n7 1.33957
R139 Ibias.n7 Ibias.n6 0.720633
R140 Ibias.n6 Ibias 0.0723667
R141 Ibias Ibias.n2 0.0379
R142 UP UP.n0 24.7864
R143 DN DN.n0 25.3928
C213 DN GND 13.1144f
C214 UP GND 11.4168f
C215 Vbn GND 5.01689f
C216 Ibias GND 14.4011f
C217 CTRL GND 0.17046p
C218 CTRL1 GND 90.8315f
C219 CTRL2 GND 0.30209p
C220 VDD GND 23.9116f
C221 m2_n11062_3177# GND 0.06437f
C222 m2_n14066_3181# GND 0.07346f
C223 a_n9528_n1680# GND 0.3372f $ **FLOATING
C224 a_n12027_n1680# GND 0.34017f $ **FLOATING
C225 a_n9531_1359# GND 0.34774f $ **FLOATING
C226 a_n12027_1365# GND 0.5546f $ **FLOATING
C227 a_n15031_1369# GND 0.56311f $ **FLOATING
C228 a_n15915_10141# GND 11.4445f
C229 a_n15915_10381# GND 9.44482f
C230 a_n15985_10141# GND 0.2161f $ **FLOATING
C231 a_4085_10381# GND 0.27119f $ **FLOATING
C232 a_n15915_10621# GND 9.43691f
C233 a_n15915_10861# GND 9.41967f
C234 a_n15985_10621# GND 0.20359f $ **FLOATING
C235 a_4085_10861# GND 0.27041f $ **FLOATING
C236 a_n15915_11101# GND 9.39971f
C237 a_n15915_11341# GND 9.39971f
C238 a_n15985_11101# GND 0.1992f $ **FLOATING
C239 a_4085_11341# GND 0.26085f $ **FLOATING
C240 a_n15915_11581# GND 9.39971f
C241 a_n15915_11821# GND 9.39971f
C242 a_n15985_11581# GND 0.19789f $ **FLOATING
C243 a_4085_11821# GND 0.25989f $ **FLOATING
C244 a_n15915_12061# GND 9.39971f
C245 a_n15915_12301# GND 10.5503f
C246 a_n15985_12061# GND 0.20161f $ **FLOATING
C247 a_n15925_12800# GND 10.5504f
C248 a_n15925_13040# GND 9.39978f
C249 a_n15995_12800# GND 0.20516f $ **FLOATING
C250 a_4075_13040# GND 0.27019f $ **FLOATING
C251 a_n15925_13280# GND 9.39978f
C252 a_n15925_13520# GND 9.39691f
C253 a_n15995_13280# GND 0.20009f $ **FLOATING
C254 a_4075_13520# GND 0.27399f $ **FLOATING
C255 a_n15925_13760# GND 9.39456f
C256 a_n15925_14000# GND 9.39456f
C257 a_n15995_13760# GND 0.19663f $ **FLOATING
C258 a_4075_14000# GND 0.26978f $ **FLOATING
C259 a_n15925_14240# GND 9.39456f
C260 a_n15925_14480# GND 9.39456f
C261 a_n15995_14240# GND 0.19685f $ **FLOATING
C262 a_4075_14480# GND 0.27109f $ **FLOATING
C263 a_n15925_14720# GND 9.39456f
C264 a_n15925_14960# GND 9.39456f
C265 a_n15995_14720# GND 0.19621f $ **FLOATING
C266 a_4075_14960# GND 0.26851f $ **FLOATING
C267 a_n15925_15200# GND 9.39456f
C268 a_n15925_15440# GND 9.39456f
C269 a_n15995_15200# GND 0.22352f $ **FLOATING
C270 a_4075_15440# GND 0.26835f $ **FLOATING
C271 a_n15925_15680# GND 9.39456f
C272 a_n15925_15920# GND 9.39456f
C273 a_n15995_15680# GND 0.27028f $ **FLOATING
C274 a_4075_15920# GND 0.27057f $ **FLOATING
C275 a_n15925_16160# GND 9.39456f
C276 a_n15925_16400# GND 9.39456f
C277 a_n15995_16160# GND 0.26621f $ **FLOATING
C278 a_4075_16400# GND 0.26841f $ **FLOATING
C279 a_n15925_16640# GND 9.39456f
C280 a_n15925_16880# GND 9.39456f
C281 a_n15995_16640# GND 0.24607f $ **FLOATING
C282 a_4075_16880# GND 0.26889f $ **FLOATING
C283 a_n15925_17120# GND 9.39456f
C284 a_n15925_17360# GND 9.39456f
C285 a_n15995_17120# GND 0.23606f $ **FLOATING
C286 a_4075_17360# GND 0.26242f $ **FLOATING
C287 a_n15925_17600# GND 9.39456f
C288 a_n15925_17840# GND 9.39456f
C289 a_n15995_17600# GND 0.2412f $ **FLOATING
C290 a_4075_17840# GND 0.26247f $ **FLOATING
C291 a_n15925_18080# GND 9.39456f
C292 a_n15925_18320# GND 9.39456f
C293 a_n15995_18080# GND 0.23303f $ **FLOATING
C294 a_4075_18320# GND 0.29189f $ **FLOATING
C295 a_n15925_18560# GND 11.3368f
.ends
