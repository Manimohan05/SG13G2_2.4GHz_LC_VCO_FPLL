** sch_path: /foss/designs/frac-n-pll-vco-unic_cass/schematic/charge-pump/cp_current.sch
**.subckt cp_current
VBGR1 VBGR GND 0.6
XM5 net1 Vgs GND GND sg13_lv_nmos w=384u l=1u ng=48
XM6 Vgs Vgs GND GND sg13_lv_nmos w=64u l=1u ng=8
XM7 Vgs VBGR VDD VDD sg13_lv_pmos w=38u l=1u ng=5
Vtail ibias net1 0
.save i(Vtail)
V1 VDD GND 1.2
**** begin user architecture code

.param temp = 27
.options method=gear rshunt=1e12

.control
* Run operating point analysis
op

* Print current through ibias (Vtail source)
print i(Vtail)
tran 1n 1u
plot i(Vtail)
.endc

.lib cornerMOSlv.lib mos_tt
.lib cornerMOShv.lib mos_tt
.lib cornerRES.lib res_typ
.lib cornerCAP.lib cap_typ

**** end user architecture code
**.ends cp_current
.GLOBAL GND
.GLOBAL VDD
.end
