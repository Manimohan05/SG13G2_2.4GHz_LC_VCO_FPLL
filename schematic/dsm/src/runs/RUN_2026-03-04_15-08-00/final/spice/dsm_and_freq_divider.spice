* NGSPICE file created from dsm_and_freq_divider.ext - technology: ihp-sg13g2

* Black-box entry subcircuit for sg13g2_decap_8 abstract view
.subckt sg13g2_decap_8 VDD VSS
.ends

* Black-box entry subcircuit for sg13g2_fill_1 abstract view
.subckt sg13g2_fill_1 VDD VSS
.ends

* Black-box entry subcircuit for sg13g2_nand3_1 abstract view
.subckt sg13g2_nand3_1 Y A B C VDD VSS
.ends

* Black-box entry subcircuit for sg13g2_a21oi_1 abstract view
.subckt sg13g2_a21oi_1 Y A1 A2 B1 VDD VSS
.ends

* Black-box entry subcircuit for sg13g2_buf_1 abstract view
.subckt sg13g2_buf_1 X A VDD VSS
.ends

* Black-box entry subcircuit for sg13g2_dfrbpq_1 abstract view
.subckt sg13g2_dfrbpq_1 Q CLK D RESET_B VDD VSS
.ends

* Black-box entry subcircuit for sg13g2_fill_2 abstract view
.subckt sg13g2_fill_2 VDD VSS
.ends

* Black-box entry subcircuit for sg13g2_xor2_1 abstract view
.subckt sg13g2_xor2_1 X A B VDD VSS
.ends

* Black-box entry subcircuit for sg13g2_nand2_1 abstract view
.subckt sg13g2_nand2_1 Y A B VDD VSS
.ends

* Black-box entry subcircuit for sg13g2_decap_4 abstract view
.subckt sg13g2_decap_4 VDD VSS
.ends

* Black-box entry subcircuit for sg13g2_inv_1 abstract view
.subckt sg13g2_inv_1 Y A VDD VSS
.ends

* Black-box entry subcircuit for sg13g2_o21ai_1 abstract view
.subckt sg13g2_o21ai_1 Y A1 A2 B1 VDD VSS
.ends

* Black-box entry subcircuit for sg13g2_buf_16 abstract view
.subckt sg13g2_buf_16 X A VDD VSS
.ends

* Black-box entry subcircuit for sg13g2_xnor2_1 abstract view
.subckt sg13g2_xnor2_1 Y A B VDD VSS
.ends

* Black-box entry subcircuit for sg13g2_a21oi_2 abstract view
.subckt sg13g2_a21oi_2 Y A1 A2 B1 VDD VSS
.ends

* Black-box entry subcircuit for sg13g2_a21o_1 abstract view
.subckt sg13g2_a21o_1 X A1 A2 B1 VDD VSS
.ends

* Black-box entry subcircuit for sg13g2_a21o_2 abstract view
.subckt sg13g2_a21o_2 X A1 A2 B1 VDD VSS
.ends

* Black-box entry subcircuit for sg13g2_and2_1 abstract view
.subckt sg13g2_and2_1 X A B VDD VSS
.ends

* Black-box entry subcircuit for sg13g2_nor2_1 abstract view
.subckt sg13g2_nor2_1 Y A B VDD VSS
.ends

* Black-box entry subcircuit for sg13g2_mux2_1 abstract view
.subckt sg13g2_mux2_1 X A0 A1 S VDD VSS
.ends

* Black-box entry subcircuit for sg13g2_and3_1 abstract view
.subckt sg13g2_and3_1 X A B C VDD VSS
.ends

* Black-box entry subcircuit for sg13g2_nor2b_1 abstract view
.subckt sg13g2_nor2b_1 Y A B_N VDD VSS
.ends

* Black-box entry subcircuit for sg13g2_nand2b_1 abstract view
.subckt sg13g2_nand2b_1 Y A_N B VDD VSS
.ends

* Black-box entry subcircuit for sg13g2_a221oi_1 abstract view
.subckt sg13g2_a221oi_1 Y A1 A2 B1 B2 C1 VDD VSS
.ends

* Black-box entry subcircuit for sg13g2_nor3_1 abstract view
.subckt sg13g2_nor3_1 Y A B C VDD VSS
.ends

.subckt dsm_and_freq_divider VGND VPWR en freq_in freq_out rst sclk sdata
XFILLER_13_111 VPWR VGND sg13g2_decap_8
XFILLER_9_159 VPWR VGND sg13g2_decap_8
XFILLER_3_67 VPWR VGND sg13g2_fill_1
XFILLER_10_147 VPWR VGND sg13g2_decap_8
X_200_ _200_/Y _200_/A _200_/B _200_/C VPWR VGND sg13g2_nand3_1
X_131_ _263_/D _263_/Q _262_/Q _130_/Y VPWR VGND sg13g2_a21oi_1
XFILLER_0_35 VPWR VGND sg13g2_decap_8
XFILLER_9_33 VPWR VGND sg13g2_decap_8
XFILLER_18_64 VPWR VGND sg13g2_fill_1
Xfanout7 _213_/A _260_/Q VPWR VGND sg13g2_buf_1
XFILLER_20_21 VPWR VGND sg13g2_decap_8
XFILLER_6_89 VPWR VGND sg13g2_decap_8
XFILLER_15_21 VPWR VGND sg13g2_decap_8
XFILLER_15_76 VPWR VGND sg13g2_decap_8
XFILLER_13_156 VPWR VGND sg13g2_decap_8
XFILLER_3_57 VPWR VGND sg13g2_fill_1
XFILLER_3_46 VPWR VGND sg13g2_decap_8
X_130_ _130_/Y _262_/Q _261_/Q _263_/Q VPWR VGND sg13g2_a21oi_1
XFILLER_0_14 VPWR VGND sg13g2_decap_8
X_259_ _259_/Q _260_/Q _259_/D _232_/Y VPWR VGND sg13g2_dfrbpq_1
XFILLER_9_67 VPWR VGND sg13g2_fill_2
XFILLER_2_144 VPWR VGND sg13g2_decap_8
XFILLER_18_54 VPWR VGND sg13g2_fill_2
XFILLER_15_7 VPWR VGND sg13g2_decap_8
Xfanout8 _224_/A input2/X VPWR VGND sg13g2_buf_1
XFILLER_20_77 VPWR VGND sg13g2_decap_8
XFILLER_6_68 VPWR VGND sg13g2_fill_1
XFILLER_19_151 VPWR VGND sg13g2_decap_8
XFILLER_16_165 VPWR VGND sg13g2_fill_2
XFILLER_9_128 VPWR VGND sg13g2_decap_8
XFILLER_10_116 VPWR VGND sg13g2_decap_8
XFILLER_10_138 VPWR VGND sg13g2_fill_1
XFILLER_5_164 VPWR VGND sg13g2_fill_2
X_189_ _196_/B _248_/Q _195_/B VPWR VGND sg13g2_xor2_1
X_258_ _258_/Q _260_/Q _258_/D _231_/Y VPWR VGND sg13g2_dfrbpq_1
XFILLER_9_79 VPWR VGND sg13g2_decap_8
Xfanout9 _232_/A input2/X VPWR VGND sg13g2_buf_1
XFILLER_1_0 VPWR VGND sg13g2_decap_8
XFILLER_20_56 VPWR VGND sg13g2_decap_8
XFILLER_6_47 VPWR VGND sg13g2_decap_8
XFILLER_19_130 VPWR VGND sg13g2_decap_8
XFILLER_15_56 VPWR VGND sg13g2_decap_8
XFILLER_13_136 VPWR VGND sg13g2_fill_1
XFILLER_9_107 VPWR VGND sg13g2_decap_8
XFILLER_12_35 VPWR VGND sg13g2_fill_2
XFILLER_5_7 VPWR VGND sg13g2_decap_8
XFILLER_5_143 VPWR VGND sg13g2_decap_8
XFILLER_0_49 VPWR VGND sg13g2_decap_8
X_188_ _192_/B _256_/Q _188_/B VPWR VGND sg13g2_nand2_1
X_257_ _257_/Q _260_/Q _257_/D _230_/Y VPWR VGND sg13g2_dfrbpq_1
XFILLER_9_69 VPWR VGND sg13g2_fill_1
XFILLER_9_47 VPWR VGND sg13g2_decap_4
XFILLER_6_26 VPWR VGND sg13g2_decap_8
XFILLER_20_35 VPWR VGND sg13g2_decap_8
XFILLER_20_7 VPWR VGND sg13g2_decap_8
XFILLER_15_35 VPWR VGND sg13g2_decap_8
XFILLER_13_104 VPWR VGND sg13g2_decap_8
XFILLER_7_91 VPWR VGND sg13g2_fill_2
XFILLER_7_80 VPWR VGND sg13g2_decap_8
XFILLER_8_130 VPWR VGND sg13g2_decap_4
XFILLER_5_122 VPWR VGND sg13g2_fill_2
XFILLER_5_166 VPWR VGND sg13g2_fill_1
XFILLER_2_158 VPWR VGND sg13g2_decap_4
XFILLER_2_136 VPWR VGND sg13g2_decap_4
XFILLER_2_114 VPWR VGND sg13g2_fill_1
XFILLER_0_28 VPWR VGND sg13g2_decap_8
XFILLER_13_90 VPWR VGND sg13g2_decap_8
X_256_ _256_/Q _213_/A _256_/D _229_/Y VPWR VGND sg13g2_dfrbpq_1
X_187_ _192_/A _247_/Q _195_/B VPWR VGND sg13g2_nand2_1
XFILLER_9_26 VPWR VGND sg13g2_decap_8
Xclkload0 clkload0/Y _250_/CLK VPWR VGND sg13g2_inv_1
X_239_ _239_/Y _239_/A VPWR VGND sg13g2_inv_1
XFILLER_20_14 VPWR VGND sg13g2_decap_8
XFILLER_19_165 VPWR VGND sg13g2_fill_2
XFILLER_15_14 VPWR VGND sg13g2_decap_8
XFILLER_15_69 VPWR VGND sg13g2_decap_8
XFILLER_16_113 VPWR VGND sg13g2_decap_4
XFILLER_11_4 VPWR VGND sg13g2_decap_4
XFILLER_13_149 VPWR VGND sg13g2_decap_8
XFILLER_4_93 VPWR VGND sg13g2_decap_8
X_255_ _255_/Q _213_/A _255_/D _228_/Y VPWR VGND sg13g2_dfrbpq_1
X_186_ _194_/A _172_/A _183_/Y _185_/Y VPWR VGND sg13g2_o21ai_1
X_238_ _238_/Y _239_/A VPWR VGND sg13g2_inv_1
X_169_ _171_/A _170_/A _170_/B _170_/C VPWR VGND sg13g2_a21oi_1
XFILLER_1_94 VPWR VGND sg13g2_decap_4
XFILLER_10_81 VPWR VGND sg13g2_decap_8
XFILLER_19_144 VPWR VGND sg13g2_decap_8
Xclkbuf_1_0__f_sclk _246_/CLK clkbuf_0_sclk/X VPWR VGND sg13g2_buf_16
XFILLER_10_109 VPWR VGND sg13g2_decap_8
XFILLER_12_49 VPWR VGND sg13g2_decap_4
XFILLER_5_157 VPWR VGND sg13g2_decap_8
XFILLER_5_102 VPWR VGND sg13g2_decap_8
XFILLER_4_72 VPWR VGND sg13g2_decap_8
X_254_ _254_/Q _213_/A _254_/D _227_/Y VPWR VGND sg13g2_dfrbpq_1
X_185_ _185_/Y _171_/A _184_/Y _179_/B VPWR VGND sg13g2_a21oi_1
XFILLER_3_7 VPWR VGND sg13g2_fill_2
XFILLER_2_127 VPWR VGND sg13g2_fill_1
XFILLER_1_160 VPWR VGND sg13g2_decap_8
X_237_ _237_/Y _241_/A VPWR VGND sg13g2_inv_1
X_168_ _170_/C _255_/Q _174_/B VPWR VGND sg13g2_xnor2_1
XFILLER_20_49 VPWR VGND sg13g2_decap_8
XFILLER_19_123 VPWR VGND sg13g2_decap_8
XFILLER_15_49 VPWR VGND sg13g2_decap_8
XFILLER_13_118 VPWR VGND sg13g2_decap_4
XFILLER_16_92 VPWR VGND sg13g2_decap_8
XFILLER_8_166 VPWR VGND sg13g2_fill_1
XFILLER_5_136 VPWR VGND sg13g2_decap_8
XFILLER_4_51 VPWR VGND sg13g2_decap_8
X_253_ _253_/Q _213_/A _253_/D _226_/Y VPWR VGND sg13g2_dfrbpq_1
X_184_ _184_/Y _184_/A _184_/B _184_/C VPWR VGND sg13g2_nand3_1
X_236_ _236_/Y _241_/A VPWR VGND sg13g2_inv_1
X_167_ _174_/B _246_/Q _173_/B VPWR VGND sg13g2_xor2_1
XFILLER_20_28 VPWR VGND sg13g2_decap_8
XFILLER_1_74 VPWR VGND sg13g2_fill_1
XFILLER_6_19 VPWR VGND sg13g2_decap_8
X_219_ _219_/Y _224_/A VPWR VGND sg13g2_inv_1
XFILLER_15_28 VPWR VGND sg13g2_decap_8
XFILLER_16_127 VPWR VGND sg13g2_decap_4
XFILLER_15_160 VPWR VGND sg13g2_decap_8
XFILLER_16_71 VPWR VGND sg13g2_decap_8
XFILLER_8_134 VPWR VGND sg13g2_fill_2
XFILLER_8_123 VPWR VGND sg13g2_decap_8
XFILLER_4_30 VPWR VGND sg13g2_decap_8
XFILLER_13_83 VPWR VGND sg13g2_decap_8
X_252_ _252_/Q _213_/A _252_/D _225_/Y VPWR VGND sg13g2_dfrbpq_1
X_183_ _183_/Y _183_/A _183_/B VPWR VGND sg13g2_nand2_1
XFILLER_9_19 VPWR VGND sg13g2_decap_8
X_235_ _235_/Y _241_/A VPWR VGND sg13g2_inv_1
X_166_ _170_/B _254_/Q _166_/B VPWR VGND sg13g2_nand2_1
XFILLER_10_95 VPWR VGND sg13g2_decap_8
X_218_ _218_/Y _224_/A VPWR VGND sg13g2_inv_1
X_149_ _157_/B _253_/Q _149_/B VPWR VGND sg13g2_xnor2_1
XFILLER_19_158 VPWR VGND sg13g2_decap_8
XFILLER_11_8 VPWR VGND sg13g2_fill_1
XFILLER_16_106 VPWR VGND sg13g2_decap_8
XFILLER_16_117 VPWR VGND sg13g2_fill_2
XFILLER_7_96 VPWR VGND sg13g2_decap_4
XFILLER_7_52 VPWR VGND sg13g2_fill_2
XFILLER_5_116 VPWR VGND sg13g2_fill_2
XFILLER_4_86 VPWR VGND sg13g2_decap_8
XFILLER_13_62 VPWR VGND sg13g2_decap_8
X_251_ _251_/Q _213_/A _251_/D _224_/Y VPWR VGND sg13g2_dfrbpq_1
X_182_ _256_/D _183_/B _182_/B VPWR VGND sg13g2_xnor2_1
XFILLER_8_0 VPWR VGND sg13g2_decap_8
XFILLER_1_7 VPWR VGND sg13g2_decap_4
X_234_ _234_/Y _241_/A VPWR VGND sg13g2_inv_1
X_165_ _170_/A _245_/Q _173_/B VPWR VGND sg13g2_nand2_1
XFILLER_1_87 VPWR VGND sg13g2_decap_8
XFILLER_10_52 VPWR VGND sg13g2_decap_8
X_217_ _217_/Y _224_/A VPWR VGND sg13g2_inv_1
X_148_ _149_/B _244_/Q _195_/B VPWR VGND sg13g2_xor2_1
XFILLER_19_83 VPWR VGND sg13g2_fill_2
XFILLER_19_137 VPWR VGND sg13g2_decap_8
XFILLER_12_165 VPWR VGND sg13g2_fill_2
XFILLER_4_65 VPWR VGND sg13g2_decap_8
X_250_ _250_/Q _250_/CLK _250_/D _223_/Y VPWR VGND sg13g2_dfrbpq_1
X_181_ _182_/B _180_/X _183_/A _171_/A VPWR VGND sg13g2_a21oi_1
XFILLER_1_153 VPWR VGND sg13g2_decap_8
X_233_ _233_/Y _239_/A VPWR VGND sg13g2_inv_1
X_164_ _172_/A _151_/A _160_/X _163_/X VPWR VGND sg13g2_a21oi_2
XFILLER_1_66 VPWR VGND sg13g2_decap_4
XFILLER_1_11 VPWR VGND sg13g2_fill_1
XFILLER_19_62 VPWR VGND sg13g2_decap_8
XFILLER_19_116 VPWR VGND sg13g2_decap_8
X_216_ _216_/Y _224_/A VPWR VGND sg13g2_inv_1
X_147_ _157_/A _252_/Q _140_/B _146_/X VPWR VGND sg13g2_a21oi_1
XFILLER_7_87 VPWR VGND sg13g2_decap_4
XFILLER_16_0 VPWR VGND sg13g2_decap_8
XFILLER_16_85 VPWR VGND sg13g2_decap_8
XFILLER_5_129 VPWR VGND sg13g2_decap_8
XFILLER_4_44 VPWR VGND sg13g2_decap_8
XFILLER_4_162 VPWR VGND sg13g2_decap_4
XFILLER_13_97 VPWR VGND sg13g2_decap_8
Xfanout10 _241_/A _239_/A VPWR VGND sg13g2_buf_1
X_180_ _180_/X _151_/A _160_/X _163_/X VPWR VGND sg13g2_a21o_1
XFILLER_1_132 VPWR VGND sg13g2_decap_8
X_232_ _232_/Y _232_/A VPWR VGND sg13g2_inv_1
X_163_ _163_/X _157_/Y _161_/Y _162_/Y VPWR VGND sg13g2_a21o_2
XFILLER_10_21 VPWR VGND sg13g2_decap_4
XFILLER_19_41 VPWR VGND sg13g2_decap_8
X_215_ _215_/Y _224_/A VPWR VGND sg13g2_inv_1
X_146_ _146_/X _243_/Q _173_/B VPWR VGND sg13g2_and2_1
XFILLER_15_153 VPWR VGND sg13g2_decap_8
X_129_ _262_/D _262_/Q _261_/Q _128_/Y VPWR VGND sg13g2_a21oi_1
XFILLER_8_116 VPWR VGND sg13g2_decap_8
XFILLER_4_23 VPWR VGND sg13g2_decap_8
XFILLER_4_141 VPWR VGND sg13g2_decap_8
Xfanout11 _239_/A input2/X VPWR VGND sg13g2_buf_1
XFILLER_13_76 VPWR VGND sg13g2_decap_8
XFILLER_1_111 VPWR VGND sg13g2_decap_8
X_231_ _231_/Y _232_/A VPWR VGND sg13g2_inv_1
X_162_ _162_/Y _162_/A _162_/B VPWR VGND sg13g2_nor2_1
XFILLER_1_46 VPWR VGND sg13g2_decap_4
XFILLER_10_66 VPWR VGND sg13g2_decap_8
XFILLER_10_88 VPWR VGND sg13g2_decap_8
Xinput1 _125_/S en VPWR VGND sg13g2_buf_1
X_214_ _267_/D _267_/Q VPWR VGND sg13g2_inv_1
X_145_ _151_/A _143_/Y _142_/B _144_/Y VPWR VGND sg13g2_a21o_2
XFILLER_18_162 VPWR VGND sg13g2_decap_4
XFILLER_15_132 VPWR VGND sg13g2_decap_8
X_128_ _128_/Y _262_/Q _261_/Q _127_/Y VPWR VGND sg13g2_o21ai_1
XFILLER_7_45 VPWR VGND sg13g2_decap_8
XFILLER_5_109 VPWR VGND sg13g2_decap_8
XFILLER_4_79 VPWR VGND sg13g2_decap_8
X_230_ _230_/Y _241_/A VPWR VGND sg13g2_inv_1
X_161_ _161_/Y _162_/A _162_/B VPWR VGND sg13g2_nand2_1
Xinput2 input2/X rst VPWR VGND sg13g2_buf_1
X_213_ _260_/D _213_/A VPWR VGND sg13g2_inv_1
X_144_ _144_/Y _144_/A _144_/B VPWR VGND sg13g2_nor2_1
XFILLER_19_76 VPWR VGND sg13g2_decap_8
XFILLER_18_130 VPWR VGND sg13g2_decap_4
XFILLER_15_111 VPWR VGND sg13g2_decap_8
X_127_ _127_/Y _263_/Q _262_/Q VPWR VGND sg13g2_nand2_1
XFILLER_16_33 VPWR VGND sg13g2_decap_4
XFILLER_16_99 VPWR VGND sg13g2_decap_8
XFILLER_14_0 VPWR VGND sg13g2_decap_8
XFILLER_4_58 VPWR VGND sg13g2_decap_8
XFILLER_4_121 VPWR VGND sg13g2_fill_1
XFILLER_13_34 VPWR VGND sg13g2_fill_2
XFILLER_13_45 VPWR VGND sg13g2_decap_4
XFILLER_1_146 VPWR VGND sg13g2_decap_8
X_160_ _160_/X _160_/A _160_/B VPWR VGND sg13g2_and2_1
Xinput3 input3/X sdata VPWR VGND sg13g2_buf_1
X_212_ _268_/D _268_/Q VPWR VGND sg13g2_inv_1
X_143_ _143_/Y _143_/A VPWR VGND sg13g2_inv_1
XFILLER_19_55 VPWR VGND sg13g2_decap_8
X_126_ _261_/D _263_/Q _262_/Q _261_/Q VPWR VGND sg13g2_a21oi_1
XFILLER_16_78 VPWR VGND sg13g2_decap_8
XFILLER_4_37 VPWR VGND sg13g2_decap_8
XFILLER_4_166 VPWR VGND sg13g2_fill_1
XFILLER_4_155 VPWR VGND sg13g2_decap_8
XFILLER_4_100 VPWR VGND sg13g2_decap_8
XFILLER_1_125 VPWR VGND sg13g2_decap_8
XFILLER_10_14 VPWR VGND sg13g2_decap_8
XFILLER_10_25 VPWR VGND sg13g2_fill_2
X_211_ _265_/D _264_/Q VPWR VGND sg13g2_inv_1
X_142_ _252_/D _143_/A _142_/B VPWR VGND sg13g2_xnor2_1
XFILLER_4_0 VPWR VGND sg13g2_decap_8
XFILLER_15_146 VPWR VGND sg13g2_decap_8
X_125_ _242_/D _242_/Q input3/X _125_/S VPWR VGND sg13g2_mux2_1
XFILLER_7_37 VPWR VGND sg13g2_decap_4
XFILLER_20_160 VPWR VGND sg13g2_decap_8
XFILLER_7_131 VPWR VGND sg13g2_decap_4
XFILLER_4_134 VPWR VGND sg13g2_decap_8
XFILLER_13_36 VPWR VGND sg13g2_fill_1
XFILLER_13_69 VPWR VGND sg13g2_decap_8
XFILLER_5_81 VPWR VGND sg13g2_decap_8
XFILLER_6_4 VPWR VGND sg13g2_decap_4
XFILLER_1_39 VPWR VGND sg13g2_decap_8
XFILLER_10_59 VPWR VGND sg13g2_decap_8
X_210_ _251_/D _242_/Q _210_/B VPWR VGND sg13g2_xnor2_1
X_141_ _142_/B _144_/A _144_/B VPWR VGND sg13g2_xor2_1
XFILLER_18_166 VPWR VGND sg13g2_fill_1
XFILLER_15_125 VPWR VGND sg13g2_decap_8
X_124_ _243_/D _243_/Q _242_/Q _125_/S VPWR VGND sg13g2_mux2_1
XFILLER_12_0 VPWR VGND sg13g2_decap_4
XFILLER_5_60 VPWR VGND sg13g2_decap_8
XFILLER_19_69 VPWR VGND sg13g2_decap_8
X_140_ _144_/B _252_/Q _140_/B VPWR VGND sg13g2_xnor2_1
XFILLER_18_134 VPWR VGND sg13g2_fill_1
XFILLER_18_101 VPWR VGND sg13g2_fill_2
XFILLER_15_104 VPWR VGND sg13g2_decap_8
XFILLER_11_81 VPWR VGND sg13g2_decap_8
XFILLER_16_7 VPWR VGND sg13g2_fill_2
X_123_ _244_/D _244_/Q _243_/Q _125_/S VPWR VGND sg13g2_mux2_1
XFILLER_12_107 VPWR VGND sg13g2_fill_1
XFILLER_16_26 VPWR VGND sg13g2_decap_8
XFILLER_16_37 VPWR VGND sg13g2_fill_2
XFILLER_7_166 VPWR VGND sg13g2_fill_1
XFILLER_7_100 VPWR VGND sg13g2_fill_1
XFILLER_4_114 VPWR VGND sg13g2_decap_8
XFILLER_1_139 VPWR VGND sg13g2_decap_8
XFILLER_19_48 VPWR VGND sg13g2_decap_8
XFILLER_19_26 VPWR VGND sg13g2_decap_8
X_199_ _201_/A _200_/A _200_/B _200_/C VPWR VGND sg13g2_a21oi_1
X_268_ _268_/Q _267_/Q _268_/D _241_/Y VPWR VGND sg13g2_dfrbpq_1
XFILLER_11_60 VPWR VGND sg13g2_decap_8
X_122_ _245_/D _245_/Q _244_/Q _125_/S VPWR VGND sg13g2_mux2_1
XFILLER_2_0 VPWR VGND sg13g2_fill_2
XFILLER_7_123 VPWR VGND sg13g2_fill_2
XFILLER_8_72 VPWR VGND sg13g2_decap_4
XFILLER_4_148 VPWR VGND sg13g2_decap_8
XFILLER_1_118 VPWR VGND sg13g2_decap_8
XFILLER_0_162 VPWR VGND sg13g2_decap_4
XFILLER_5_95 VPWR VGND sg13g2_decap_8
X_198_ _200_/C _258_/Q _198_/B VPWR VGND sg13g2_xnor2_1
X_267_ _267_/Q freq_in _267_/D _240_/Y VPWR VGND sg13g2_dfrbpq_1
XFILLER_15_139 VPWR VGND sg13g2_decap_8
X_121_ _246_/D _246_/Q _245_/Q _125_/S VPWR VGND sg13g2_mux2_1
XFILLER_20_153 VPWR VGND sg13g2_decap_8
XFILLER_11_120 VPWR VGND sg13g2_fill_1
XFILLER_7_135 VPWR VGND sg13g2_fill_1
XFILLER_4_127 VPWR VGND sg13g2_decap_8
XFILLER_0_141 VPWR VGND sg13g2_decap_8
XFILLER_10_0 VPWR VGND sg13g2_decap_8
XFILLER_5_74 VPWR VGND sg13g2_decap_8
XFILLER_6_8 VPWR VGND sg13g2_fill_1
X_197_ _198_/B _249_/Q _259_/Q VPWR VGND sg13g2_xnor2_1
X_266_ _266_/Q _268_/Q _266_/D _239_/Y VPWR VGND sg13g2_dfrbpq_1
XFILLER_11_40 VPWR VGND sg13g2_decap_8
XFILLER_11_51 VPWR VGND sg13g2_fill_1
XFILLER_11_95 VPWR VGND sg13g2_decap_8
XFILLER_15_118 VPWR VGND sg13g2_decap_8
X_120_ _247_/D _247_/Q _246_/Q _125_/S VPWR VGND sg13g2_mux2_1
XFILLER_2_2 VPWR VGND sg13g2_fill_1
XFILLER_14_162 VPWR VGND sg13g2_decap_4
X_249_ _249_/Q _250_/CLK _249_/D _222_/Y VPWR VGND sg13g2_dfrbpq_1
XFILLER_20_132 VPWR VGND sg13g2_decap_8
XFILLER_14_7 VPWR VGND sg13g2_fill_2
XFILLER_7_125 VPWR VGND sg13g2_fill_1
XFILLER_17_94 VPWR VGND sg13g2_decap_8
XFILLER_12_4 VPWR VGND sg13g2_fill_1
XFILLER_0_120 VPWR VGND sg13g2_decap_8
XFILLER_5_53 VPWR VGND sg13g2_decap_8
X_196_ _200_/B _257_/Q _196_/B VPWR VGND sg13g2_nand2_1
X_265_ _266_/D _268_/Q _265_/D _238_/Y VPWR VGND sg13g2_dfrbpq_1
XFILLER_11_74 VPWR VGND sg13g2_decap_8
XFILLER_14_141 VPWR VGND sg13g2_decap_8
X_248_ _248_/Q _250_/CLK _248_/D _221_/Y VPWR VGND sg13g2_dfrbpq_1
X_179_ _183_/B _179_/A _179_/B VPWR VGND sg13g2_nor2_1
XFILLER_16_19 VPWR VGND sg13g2_decap_8
XFILLER_20_111 VPWR VGND sg13g2_decap_8
XFILLER_0_0 VPWR VGND sg13g2_decap_8
XFILLER_11_166 VPWR VGND sg13g2_fill_1
XFILLER_8_64 VPWR VGND sg13g2_fill_2
XFILLER_4_107 VPWR VGND sg13g2_decap_8
XFILLER_5_21 VPWR VGND sg13g2_decap_8
XFILLER_19_19 VPWR VGND sg13g2_decap_8
XFILLER_4_7 VPWR VGND sg13g2_fill_2
X_195_ _200_/A _248_/Q _195_/B VPWR VGND sg13g2_nand2_1
X_264_ _264_/Q _268_/Q _264_/D _237_/Y VPWR VGND sg13g2_dfrbpq_1
X_247_ _247_/Q _250_/CLK _247_/D _220_/Y VPWR VGND sg13g2_dfrbpq_1
X_178_ _179_/B _184_/A _184_/B _184_/C VPWR VGND sg13g2_a21oi_1
XFILLER_7_116 VPWR VGND sg13g2_fill_2
XFILLER_17_52 VPWR VGND sg13g2_decap_8
XFILLER_0_155 VPWR VGND sg13g2_decap_8
XFILLER_0_166 VPWR VGND sg13g2_fill_1
XFILLER_5_88 VPWR VGND sg13g2_decap_8
X_194_ _257_/D _194_/A _204_/A VPWR VGND sg13g2_xor2_1
X_263_ _263_/Q _266_/Q _263_/D _236_/Y VPWR VGND sg13g2_dfrbpq_1
XFILLER_17_151 VPWR VGND sg13g2_decap_8
XFILLER_14_121 VPWR VGND sg13g2_fill_2
X_246_ _246_/Q _246_/CLK _246_/D _219_/Y VPWR VGND sg13g2_dfrbpq_1
X_177_ _179_/A _184_/A _184_/B _184_/C VPWR VGND sg13g2_and3_1
XFILLER_20_146 VPWR VGND sg13g2_decap_8
XFILLER_11_102 VPWR VGND sg13g2_decap_8
X_229_ _229_/Y _241_/A VPWR VGND sg13g2_inv_1
XFILLER_8_66 VPWR VGND sg13g2_fill_1
XFILLER_3_120 VPWR VGND sg13g2_fill_2
XFILLER_0_134 VPWR VGND sg13g2_decap_8
XFILLER_5_67 VPWR VGND sg13g2_decap_8
XFILLER_14_54 VPWR VGND sg13g2_decap_4
XFILLER_14_65 VPWR VGND sg13g2_decap_4
X_193_ _204_/A _193_/A _192_/Y VPWR VGND sg13g2_nor2b_1
X_262_ _262_/Q _266_/Q _262_/D _235_/Y VPWR VGND sg13g2_dfrbpq_1
XFILLER_4_9 VPWR VGND sg13g2_fill_1
XFILLER_2_46 VPWR VGND sg13g2_fill_2
XFILLER_11_33 VPWR VGND sg13g2_decap_8
XFILLER_11_88 VPWR VGND sg13g2_decap_8
XFILLER_14_155 VPWR VGND sg13g2_decap_8
XFILLER_14_166 VPWR VGND sg13g2_fill_1
X_245_ _245_/Q _246_/CLK _245_/D _218_/Y VPWR VGND sg13g2_dfrbpq_1
X_176_ _184_/C _256_/Q _188_/B VPWR VGND sg13g2_xnor2_1
XFILLER_20_125 VPWR VGND sg13g2_decap_8
XFILLER_7_118 VPWR VGND sg13g2_fill_1
X_228_ _228_/Y _239_/A VPWR VGND sg13g2_inv_1
X_159_ _254_/D _160_/B _159_/B VPWR VGND sg13g2_xnor2_1
Xclkbuf_0_sclk clkbuf_0_sclk/X sclk VPWR VGND sg13g2_buf_16
XFILLER_3_165 VPWR VGND sg13g2_fill_2
XFILLER_0_113 VPWR VGND sg13g2_decap_8
X_192_ _192_/Y _192_/A _192_/B _192_/C VPWR VGND sg13g2_nand3_1
X_261_ _261_/Q _266_/Q _261_/D _234_/Y VPWR VGND sg13g2_dfrbpq_1
XFILLER_9_0 VPWR VGND sg13g2_decap_8
XFILLER_11_67 VPWR VGND sg13g2_decap_8
XFILLER_14_134 VPWR VGND sg13g2_decap_8
X_244_ _244_/Q _246_/CLK _244_/D _217_/Y VPWR VGND sg13g2_dfrbpq_1
X_175_ _188_/B _247_/Q _195_/B VPWR VGND sg13g2_xor2_1
XFILLER_20_104 VPWR VGND sg13g2_decap_8
X_227_ _227_/Y _239_/A VPWR VGND sg13g2_inv_1
X_158_ _159_/B _151_/A _160_/A _157_/Y VPWR VGND sg13g2_a21oi_1
XFILLER_6_152 VPWR VGND sg13g2_fill_1
XFILLER_5_14 VPWR VGND sg13g2_decap_8
X_260_ _260_/Q _263_/Q _260_/D _233_/Y VPWR VGND sg13g2_dfrbpq_1
XFILLER_17_165 VPWR VGND sg13g2_fill_2
X_191_ _193_/A _192_/A _192_/B _192_/C VPWR VGND sg13g2_a21oi_1
XFILLER_2_48 VPWR VGND sg13g2_fill_1
X_243_ _243_/Q _246_/CLK _243_/D _216_/Y VPWR VGND sg13g2_dfrbpq_1
X_174_ _184_/B _255_/Q _174_/B VPWR VGND sg13g2_nand2_1
XFILLER_11_116 VPWR VGND sg13g2_decap_4
XFILLER_3_91 VPWR VGND sg13g2_decap_8
X_226_ _226_/Y _239_/A VPWR VGND sg13g2_inv_1
X_157_ _157_/Y _157_/A _157_/B VPWR VGND sg13g2_nor2_1
XFILLER_6_164 VPWR VGND sg13g2_fill_2
XFILLER_17_45 VPWR VGND sg13g2_decap_8
XFILLER_0_70 VPWR VGND sg13g2_decap_4
XFILLER_0_92 VPWR VGND sg13g2_decap_8
XFILLER_17_0 VPWR VGND sg13g2_decap_4
X_209_ _259_/D _209_/A _209_/B VPWR VGND sg13g2_xnor2_1
XFILLER_0_148 VPWR VGND sg13g2_decap_8
XFILLER_10_7 VPWR VGND sg13g2_decap_8
X_190_ _192_/C _257_/Q _196_/B VPWR VGND sg13g2_xnor2_1
XFILLER_11_47 VPWR VGND sg13g2_decap_4
XFILLER_14_114 VPWR VGND sg13g2_decap_8
X_242_ _242_/Q _246_/CLK _242_/D _215_/Y VPWR VGND sg13g2_dfrbpq_1
X_173_ _184_/A _246_/Q _173_/B VPWR VGND sg13g2_nand2_1
XFILLER_20_139 VPWR VGND sg13g2_decap_8
XFILLER_10_161 VPWR VGND sg13g2_decap_4
X_225_ _225_/Y _239_/A VPWR VGND sg13g2_inv_1
X_156_ _160_/B _162_/A _162_/B VPWR VGND sg13g2_xor2_1
XFILLER_8_48 VPWR VGND sg13g2_fill_2
XFILLER_8_37 VPWR VGND sg13g2_fill_2
XFILLER_19_4 VPWR VGND sg13g2_decap_4
X_208_ _209_/B _250_/Q _208_/B VPWR VGND sg13g2_xor2_1
X_139_ _140_/B _243_/Q _173_/B VPWR VGND sg13g2_xor2_1
XFILLER_0_127 VPWR VGND sg13g2_decap_8
XFILLER_14_47 VPWR VGND sg13g2_fill_2
XFILLER_14_58 VPWR VGND sg13g2_fill_2
XFILLER_17_112 VPWR VGND sg13g2_fill_2
XFILLER_15_90 VPWR VGND sg13g2_decap_8
XFILLER_11_26 VPWR VGND sg13g2_decap_8
XFILLER_14_148 VPWR VGND sg13g2_decap_8
X_241_ _241_/Y _241_/A VPWR VGND sg13g2_inv_1
X_172_ _255_/D _172_/A _183_/A VPWR VGND sg13g2_xnor2_1
XFILLER_9_152 VPWR VGND sg13g2_decap_8
XFILLER_7_0 VPWR VGND sg13g2_decap_8
XFILLER_20_118 VPWR VGND sg13g2_decap_8
XFILLER_0_7 VPWR VGND sg13g2_decap_8
X_224_ _224_/Y _224_/A VPWR VGND sg13g2_inv_1
X_155_ _162_/B _254_/Q _166_/B VPWR VGND sg13g2_xnor2_1
XFILLER_6_166 VPWR VGND sg13g2_fill_1
XFILLER_3_114 VPWR VGND sg13g2_fill_1
X_207_ _208_/B _258_/Q _198_/B _206_/Y VPWR VGND sg13g2_a21oi_1
X_138_ _144_/A _173_/B _251_/Q VPWR VGND sg13g2_nor2_1
XFILLER_0_106 VPWR VGND sg13g2_decap_8
XFILLER_20_91 VPWR VGND sg13g2_fill_2
XFILLER_14_127 VPWR VGND sg13g2_decap_8
X_240_ _240_/Y _241_/A VPWR VGND sg13g2_inv_1
X_171_ _183_/A _171_/A _170_/Y VPWR VGND sg13g2_nor2b_1
X_223_ _223_/Y _232_/A VPWR VGND sg13g2_inv_1
XFILLER_8_39 VPWR VGND sg13g2_fill_1
XFILLER_12_70 VPWR VGND sg13g2_decap_8
X_154_ _166_/B _245_/Q _173_/B VPWR VGND sg13g2_xor2_1
XFILLER_6_145 VPWR VGND sg13g2_decap_8
X_206_ _206_/Y _259_/Q _249_/Q VPWR VGND sg13g2_nor2b_1
X_137_ _143_/A _210_/B _242_/Q VPWR VGND sg13g2_nand2b_1
XFILLER_9_93 VPWR VGND sg13g2_decap_8
XFILLER_15_0 VPWR VGND sg13g2_decap_8
XFILLER_14_49 VPWR VGND sg13g2_fill_1
XFILLER_20_70 VPWR VGND sg13g2_decap_8
XFILLER_6_61 VPWR VGND sg13g2_decap_8
XFILLER_17_158 VPWR VGND sg13g2_decap_8
X_170_ _170_/Y _170_/A _170_/B _170_/C VPWR VGND sg13g2_nand3_1
XFILLER_9_121 VPWR VGND sg13g2_decap_8
XFILLER_3_84 VPWR VGND sg13g2_decap_8
XFILLER_11_109 VPWR VGND sg13g2_decap_8
X_222_ _222_/Y _232_/A VPWR VGND sg13g2_inv_1
X_153_ _162_/A _253_/Q _149_/B _152_/X VPWR VGND sg13g2_a21oi_1
XFILLER_6_157 VPWR VGND sg13g2_decap_8
XFILLER_6_113 VPWR VGND sg13g2_fill_1
X_205_ _209_/A _193_/A _200_/Y _204_/X _194_/A _201_/A VPWR VGND sg13g2_a221oi_1
X_136_ _210_/B _173_/B _251_/Q VPWR VGND sg13g2_xor2_1
XFILLER_0_63 VPWR VGND sg13g2_decap_8
XFILLER_0_74 VPWR VGND sg13g2_fill_1
XFILLER_0_85 VPWR VGND sg13g2_decap_8
X_119_ _248_/D _248_/Q _247_/Q _125_/S VPWR VGND sg13g2_mux2_1
XFILLER_6_84 VPWR VGND sg13g2_fill_1
XFILLER_6_40 VPWR VGND sg13g2_decap_8
XFILLER_17_104 VPWR VGND sg13g2_fill_1
XFILLER_14_107 VPWR VGND sg13g2_decap_8
XFILLER_9_166 VPWR VGND sg13g2_fill_1
XFILLER_9_100 VPWR VGND sg13g2_decap_8
XFILLER_3_63 VPWR VGND sg13g2_decap_4
XFILLER_10_154 VPWR VGND sg13g2_decap_8
XFILLER_10_165 VPWR VGND sg13g2_fill_2
X_221_ _221_/Y _224_/A VPWR VGND sg13g2_inv_1
X_152_ _152_/X _244_/Q _195_/B VPWR VGND sg13g2_and2_1
XFILLER_5_0 VPWR VGND sg13g2_decap_8
XFILLER_19_8 VPWR VGND sg13g2_fill_1
XFILLER_17_39 VPWR VGND sg13g2_fill_1
X_204_ _204_/X _204_/A _204_/B VPWR VGND sg13g2_and2_1
XFILLER_0_42 VPWR VGND sg13g2_decap_8
X_135_ _264_/D _266_/D _135_/B VPWR VGND sg13g2_and2_1
XFILLER_9_40 VPWR VGND sg13g2_decap_8
X_118_ _249_/D _249_/Q _248_/Q _125_/S VPWR VGND sg13g2_mux2_1
XFILLER_6_96 VPWR VGND sg13g2_fill_2
XFILLER_20_0 VPWR VGND sg13g2_decap_8
Xclkbuf_1_1__f_sclk _250_/CLK clkbuf_0_sclk/X VPWR VGND sg13g2_buf_16
XFILLER_9_7 VPWR VGND sg13g2_fill_2
XFILLER_15_83 VPWR VGND sg13g2_decap_8
XFILLER_11_19 VPWR VGND sg13g2_decap_8
XFILLER_13_163 VPWR VGND sg13g2_decap_4
XFILLER_9_145 VPWR VGND sg13g2_decap_8
XFILLER_3_53 VPWR VGND sg13g2_decap_4
X_220_ _220_/Y _224_/A VPWR VGND sg13g2_inv_1
X_151_ _253_/D _151_/A _160_/A VPWR VGND sg13g2_xor2_1
XFILLER_3_107 VPWR VGND sg13g2_decap_8
XFILLER_0_21 VPWR VGND sg13g2_decap_8
X_203_ _258_/D _204_/B _203_/B VPWR VGND sg13g2_xnor2_1
X_134_ _135_/B _195_/B _127_/Y _133_/Y VPWR VGND sg13g2_o21ai_1
XFILLER_2_162 VPWR VGND sg13g2_fill_1
XFILLER_2_151 VPWR VGND sg13g2_decap_8
XFILLER_2_140 VPWR VGND sg13g2_fill_1
X_117_ _250_/D _250_/Q _249_/Q _125_/S VPWR VGND sg13g2_mux2_1
XFILLER_18_50 VPWR VGND sg13g2_decap_4
XFILLER_20_84 VPWR VGND sg13g2_decap_8
XFILLER_17_117 VPWR VGND sg13g2_fill_1
Xoutput4 freq_out _213_/A VPWR VGND sg13g2_buf_1
XFILLER_16_161 VPWR VGND sg13g2_decap_4
XFILLER_13_142 VPWR VGND sg13g2_decap_8
XFILLER_9_135 VPWR VGND sg13g2_decap_8
XFILLER_3_98 VPWR VGND sg13g2_fill_1
XFILLER_10_123 VPWR VGND sg13g2_decap_8
XFILLER_10_134 VPWR VGND sg13g2_decap_4
XFILLER_12_63 VPWR VGND sg13g2_decap_8
X_150_ _160_/A _157_/A _157_/B VPWR VGND sg13g2_xor2_1
XFILLER_6_138 VPWR VGND sg13g2_decap_8
X_202_ _203_/B _194_/A _204_/A _193_/A VPWR VGND sg13g2_a21oi_1
X_133_ _133_/Y _261_/Q _266_/Q _133_/C VPWR VGND sg13g2_nor3_1
XFILLER_0_99 VPWR VGND sg13g2_decap_8
XFILLER_9_86 VPWR VGND sg13g2_decap_8
Xfanout5 _173_/B _195_/B VPWR VGND sg13g2_buf_1
XFILLER_6_54 VPWR VGND sg13g2_decap_8
XFILLER_20_63 VPWR VGND sg13g2_decap_8
XFILLER_15_63 VPWR VGND sg13g2_fill_1
XFILLER_9_114 VPWR VGND sg13g2_decap_8
XFILLER_10_102 VPWR VGND sg13g2_decap_8
XFILLER_6_106 VPWR VGND sg13g2_decap_8
XFILLER_12_53 VPWR VGND sg13g2_fill_1
XFILLER_5_150 VPWR VGND sg13g2_decap_8
X_201_ _204_/B _201_/A _200_/Y VPWR VGND sg13g2_nor2b_1
X_132_ _133_/C _263_/Q _262_/Q VPWR VGND sg13g2_nor2_1
XFILLER_3_0 VPWR VGND sg13g2_decap_8
XFILLER_0_56 VPWR VGND sg13g2_decap_8
XFILLER_0_78 VPWR VGND sg13g2_decap_8
Xfanout6 _195_/B _259_/Q VPWR VGND sg13g2_buf_1
XFILLER_20_97 VPWR VGND sg13g2_decap_8
XFILLER_20_42 VPWR VGND sg13g2_decap_8
XFILLER_6_77 VPWR VGND sg13g2_decap_8
XFILLER_6_33 VPWR VGND sg13g2_decap_8
XFILLER_15_42 VPWR VGND sg13g2_decap_8
XFILLER_15_97 VPWR VGND sg13g2_decap_8
XFILLER_17_108 VPWR VGND sg13g2_decap_4
.ends
