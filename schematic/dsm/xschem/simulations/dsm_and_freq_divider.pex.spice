* NGSPICE file created from dsm_and_freq_divider.ext - technology: ihp-sg13g2

.subckt dsm_and_freq_divider VGND VPWR en freq_in freq_out rst sclk sdata
X0 VGND VPWR VGND VGND sg13_lv_nmos ad=0.1428p pd=1.52u as=0.90596n ps=4.48705m w=0.42u l=1u
X1 VPWR a_13391_12287# a_13648_12430# VPWR sg13_lv_pmos ad=0.4659p pd=3.65u as=79.8f ps=0.8u w=0.42u l=0.13u
X2 VPWR _260_.CLK a_13804_10996# VPWR sg13_lv_pmos ad=0.4032p pd=2.96u as=0.1176p ps=1.33u w=1.12u l=0.13u
X3 VGND a_9808_16966# a_9457_16823# VGND sg13_lv_nmos ad=79.8f pd=0.8u as=0.1428p ps=1.52u w=0.42u l=0.13u
X4 VGND a_16079_8797# a_16746_8436# VGND sg13_lv_nmos ad=0.1406p pd=1.12u as=0.2516p ps=2.16u w=0.74u l=0.13u
X5 a_8709_16725# fanout7.A a_9169_16767# VGND sg13_lv_nmos ad=0.2516p pd=2.16u as=0.31732p ps=1.805u w=0.74u l=0.13u
X6 VPWR VGND VPWR VPWR sg13_lv_pmos ad=0.34p pd=2.68u as=1.19017n ps=5.16309m w=1u l=1u
X7 _124_.S a_1192_11460# VGND VGND sg13_lv_nmos ad=0.2886p pd=2.26u as=0.14875p ps=1.16u w=0.74u l=0.13u
X8 VPWR VGND VPWR VPWR sg13_lv_pmos ad=0.34p pd=2.68u as=0 ps=0 w=1u l=1u
X9 VPWR VGND VPWR VPWR sg13_lv_pmos ad=0.34p pd=2.68u as=0 ps=0 w=1u l=1u
X10 VPWR VGND VPWR VPWR sg13_lv_pmos ad=0.19p pd=1.38u as=0 ps=0 w=1u l=1u
X11 a_2232_15428# _124_.S VGND VGND sg13_lv_nmos ad=0.187p pd=1.78u as=0.18945p ps=1.27u w=0.55u l=0.13u
X12 a_15601_12231# a_15141_12189# a_15243_12332# VGND sg13_lv_nmos ad=0.31732p pd=1.805u as=0.2516p ps=2.16u w=0.74u l=0.13u
X13 VGND VPWR VGND VGND sg13_lv_nmos ad=0.1428p pd=1.52u as=0 ps=0 w=0.42u l=1u
X14 VGND VPWR VGND VGND sg13_lv_nmos ad=0.1428p pd=1.52u as=0 ps=0 w=0.42u l=1u
X15 a_10864_4870# _225_.Y a_10924_4965# VPWR sg13_lv_pmos ad=79.8f pd=0.8u as=0.204p ps=1.835u w=0.42u l=0.13u
X16 _131_.Y _131_.B1 VGND VGND sg13_lv_nmos ad=0.1406p pd=1.12u as=0.2516p ps=2.16u w=0.74u l=0.13u
X17 a_3380_13690# clkbuf_1_0__f_sclk.A VPWR VPWR sg13_lv_pmos ad=0.2128p pd=1.5u as=0.2128p ps=1.5u w=1.12u l=0.13u
X18 a_13464_12952# _131_.A2 VPWR VPWR sg13_lv_pmos ad=0.2128p pd=1.5u as=0.3808p ps=2.92u w=1.12u l=0.15u
X19 VGND _136_.B _138_.Y VGND sg13_lv_nmos ad=0.2516p pd=2.16u as=0.1406p ps=1.12u w=0.74u l=0.13u
X20 VGND VPWR VGND VGND sg13_lv_nmos ad=79.8f pd=0.8u as=0 ps=0 w=0.42u l=1u
X21 VPWR VGND VPWR VPWR sg13_lv_pmos ad=0.34p pd=2.68u as=0 ps=0 w=1u l=1u
X22 VGND VPWR VGND VGND sg13_lv_nmos ad=0.1428p pd=1.52u as=0 ps=0 w=0.42u l=1u
X23 VPWR a_2126_7864# _122_.X VPWR sg13_lv_pmos ad=0.2198p pd=1.52u as=0.6048p ps=3.32u w=1.12u l=0.13u
X24 VPWR _160_.X a_10895_8436# VPWR sg13_lv_pmos ad=0.2128p pd=1.5u as=0.3808p ps=2.92u w=1.12u l=0.13u
X25 VGND _148_.B a_12331_5760# VGND sg13_lv_nmos ad=0.1331p pd=1.12u as=0.1216p ps=1.02u w=0.64u l=0.13u
X26 VPWR VGND VPWR VPWR sg13_lv_pmos ad=0.34p pd=2.68u as=0 ps=0 w=1u l=1u
X27 a_14698_12433# a_15141_12189# a_15081_12601# VPWR sg13_lv_pmos ad=79.8f pd=0.8u as=63f ps=0.72u w=0.42u l=0.13u
X28 VGND VPWR VGND VGND sg13_lv_nmos ad=0.1428p pd=1.52u as=0 ps=0 w=0.42u l=1u
X29 VGND VPWR VGND VGND sg13_lv_nmos ad=79.8f pd=0.8u as=0 ps=0 w=0.42u l=1u
X30 a_14757_15213# _266_.CLK a_15217_15530# VPWR sg13_lv_pmos ad=0.4088p pd=2.97u as=0.41165p ps=2.12u w=1.12u l=0.13u
X31 VGND VPWR VGND VGND sg13_lv_nmos ad=0.1428p pd=1.52u as=0 ps=0 w=0.42u l=1u
X32 VPWR VGND VPWR VPWR sg13_lv_pmos ad=0.19p pd=1.38u as=0 ps=0 w=1u l=1u
X33 VGND _118_.A0 a_4661_17878# VGND sg13_lv_nmos ad=0.1898p pd=1.36u as=0.2516p ps=2.16u w=0.74u l=0.13u
X34 _208_.X a_4625_16800# a_4796_17044# VPWR sg13_lv_pmos ad=0.3808p pd=2.92u as=0.2128p ps=1.5u w=1.12u l=0.13u
X35 a_8292_17064# a_8266_16969# VGND VGND sg13_lv_nmos ad=0.2516p pd=2.16u as=0.1626p ps=1.415u w=0.74u l=0.13u
X36 a_12940_17061# a_12880_16966# a_12825_17061# VPWR sg13_lv_pmos ad=0.204p pd=1.835u as=93.45f ps=0.865u w=0.42u l=0.13u
X37 _247_.CLK a_3380_13690# VGND VGND sg13_lv_nmos ad=0.1406p pd=1.12u as=0.1406p ps=1.12u w=0.74u l=0.13u
X38 VGND VPWR VGND VGND sg13_lv_nmos ad=79.8f pd=0.8u as=0 ps=0 w=0.42u l=1u
X39 a_3025_16349# a_2565_16007# a_2667_16007# VGND sg13_lv_nmos ad=0.31732p pd=1.805u as=0.2516p ps=2.16u w=0.74u l=0.13u
X40 VGND _183_.Y a_8050_10326# VGND sg13_lv_nmos ad=0.1406p pd=1.12u as=0.1406p ps=1.12u w=0.74u l=0.15u
X41 a_16079_11821# a_15237_11471# a_15985_11821# VGND sg13_lv_nmos ad=0.12665p pd=1.145u as=0.1428p ps=1.52u w=0.42u l=0.13u
X42 VGND a_3886_10702# clkbuf_1_0__f_sclk.A VGND sg13_lv_nmos ad=0.1406p pd=1.12u as=0.1406p ps=1.12u w=0.74u l=0.13u
X43 a_10308_17933# a_10539_17519# a_9994_17476# VGND sg13_lv_nmos ad=0.2373p pd=1.97u as=79.8f ps=0.8u w=0.42u l=0.13u
X44 a_7634_8802# _168_.Y VGND VGND sg13_lv_nmos ad=0.1406p pd=1.12u as=0.2886p ps=2.26u w=0.74u l=0.13u
X45 VPWR _228_.Y a_9994_9409# VPWR sg13_lv_pmos ad=0.1563p pd=1.22u as=0.147p ps=1.54u w=0.42u l=0.13u
X46 VGND VPWR VGND VGND sg13_lv_nmos ad=0.1428p pd=1.52u as=0 ps=0 w=0.42u l=1u
X47 _241_.Y _236_.A VPWR VPWR sg13_lv_pmos ad=0.3808p pd=2.92u as=0.3808p ps=2.92u w=1.12u l=0.13u
X48 a_6528_8475# _168_.A VPWR VPWR sg13_lv_pmos ad=0.1596p pd=1.22u as=0.4536p ps=2.76u w=0.84u l=0.13u
X49 VGND VPWR VGND VGND sg13_lv_nmos ad=0.1428p pd=1.52u as=0 ps=0 w=0.42u l=1u
X50 VGND a_16079_9263# a_16746_9484# VGND sg13_lv_nmos ad=0.1406p pd=1.12u as=0.2516p ps=2.16u w=0.74u l=0.13u
X51 VPWR VGND VPWR VPWR sg13_lv_pmos ad=0.34p pd=2.68u as=0 ps=0 w=1u l=1u
X52 a_6949_5782# _210_.A VGND VGND sg13_lv_nmos ad=0.1406p pd=1.12u as=0.14505p ps=1.15u w=0.74u l=0.13u
X53 VGND _222_.Y a_1956_16746# VGND sg13_lv_nmos ad=0.1626p pd=1.415u as=60.89999f ps=0.71u w=0.42u l=0.13u
X54 VGND VPWR VGND VGND sg13_lv_nmos ad=0.1428p pd=1.52u as=0 ps=0 w=0.42u l=1u
X55 a_2301_4654# _124_.S VGND VGND sg13_lv_nmos ad=0.13135p pd=1.095u as=0.18945p ps=1.27u w=0.74u l=0.13u
X56 a_10737_3900# _243_.Q VPWR VPWR sg13_lv_pmos ad=0.1225p pd=1.245u as=0.36p ps=2.72u w=1u l=0.13u
X57 a_8501_10702# _181_.Y VGND VGND sg13_lv_nmos ad=0.1406p pd=1.12u as=0.1898p ps=1.36u w=0.74u l=0.13u
X58 a_2342_4338# a_3147_3911# a_2602_3868# VPWR sg13_lv_pmos ad=0.1428p pd=1.52u as=79.8f ps=0.8u w=0.42u l=0.13u
X59 a_7908_16000# a_8427_16007# a_9167_16357# VGND sg13_lv_nmos ad=0.3473p pd=2.71u as=0.12665p ps=1.145u w=0.74u l=0.13u
X60 a_6885_4629# _251_.CLK a_7345_4671# VGND sg13_lv_nmos ad=0.2516p pd=2.16u as=0.31732p ps=1.805u w=0.74u l=0.13u
X61 a_13824_7989# _160_.B VPWR VPWR sg13_lv_pmos ad=0.1596p pd=1.22u as=0.4536p ps=2.76u w=0.84u l=0.13u
X62 VPWR _166_.A _170_.B VPWR sg13_lv_pmos ad=0.3808p pd=2.92u as=0.2128p ps=1.5u w=1.12u l=0.13u
X63 VGND VPWR VGND VGND sg13_lv_nmos ad=0.1428p pd=1.52u as=0 ps=0 w=0.42u l=1u
X64 VPWR a_3886_10702# clkbuf_1_0__f_sclk.A VPWR sg13_lv_pmos ad=0.2128p pd=1.5u as=0.2128p ps=1.5u w=1.12u l=0.13u
X65 a_7553_14832# _186_.Y _202_.Y VGND sg13_lv_nmos ad=0.1406p pd=1.12u as=0.1406p ps=1.12u w=0.74u l=0.13u
X66 a_1580_12936# fanout8.A VPWR VPWR sg13_lv_pmos ad=0.2856p pd=2.36u as=0.2114p ps=1.54u w=0.84u l=0.13u
X67 fanout8.A a_1192_17508# VPWR VPWR sg13_lv_pmos ad=0.42p pd=2.99u as=0.2114p ps=1.54u w=1.12u l=0.13u
X68 VPWR _170_.Y a_8014_8492# VPWR sg13_lv_pmos ad=0.2618p pd=1.63u as=0.2856p ps=2.36u w=0.84u l=0.13u
X69 VPWR _180_.X a_8603_9484# VPWR sg13_lv_pmos ad=0.2128p pd=1.5u as=0.2128p ps=1.5u w=1.12u l=0.13u
X70 a_16281_11583# a_15339_11471# a_16079_11821# VPWR sg13_lv_pmos ad=93.45f pd=0.865u as=0.2048p ps=1.63u w=0.42u l=0.13u
X71 a_12132_12528# a_12651_12332# a_13391_12287# VGND sg13_lv_nmos ad=0.3473p pd=2.71u as=0.12665p ps=1.145u w=0.74u l=0.13u
X72 a_2298_10318# a_2232_10210# VGND VGND sg13_lv_nmos ad=0.3367p pd=1.65u as=0.148p ps=1.14u w=0.74u l=0.13u
X73 a_15697_8789# a_15237_8447# a_15339_8447# VGND sg13_lv_nmos ad=0.31732p pd=1.805u as=0.2516p ps=2.16u w=0.74u l=0.13u
X74 a_6320_10296# _174_.Y a_6218_10296# VGND sg13_lv_nmos ad=0.1216p pd=1.02u as=0.1216p ps=1.02u w=0.64u l=0.13u
X75 VGND _178_.Y _185_.Y VGND sg13_lv_nmos ad=0.2516p pd=2.16u as=0.1406p ps=1.12u w=0.74u l=0.13u
X76 _201_.Y a_6286_15276# VGND VGND sg13_lv_nmos ad=0.1406p pd=1.12u as=0.17255p ps=1.25u w=0.74u l=0.13u
X77 VGND VPWR VGND VGND sg13_lv_nmos ad=79.8f pd=0.8u as=0 ps=0 w=0.42u l=1u
X78 VPWR _250_.RESET_B a_2122_15964# VPWR sg13_lv_pmos ad=0.1563p pd=1.22u as=0.147p ps=1.54u w=0.42u l=0.13u
X79 VPWR VGND VPWR VPWR sg13_lv_pmos ad=0.34p pd=2.68u as=0 ps=0 w=1u l=1u
X80 VPWR VGND VPWR VPWR sg13_lv_pmos ad=0.34p pd=2.68u as=0 ps=0 w=1u l=1u
X81 VGND VPWR VGND VGND sg13_lv_nmos ad=79.8f pd=0.8u as=0 ps=0 w=0.42u l=1u
X82 VPWR VGND VPWR VPWR sg13_lv_pmos ad=0.19p pd=1.38u as=0 ps=0 w=1u l=1u
X83 a_14820_11464# a_14794_11428# VGND VGND sg13_lv_nmos ad=0.2516p pd=2.16u as=0.1626p ps=1.415u w=0.74u l=0.13u
X84 VGND _148_.B a_4913_13330# VGND sg13_lv_nmos ad=0.15245p pd=1.17u as=0.17462p ps=1.185u w=0.55u l=0.13u
X85 a_6442_4873# a_6885_4629# a_6825_5041# VPWR sg13_lv_pmos ad=79.8f pd=0.8u as=63f ps=0.72u w=0.42u l=0.13u
X86 _210_.B a_6810_3863# VGND VGND sg13_lv_nmos ad=0.1628p pd=1.18u as=0.3108p ps=2.32u w=0.74u l=0.13u
X87 VGND VPWR VGND VGND sg13_lv_nmos ad=79.8f pd=0.8u as=0 ps=0 w=0.42u l=1u
X88 VGND VPWR VGND VGND sg13_lv_nmos ad=79.8f pd=0.8u as=0 ps=0 w=0.42u l=1u
X89 VPWR VGND VPWR VPWR sg13_lv_pmos ad=0.34p pd=2.68u as=0 ps=0 w=1u l=1u
X90 VPWR VGND VPWR VPWR sg13_lv_pmos ad=0.19p pd=1.38u as=0 ps=0 w=1u l=1u
X91 a_10020_9504# a_9994_9409# VPWR VPWR sg13_lv_pmos ad=0.34p pd=2.68u as=0.36237p ps=2.605u w=1u l=0.13u
X92 _232_.Y _222_.A VGND VGND sg13_lv_nmos ad=0.2516p pd=2.16u as=0.2516p ps=2.16u w=0.74u l=0.13u
X93 a_8785_16349# a_8325_16007# a_8427_16007# VGND sg13_lv_nmos ad=0.31732p pd=1.805u as=0.2516p ps=2.16u w=0.74u l=0.13u
X94 a_15983_12287# a_15141_12189# a_15889_12287# VGND sg13_lv_nmos ad=0.12665p pd=1.145u as=0.1428p ps=1.52u w=0.42u l=0.13u
X95 _149_.A a_16650_5412# VGND VGND sg13_lv_nmos ad=0.2516p pd=2.16u as=0.1406p ps=1.12u w=0.74u l=0.13u
X96 a_6962_9194# _178_.B1 VGND VGND sg13_lv_nmos ad=0.1406p pd=1.12u as=0.2886p ps=2.26u w=0.74u l=0.13u
X97 VPWR VGND VPWR VPWR sg13_lv_pmos ad=0.19p pd=1.38u as=0 ps=0 w=1u l=1u
X98 a_15108_8861# a_15339_8447# a_14794_8404# VGND sg13_lv_nmos ad=0.2373p pd=1.97u as=79.8f ps=0.8u w=0.42u l=0.13u
X99 _179_.Y _177_.X VGND VGND sg13_lv_nmos ad=0.1406p pd=1.12u as=0.2516p ps=2.16u w=0.74u l=0.13u
X100 a_2122_12940# a_2565_12983# a_1862_13410# VGND sg13_lv_nmos ad=79.8f pd=0.8u as=0.1296p ps=1.52u w=0.42u l=0.13u
X101 a_2244_12528# a_2218_12433# VGND VGND sg13_lv_nmos ad=0.2516p pd=2.16u as=0.1626p ps=1.415u w=0.74u l=0.13u
X102 VGND VPWR VGND VGND sg13_lv_nmos ad=79.8f pd=0.8u as=0 ps=0 w=0.42u l=1u
X103 VGND VPWR VGND VGND sg13_lv_nmos ad=0.1428p pd=1.52u as=0 ps=0 w=0.42u l=1u
X104 a_2512_5782# _210_.A a_2398_5782# VGND sg13_lv_nmos ad=0.3367p pd=1.65u as=0.1628p ps=1.18u w=0.74u l=0.13u
X105 a_2620_17878# _118_.A0 a_2126_17774# VGND sg13_lv_nmos ad=0.13135p pd=1.095u as=0.1628p ps=1.18u w=0.74u l=0.13u
X106 _210_.A a_5226_4948# VGND VGND sg13_lv_nmos ad=0.2516p pd=2.16u as=0.1406p ps=1.12u w=0.74u l=0.13u
X107 a_2853_9165# _243_.CLK a_3313_9207# VGND sg13_lv_nmos ad=0.2516p pd=2.16u as=0.31732p ps=1.805u w=0.74u l=0.13u
X108 a_12518_16434# _135_.X VPWR VPWR sg13_lv_pmos ad=79.8f pd=0.8u as=0.1428p ps=1.52u w=0.42u l=0.13u
X109 VGND a_12992_15437# _135_.X VGND sg13_lv_nmos ad=0.1331p pd=1.12u as=0.2516p ps=2.16u w=0.74u l=0.13u
X110 a_3014_4650# _242_.D VPWR VPWR sg13_lv_pmos ad=79.8f pd=0.8u as=0.1428p ps=1.52u w=0.42u l=0.13u
X111 _192_.Y _192_.C VPWR VPWR sg13_lv_pmos ad=0.2128p pd=1.5u as=0.3808p ps=2.92u w=1.12u l=0.13u
X112 a_8352_11013# _179_.Y VPWR VPWR sg13_lv_pmos ad=0.1596p pd=1.22u as=0.4536p ps=2.76u w=0.84u l=0.13u
X113 _119_.A0 a_4074_12972# VPWR VPWR sg13_lv_pmos ad=0.3808p pd=2.92u as=0.2128p ps=1.5u w=1.12u l=0.13u
X114 VPWR VGND VPWR VPWR sg13_lv_pmos ad=0.34p pd=2.68u as=0 ps=0 w=1u l=1u
X115 VGND VPWR VGND VGND sg13_lv_nmos ad=0.1428p pd=1.52u as=0 ps=0 w=0.42u l=1u
X116 VGND VPWR VGND VGND sg13_lv_nmos ad=0.1428p pd=1.52u as=0 ps=0 w=0.42u l=1u
X117 fanout6.A a_10218_17044# VPWR VPWR sg13_lv_pmos ad=0.3808p pd=2.92u as=0.2128p ps=1.5u w=1.12u l=0.13u
X118 a_15861_16904# _238_.Y VPWR VPWR sg13_lv_pmos ad=0.147p pd=1.54u as=0.1563p ps=1.22u w=0.42u l=0.13u
X119 a_15081_5459# a_14724_5416# VPWR VPWR sg13_lv_pmos ad=63f pd=0.72u as=0.1563p ps=1.22u w=0.42u l=0.13u
X120 a_12215_7664# _162_.Y VGND VGND sg13_lv_nmos ad=0.1406p pd=1.12u as=0.3811p ps=2.51u w=0.74u l=0.13u
X121 VGND VPWR VGND VGND sg13_lv_nmos ad=79.8f pd=0.8u as=0 ps=0 w=0.42u l=1u
X122 _218_.Y _215_.A VPWR VPWR sg13_lv_pmos ad=0.3808p pd=2.92u as=0.3808p ps=2.92u w=1.12u l=0.13u
X123 a_8315_10744# _179_.Y VGND VGND sg13_lv_nmos ad=78.39999f pd=0.885u as=0.2272p ps=1.99u w=0.64u l=0.13u
X124 _250_.Q a_4074_15996# VGND VGND sg13_lv_nmos ad=0.2516p pd=2.16u as=0.1406p ps=1.12u w=0.74u l=0.13u
X125 a_13019_6460# _152_.X _153_.Y VPWR sg13_lv_pmos ad=0.2128p pd=1.5u as=0.3808p ps=2.92u w=1.12u l=0.13u
X126 VPWR VGND VPWR VPWR sg13_lv_pmos ad=0.19p pd=1.38u as=0 ps=0 w=1u l=1u
X127 VPWR VGND VPWR VPWR sg13_lv_pmos ad=0.34p pd=2.68u as=0 ps=0 w=1u l=1u
X128 _153_.Y _152_.X VGND VGND sg13_lv_nmos ad=0.1406p pd=1.12u as=0.2516p ps=2.16u w=0.74u l=0.13u
X129 VPWR VGND VPWR VPWR sg13_lv_pmos ad=0.34p pd=2.68u as=0 ps=0 w=1u l=1u
X130 _219_.Y _215_.A VGND VGND sg13_lv_nmos ad=0.2516p pd=2.16u as=0.2516p ps=2.16u w=0.74u l=0.13u
X131 a_12992_15437# _135_.A a_13129_15280# VGND sg13_lv_nmos ad=0.2176p pd=1.96u as=0.1216p ps=1.02u w=0.64u l=0.13u
X132 a_2661_12189# _247_.CLK a_3121_12506# VPWR sg13_lv_pmos ad=0.4088p pd=2.97u as=0.41165p ps=2.12u w=1.12u l=0.13u
X133 a_6862_15260# _200_.Y VGND VGND sg13_lv_nmos ad=0.1406p pd=1.12u as=0.2516p ps=2.16u w=0.74u l=0.13u
X134 VGND a_3956_6888# _243_.CLK VGND sg13_lv_nmos ad=0.1406p pd=1.12u as=0.1406p ps=1.12u w=0.74u l=0.13u
X135 a_10377_9577# a_10020_9504# VPWR VPWR sg13_lv_pmos ad=63f pd=0.72u as=0.1563p ps=1.22u w=0.42u l=0.13u
X136 VPWR VGND VPWR VPWR sg13_lv_pmos ad=0.19p pd=1.38u as=0 ps=0 w=1u l=1u
X137 VPWR VGND VPWR VPWR sg13_lv_pmos ad=0.34p pd=2.68u as=0 ps=0 w=1u l=1u
X138 a_16402_5850# _226_.Y VGND VGND sg13_lv_nmos ad=37.8f pd=0.6u as=79.8f ps=0.8u w=0.42u l=0.13u
X139 a_16281_8559# a_15339_8447# a_16079_8797# VPWR sg13_lv_pmos ad=93.45f pd=0.865u as=0.2048p ps=1.63u w=0.42u l=0.13u
X140 a_3121_12231# a_2661_12189# a_2763_12332# VGND sg13_lv_nmos ad=0.31732p pd=1.805u as=0.2516p ps=2.16u w=0.74u l=0.13u
X141 VPWR VGND VPWR VPWR sg13_lv_pmos ad=0.19p pd=1.38u as=0 ps=0 w=1u l=1u
X142 VPWR _260_.RESET_B a_14794_9409# VPWR sg13_lv_pmos ad=0.1563p pd=1.22u as=0.147p ps=1.54u w=0.42u l=0.13u
X143 a_6389_9484# _173_.Y VPWR VPWR sg13_lv_pmos ad=0.2128p pd=1.5u as=0.2128p ps=1.5u w=1.12u l=0.13u
X144 a_5147_15996# _207_.A2 VPWR VPWR sg13_lv_pmos ad=0.3808p pd=2.92u as=0.2128p ps=1.5u w=1.12u l=0.13u
X145 a_11279_9263# a_10437_9165# a_10020_9504# VPWR sg13_lv_pmos ad=0.2048p pd=1.63u as=0.34p ps=2.68u w=1u l=0.13u
X146 VGND a_15599_15311# a_16266_15532# VGND sg13_lv_nmos ad=0.1406p pd=1.12u as=0.2516p ps=2.16u w=0.74u l=0.13u
X147 VPWR VGND VPWR VPWR sg13_lv_pmos ad=0.34p pd=2.68u as=0 ps=0 w=1u l=1u
X148 a_2342_4338# _243_.D VPWR VPWR sg13_lv_pmos ad=79.8f pd=0.8u as=0.1428p ps=1.52u w=0.42u l=0.13u
X149 VGND _147_.B1 _147_.Y VGND sg13_lv_nmos ad=0.2516p pd=2.16u as=0.1406p ps=1.12u w=0.74u l=0.13u
X150 VGND _210_.B a_6747_5468# VGND sg13_lv_nmos ad=0.14505p pd=1.15u as=0.187p ps=1.78u w=0.55u l=0.13u
X151 VGND VPWR VGND VGND sg13_lv_nmos ad=0.1428p pd=1.52u as=0 ps=0 w=0.42u l=1u
X152 _243_.CLK a_3956_6888# VGND VGND sg13_lv_nmos ad=0.1406p pd=1.12u as=0.1406p ps=1.12u w=0.74u l=0.13u
X153 VGND _148_.X a_13775_5782# VGND sg13_lv_nmos ad=0.1898p pd=1.36u as=0.1406p ps=1.12u w=0.74u l=0.13u
X154 a_6011_13320# _190_.A VGND VGND sg13_lv_nmos ad=78.39999f pd=0.885u as=0.2272p ps=1.99u w=0.64u l=0.13u
X155 _128_.B1 _260_.CLK VPWR VPWR sg13_lv_pmos ad=0.2128p pd=1.5u as=0.3808p ps=2.92u w=1.12u l=0.13u
X156 VGND VPWR VGND VGND sg13_lv_nmos ad=79.8f pd=0.8u as=0 ps=0 w=0.42u l=1u
X157 VPWR VGND VPWR VPWR sg13_lv_pmos ad=0.34p pd=2.68u as=0 ps=0 w=1u l=1u
X158 _187_.Y _120_.A0 VPWR VPWR sg13_lv_pmos ad=0.2128p pd=1.5u as=0.3808p ps=2.92u w=1.12u l=0.13u
X159 a_13030_16421# _237_.Y VGND VGND sg13_lv_nmos ad=37.8f pd=0.6u as=0.1701p ps=1.65u w=0.42u l=0.13u
X160 a_12420_12223# a_12132_12528# a_12358_12223# VGND sg13_lv_nmos ad=0.1428p pd=1.52u as=37.8f ps=0.6u w=0.42u l=0.13u
X161 a_7872_5451# _145_.A2 a_7835_5760# VGND sg13_lv_nmos ad=0.2176p pd=1.96u as=78.39999f ps=0.885u w=0.64u l=0.13u
X162 VGND VPWR VGND VGND sg13_lv_nmos ad=79.8f pd=0.8u as=0 ps=0 w=0.42u l=1u
X163 VGND a_3956_6888# _243_.CLK VGND sg13_lv_nmos ad=0.1406p pd=1.12u as=0.1406p ps=1.12u w=0.74u l=0.13u
X164 VPWR _207_.A2 a_5376_17061# VPWR sg13_lv_pmos ad=0.2891p pd=1.695u as=0.1596p ps=1.22u w=0.84u l=0.13u
X165 a_11590_16759# _241_.Y VGND VGND sg13_lv_nmos ad=37.8f pd=0.6u as=0.1701p ps=1.65u w=0.42u l=0.13u
X166 _247_.CLK a_3380_13690# VPWR VPWR sg13_lv_pmos ad=0.2128p pd=1.5u as=0.3976p ps=2.95u w=1.12u l=0.13u
X167 a_3274_5380# a_3717_5423# a_3014_5850# VGND sg13_lv_nmos ad=79.8f pd=0.8u as=0.1296p ps=1.52u w=0.42u l=0.13u
X168 VPWR VGND VPWR VPWR sg13_lv_pmos ad=0.19p pd=1.38u as=0 ps=0 w=1u l=1u
X169 VPWR _124_.S a_2558_15532# VPWR sg13_lv_pmos ad=0.253p pd=1.53u as=0.3325p ps=1.665u w=1u l=0.13u
X170 VGND VPWR VGND VGND sg13_lv_nmos ad=79.8f pd=0.8u as=0 ps=0 w=0.42u l=1u
X171 VPWR _191_.Y a_6862_15532# VPWR sg13_lv_pmos ad=0.3808p pd=2.92u as=0.2128p ps=1.5u w=1.12u l=0.13u
X172 a_14534_11898# a_15339_11471# a_14794_11428# VPWR sg13_lv_pmos ad=0.1428p pd=1.52u as=79.8f ps=0.8u w=0.42u l=0.13u
X173 a_2436_8440# a_2410_8404# VPWR VPWR sg13_lv_pmos ad=0.34p pd=2.68u as=0.36237p ps=2.605u w=1u l=0.13u
X174 VPWR _240_.Y a_9994_17476# VPWR sg13_lv_pmos ad=0.1563p pd=1.22u as=0.147p ps=1.54u w=0.42u l=0.13u
X175 a_4890_16762# _250_.Q VGND VGND sg13_lv_nmos ad=88.8f pd=0.98u as=0.15245p ps=1.17u w=0.74u l=0.13u
X176 a_2232_7868# _124_.S VGND VGND sg13_lv_nmos ad=0.187p pd=1.78u as=0.18945p ps=1.27u w=0.55u l=0.13u
X177 _134_.Y _133_.Y a_12886_13350# VGND sg13_lv_nmos ad=0.2516p pd=2.16u as=0.1406p ps=1.12u w=0.74u l=0.15u
X178 VGND VPWR VGND VGND sg13_lv_nmos ad=0.1428p pd=1.52u as=0 ps=0 w=0.42u l=1u
X179 _247_.CLK a_3380_13690# VGND VGND sg13_lv_nmos ad=0.1406p pd=1.12u as=0.1406p ps=1.12u w=0.74u l=0.13u
X180 a_11338_16969# a_11781_16725# a_11721_17137# VPWR sg13_lv_pmos ad=79.8f pd=0.8u as=63f ps=0.72u w=0.42u l=0.13u
X181 VPWR VGND VPWR VPWR sg13_lv_pmos ad=0.34p pd=2.68u as=0 ps=0 w=1u l=1u
X182 VGND VPWR VGND VGND sg13_lv_nmos ad=79.8f pd=0.8u as=0 ps=0 w=0.42u l=1u
X183 a_12778_15964# a_13221_16007# a_12518_16434# VGND sg13_lv_nmos ad=79.8f pd=0.8u as=0.1296p ps=1.52u w=0.42u l=0.13u
X184 a_8506_10318# _171_.Y _183_.Y VGND sg13_lv_nmos ad=0.1406p pd=1.12u as=0.2516p ps=2.16u w=0.74u l=0.13u
X185 a_13009_12231# a_12549_12189# a_12651_12332# VGND sg13_lv_nmos ad=0.31732p pd=1.805u as=0.2516p ps=2.16u w=0.74u l=0.13u
X186 VGND VPWR VGND VGND sg13_lv_nmos ad=0.1428p pd=1.52u as=0 ps=0 w=0.42u l=1u
X187 a_15141_5423# _251_.CLK a_15601_5414# VPWR sg13_lv_pmos ad=0.4088p pd=2.97u as=0.41165p ps=2.12u w=1.12u l=0.13u
X188 VPWR _229_.Y a_9130_12433# VPWR sg13_lv_pmos ad=0.1563p pd=1.22u as=0.147p ps=1.54u w=0.42u l=0.13u
X189 _147_.A1 a_11274_4948# VGND VGND sg13_lv_nmos ad=0.2516p pd=2.16u as=0.1406p ps=1.12u w=0.74u l=0.13u
X190 VPWR _218_.Y a_2410_8404# VPWR sg13_lv_pmos ad=0.1563p pd=1.22u as=0.147p ps=1.54u w=0.42u l=0.13u
X191 a_13321_7272# _160_.B VGND VGND sg13_lv_nmos ad=0.1216p pd=1.02u as=0.1331p ps=1.12u w=0.64u l=0.13u
X192 a_16300_5535# a_16240_5654# a_16185_5535# VPWR sg13_lv_pmos ad=0.204p pd=1.835u as=93.45f ps=0.865u w=0.42u l=0.13u
X193 a_2575_5436# _125_.A1 a_2398_5782# VPWR sg13_lv_pmos ad=0.2975p pd=1.595u as=0.2225p ps=1.445u w=1u l=0.13u
X194 VGND _162_.B a_13073_7728# VGND sg13_lv_nmos ad=0.15245p pd=1.17u as=0.17462p ps=1.185u w=0.55u l=0.13u
X195 a_9169_16767# a_8709_16725# a_8811_16868# VGND sg13_lv_nmos ad=0.31732p pd=1.805u as=0.2516p ps=2.16u w=0.74u l=0.13u
X196 VGND VPWR VGND VGND sg13_lv_nmos ad=0.1428p pd=1.52u as=0 ps=0 w=0.42u l=1u
X197 VGND VPWR VGND VGND sg13_lv_nmos ad=79.8f pd=0.8u as=0 ps=0 w=0.42u l=1u
X198 VPWR VGND VPWR VPWR sg13_lv_pmos ad=0.19p pd=1.38u as=0 ps=0 w=1u l=1u
X199 a_4177_4671# a_3717_4629# a_3819_4772# VGND sg13_lv_nmos ad=0.31732p pd=1.805u as=0.2516p ps=2.16u w=0.74u l=0.13u
X200 _207_.Y _206_.Y VGND VGND sg13_lv_nmos ad=0.1406p pd=1.12u as=0.2516p ps=2.16u w=0.74u l=0.13u
X201 VPWR VGND VPWR VPWR sg13_lv_pmos ad=0.34p pd=2.68u as=0 ps=0 w=1u l=1u
X202 a_5084_12972# _148_.B VPWR VPWR sg13_lv_pmos ad=0.2128p pd=1.5u as=0.2128p ps=1.5u w=1.12u l=0.13u
X203 VPWR _145_.X a_13820_4948# VPWR sg13_lv_pmos ad=0.2128p pd=1.5u as=0.3808p ps=2.92u w=1.12u l=0.13u
X204 _214_.A a_11946_17508# VGND VGND sg13_lv_nmos ad=0.2516p pd=2.16u as=0.1406p ps=1.12u w=0.74u l=0.13u
X205 a_8709_16725# fanout7.A a_9169_17042# VPWR sg13_lv_pmos ad=0.4088p pd=2.97u as=0.41165p ps=2.12u w=1.12u l=0.13u
X206 VGND a_3380_13690# _247_.CLK VGND sg13_lv_nmos ad=0.1406p pd=1.12u as=0.1406p ps=1.12u w=0.74u l=0.13u
X207 a_4761_5535# a_3819_5423# a_4559_5773# VPWR sg13_lv_pmos ad=93.45f pd=0.865u as=0.2048p ps=1.63u w=0.42u l=0.13u
X208 VPWR a_10220_18222# _236_.A VPWR sg13_lv_pmos ad=0.2114p pd=1.54u as=0.42p ps=2.99u w=1.12u l=0.13u
X209 a_3503_12287# a_2661_12189# a_3409_12287# VGND sg13_lv_nmos ad=0.12665p pd=1.145u as=0.1428p ps=1.52u w=0.42u l=0.13u
X210 _192_.B _176_.B VPWR VPWR sg13_lv_pmos ad=0.2128p pd=1.5u as=0.3808p ps=2.92u w=1.12u l=0.13u
X211 VGND _225_.Y a_9156_4650# VGND sg13_lv_nmos ad=0.1626p pd=1.415u as=60.89999f ps=0.71u w=0.42u l=0.13u
X212 a_2301_5782# _124_.S VGND VGND sg13_lv_nmos ad=0.13135p pd=1.095u as=0.18945p ps=1.27u w=0.74u l=0.13u
X213 a_15177_9577# a_14820_9504# VPWR VPWR sg13_lv_pmos ad=63f pd=0.72u as=0.1563p ps=1.22u w=0.42u l=0.13u
X214 a_12804_16000# a_12778_15964# VPWR VPWR sg13_lv_pmos ad=0.34p pd=2.68u as=0.36237p ps=2.605u w=1u l=0.13u
X215 VPWR _174_.Y _184_.Y VPWR sg13_lv_pmos ad=0.2128p pd=1.5u as=0.2128p ps=1.5u w=1.12u l=0.13u
X216 VGND VPWR VGND VGND sg13_lv_nmos ad=0.1428p pd=1.52u as=0 ps=0 w=0.42u l=1u
X217 VPWR VGND VPWR VPWR sg13_lv_pmos ad=0.34p pd=2.68u as=0 ps=0 w=1u l=1u
X218 VPWR VGND VPWR VPWR sg13_lv_pmos ad=0.19p pd=1.38u as=0 ps=0 w=1u l=1u
X219 a_16079_9263# a_15237_9165# a_14820_9504# VPWR sg13_lv_pmos ad=0.2048p pd=1.63u as=0.34p ps=2.68u w=1u l=0.13u
X220 VGND a_3380_13690# _247_.CLK VGND sg13_lv_nmos ad=0.1406p pd=1.12u as=0.1406p ps=1.12u w=0.74u l=0.13u
X221 a_8564_5412# _138_.Y VPWR VPWR sg13_lv_pmos ad=0.3808p pd=2.92u as=0.2128p ps=1.5u w=1.12u l=0.13u
X222 _173_.Y _173_.A VPWR VPWR sg13_lv_pmos ad=0.2128p pd=1.5u as=0.3808p ps=2.92u w=1.12u l=0.13u
X223 a_3952_9406# a_3695_9263# a_4114_9186# VGND sg13_lv_nmos ad=0.1428p pd=1.52u as=37.8f ps=0.6u w=0.42u l=0.13u
X224 VGND a_1580_16710# _222_.A VGND sg13_lv_nmos ad=0.14875p pd=1.16u as=0.2886p ps=2.26u w=0.74u l=0.13u
X225 VPWR VGND VPWR VPWR sg13_lv_pmos ad=0.34p pd=2.68u as=0 ps=0 w=1u l=1u
X226 a_10895_8436# _160_.X VPWR VPWR sg13_lv_pmos ad=0.2128p pd=1.5u as=0.2128p ps=1.5u w=1.12u l=0.13u
X227 a_8705_9212# _180_.X _181_.Y VGND sg13_lv_nmos ad=0.1406p pd=1.12u as=0.1406p ps=1.12u w=0.74u l=0.13u
X228 a_14438_5850# _151_.X VPWR VPWR sg13_lv_pmos ad=79.8f pd=0.8u as=0.1428p ps=1.52u w=0.42u l=0.13u
X229 a_13787_7720# _160_.B VGND VGND sg13_lv_nmos ad=78.39999f pd=0.885u as=0.2272p ps=1.99u w=0.64u l=0.13u
X230 _147_.B1 a_11661_4696# VGND VGND sg13_lv_nmos ad=0.2516p pd=2.16u as=0.1331p ps=1.12u w=0.74u l=0.13u
X231 VGND VPWR VGND VGND sg13_lv_nmos ad=0.1428p pd=1.52u as=0 ps=0 w=0.42u l=1u
X232 a_5339_16792# _207_.A1 VGND VGND sg13_lv_nmos ad=78.39999f pd=0.885u as=0.2272p ps=1.99u w=0.64u l=0.13u
X233 a_14314_15457# a_14757_15213# a_14697_15625# VPWR sg13_lv_pmos ad=79.8f pd=0.8u as=63f ps=0.72u w=0.42u l=0.13u
X234 VPWR VGND VPWR VPWR sg13_lv_pmos ad=0.19p pd=1.38u as=0 ps=0 w=1u l=1u
X235 a_12984_12952# _148_.B VPWR VPWR sg13_lv_pmos ad=0.2128p pd=1.5u as=0.3808p ps=2.92u w=1.12u l=0.15u
X236 VGND VPWR VGND VGND sg13_lv_nmos ad=0.1428p pd=1.52u as=0 ps=0 w=0.42u l=1u
X237 VGND _243_.RESET_B a_2436_4338# VGND sg13_lv_nmos ad=0.1626p pd=1.415u as=60.89999f ps=0.71u w=0.42u l=0.13u
X238 VGND VPWR VGND VGND sg13_lv_nmos ad=0.1428p pd=1.52u as=0 ps=0 w=0.42u l=1u
X239 VPWR VGND VPWR VPWR sg13_lv_pmos ad=0.19p pd=1.38u as=0 ps=0 w=1u l=1u
X240 a_1580_12936# fanout8.A VGND VGND sg13_lv_nmos ad=0.187p pd=1.78u as=0.14875p ps=1.16u w=0.55u l=0.13u
X241 _133_.Y _132_.Y VGND VGND sg13_lv_nmos ad=0.2618p pd=2.22u as=0.1463p ps=1.15u w=0.77u l=0.13u
X242 VGND VPWR VGND VGND sg13_lv_nmos ad=0.1428p pd=1.52u as=0 ps=0 w=0.42u l=1u
X243 a_2232_11722# _124_.S VPWR VPWR sg13_lv_pmos ad=0.2856p pd=2.36u as=0.253p ps=1.53u w=0.84u l=0.13u
X244 a_13649_4704# _145_.X VGND VGND sg13_lv_nmos ad=0.17462p pd=1.185u as=0.374p ps=2.46u w=0.55u l=0.13u
X245 a_10225_4671# a_9765_4629# a_9867_4772# VGND sg13_lv_nmos ad=0.31732p pd=1.805u as=0.2516p ps=2.16u w=0.74u l=0.13u
X246 a_3956_6888# clkbuf_1_0__f_sclk.A VGND VGND sg13_lv_nmos ad=0.1406p pd=1.12u as=0.1406p ps=1.12u w=0.74u l=0.13u
X247 a_10897_17861# a_10437_17519# a_10539_17519# VGND sg13_lv_nmos ad=0.31732p pd=1.805u as=0.2516p ps=2.16u w=0.74u l=0.13u
X248 a_6508_15532# a_6286_15276# VPWR VPWR sg13_lv_pmos ad=0.1176p pd=1.33u as=0.2618p ps=1.63u w=1.12u l=0.13u
X249 VPWR _221_.Y a_2122_12940# VPWR sg13_lv_pmos ad=0.1563p pd=1.22u as=0.147p ps=1.54u w=0.42u l=0.13u
X250 _129_.B1 _128_.B1 a_13366_13350# VGND sg13_lv_nmos ad=0.2516p pd=2.16u as=0.1406p ps=1.12u w=0.74u l=0.15u
X251 _242_.D a_2398_5782# VPWR VPWR sg13_lv_pmos ad=0.6048p pd=3.32u as=0.2198p ps=1.52u w=1.12u l=0.13u
X252 a_9444_13735# a_9675_13844# a_9130_13945# VGND sg13_lv_nmos ad=0.2373p pd=1.97u as=79.8f ps=0.8u w=0.42u l=0.13u
X253 a_9382_13735# _230_.Y VGND VGND sg13_lv_nmos ad=37.8f pd=0.6u as=0.1701p ps=1.65u w=0.42u l=0.13u
X254 a_12549_7996# _161_.Y VPWR VPWR sg13_lv_pmos ad=0.34p pd=2.68u as=0.19p ps=1.38u w=1u l=0.13u
X255 a_7251_15996# _201_.Y VPWR VPWR sg13_lv_pmos ad=0.1428p pd=1.375u as=0.2891p ps=1.695u w=1.12u l=0.13u
X256 VPWR a_3956_6888# _243_.CLK VPWR sg13_lv_pmos ad=0.2128p pd=1.5u as=0.2128p ps=1.5u w=1.12u l=0.13u
X257 VPWR VGND VPWR VPWR sg13_lv_pmos ad=0.34p pd=2.68u as=0 ps=0 w=1u l=1u
X258 VGND VPWR VGND VGND sg13_lv_nmos ad=79.8f pd=0.8u as=0 ps=0 w=0.42u l=1u
X259 VPWR _153_.Y _161_.Y VPWR sg13_lv_pmos ad=0.3808p pd=2.92u as=0.2128p ps=1.5u w=1.12u l=0.13u
X260 a_13244_7972# _162_.B VPWR VPWR sg13_lv_pmos ad=0.2128p pd=1.5u as=0.2128p ps=1.5u w=1.12u l=0.13u
X261 a_6491_8784# _168_.A VGND VGND sg13_lv_nmos ad=78.39999f pd=0.885u as=0.2272p ps=1.99u w=0.64u l=0.13u
X262 a_5178_13330# _119_.A0 VGND VGND sg13_lv_nmos ad=88.8f pd=0.98u as=0.15245p ps=1.17u w=0.74u l=0.13u
X263 a_7727_4727# a_6885_4629# a_7633_4727# VGND sg13_lv_nmos ad=0.12665p pd=1.145u as=0.1428p ps=1.52u w=0.42u l=0.13u
X264 VPWR a_3503_12287# a_3760_12430# VPWR sg13_lv_pmos ad=0.4659p pd=3.65u as=79.8f ps=0.8u w=0.42u l=0.13u
X265 a_3717_5423# _243_.CLK a_4177_5414# VPWR sg13_lv_pmos ad=0.4088p pd=2.97u as=0.41165p ps=2.12u w=1.12u l=0.13u
X266 VGND VPWR VGND VGND sg13_lv_nmos ad=79.8f pd=0.8u as=0 ps=0 w=0.42u l=1u
X267 a_9130_13945# a_9573_13701# a_9513_14113# VPWR sg13_lv_pmos ad=79.8f pd=0.8u as=63f ps=0.72u w=0.42u l=0.13u
X268 _243_.CLK a_3956_6888# VPWR VPWR sg13_lv_pmos ad=0.2128p pd=1.5u as=0.2128p ps=1.5u w=1.12u l=0.13u
X269 VGND VPWR VGND VGND sg13_lv_nmos ad=79.8f pd=0.8u as=0 ps=0 w=0.42u l=1u
X270 VPWR _124_.S a_2171_6204# VPWR sg13_lv_pmos ad=0.253p pd=1.53u as=0.2856p ps=2.36u w=0.84u l=0.13u
X271 _182_.Y _181_.Y a_8595_10996# VPWR sg13_lv_pmos ad=0.2408p pd=1.55u as=0.1428p ps=1.375u w=1.12u l=0.13u
X272 a_10020_9504# a_9994_9409# VGND VGND sg13_lv_nmos ad=0.2516p pd=2.16u as=0.1626p ps=1.415u w=0.74u l=0.13u
X273 VPWR VGND VPWR VPWR sg13_lv_pmos ad=0.34p pd=2.68u as=0 ps=0 w=1u l=1u
X274 VGND VPWR VGND VGND sg13_lv_nmos ad=0.1428p pd=1.52u as=0 ps=0 w=0.42u l=1u
X275 VGND VPWR VGND VGND sg13_lv_nmos ad=0.1428p pd=1.52u as=0 ps=0 w=0.42u l=1u
X276 VPWR _124_.S a_2558_9972# VPWR sg13_lv_pmos ad=0.253p pd=1.53u as=0.3325p ps=1.665u w=1u l=0.13u
X277 VPWR VGND VPWR VPWR sg13_lv_pmos ad=0.19p pd=1.38u as=0 ps=0 w=1u l=1u
X278 VPWR _210_.A a_6060_4166# VPWR sg13_lv_pmos ad=0.4536p pd=2.76u as=0.1596p ps=1.22u w=0.84u l=0.13u
X279 a_10732_12525# a_10672_12430# a_10617_12525# VPWR sg13_lv_pmos ad=0.204p pd=1.835u as=93.45f ps=0.865u w=0.42u l=0.13u
X280 VGND VPWR VGND VGND sg13_lv_nmos ad=0.1428p pd=1.52u as=0 ps=0 w=0.42u l=1u
X281 _119_.A0 a_4074_12972# VGND VGND sg13_lv_nmos ad=0.2516p pd=2.16u as=0.1406p ps=1.12u w=0.74u l=0.13u
X282 VPWR a_3956_6888# _243_.CLK VPWR sg13_lv_pmos ad=0.2128p pd=1.5u as=0.2128p ps=1.5u w=1.12u l=0.13u
X283 VPWR VGND VPWR VPWR sg13_lv_pmos ad=0.34p pd=2.68u as=0 ps=0 w=1u l=1u
X284 VPWR _120_.A0 a_5468_12508# VPWR sg13_lv_pmos ad=0.2128p pd=1.5u as=0.3808p ps=2.92u w=1.12u l=0.13u
X285 a_7727_4727# a_6885_4629# a_6468_4968# VPWR sg13_lv_pmos ad=0.2048p pd=1.63u as=0.34p ps=2.68u w=1u l=0.13u
X286 _178_.Y _173_.Y a_6483_9212# VGND sg13_lv_nmos ad=0.1406p pd=1.12u as=0.1406p ps=1.12u w=0.74u l=0.13u
X287 VPWR VGND VPWR VPWR sg13_lv_pmos ad=0.19p pd=1.38u as=0 ps=0 w=1u l=1u
X288 a_15012_12223# a_14724_12528# a_14950_12223# VGND sg13_lv_nmos ad=0.1428p pd=1.52u as=37.8f ps=0.6u w=0.42u l=0.13u
X289 VPWR VGND VPWR VPWR sg13_lv_pmos ad=0.34p pd=2.68u as=0 ps=0 w=1u l=1u
X290 VPWR VGND VPWR VPWR sg13_lv_pmos ad=0.19p pd=1.38u as=0 ps=0 w=1u l=1u
X291 a_13883_11460# _126_.B1 VPWR VPWR sg13_lv_pmos ad=0.3808p pd=2.92u as=0.2128p ps=1.5u w=1.12u l=0.13u
X292 VGND _144_.Y a_8557_4248# VGND sg13_lv_nmos ad=0.3811p pd=2.51u as=0.1406p ps=1.12u w=0.74u l=0.13u
X293 VGND _124_.S a_2620_7678# VGND sg13_lv_nmos ad=0.18945p pd=1.27u as=0.13135p ps=1.095u w=0.74u l=0.13u
X294 VPWR VGND VPWR VPWR sg13_lv_pmos ad=0.34p pd=2.68u as=0 ps=0 w=1u l=1u
X295 VPWR _236_.Y a_14534_11898# VPWR sg13_lv_pmos ad=0.36237p pd=2.605u as=79.8f ps=0.8u w=0.42u l=0.13u
X296 a_12358_12223# _234_.Y VGND VGND sg13_lv_nmos ad=37.8f pd=0.6u as=0.1701p ps=1.65u w=0.42u l=0.13u
X297 VPWR VGND VPWR VPWR sg13_lv_pmos ad=0.19p pd=1.38u as=0 ps=0 w=1u l=1u
X298 a_9734_9186# a_10539_9308# a_9994_9409# VPWR sg13_lv_pmos ad=0.1428p pd=1.52u as=79.8f ps=0.8u w=0.42u l=0.13u
X299 _164_.B1 a_12215_7664# VPWR VPWR sg13_lv_pmos ad=0.2128p pd=1.5u as=0.3808p ps=2.92u w=1.12u l=0.13u
X300 VPWR _189_.X a_6048_13011# VPWR sg13_lv_pmos ad=0.2891p pd=1.695u as=0.1596p ps=1.22u w=0.84u l=0.13u
X301 VPWR VGND VPWR VPWR sg13_lv_pmos ad=0.34p pd=2.68u as=0 ps=0 w=1u l=1u
X302 a_4755_17508# _118_.A0 VPWR VPWR sg13_lv_pmos ad=0.1428p pd=1.375u as=0.2891p ps=1.695u w=1.12u l=0.13u
X303 VGND VPWR VGND VGND sg13_lv_nmos ad=0.1428p pd=1.52u as=0 ps=0 w=0.42u l=1u
X304 a_15012_5837# a_15243_5423# a_14698_5380# VGND sg13_lv_nmos ad=0.2373p pd=1.97u as=79.8f ps=0.8u w=0.42u l=0.13u
X305 VGND a_3956_6888# _243_.CLK VGND sg13_lv_nmos ad=0.1406p pd=1.12u as=0.1406p ps=1.12u w=0.74u l=0.13u
X306 VGND _160_.X a_12110_8784# VGND sg13_lv_nmos ad=0.2176p pd=1.96u as=81.6f ps=0.895u w=0.64u l=0.13u
X307 VGND _236_.Y a_14628_11898# VGND sg13_lv_nmos ad=0.1626p pd=1.415u as=60.89999f ps=0.71u w=0.42u l=0.13u
X308 VGND _131_.A2 a_13366_13350# VGND sg13_lv_nmos ad=0.1406p pd=1.12u as=0.2516p ps=2.16u w=0.74u l=0.15u
X309 VPWR _145_.X a_13403_8436# VPWR sg13_lv_pmos ad=0.2128p pd=1.5u as=0.2128p ps=1.5u w=1.12u l=0.13u
X310 VGND VPWR VGND VGND sg13_lv_nmos ad=79.8f pd=0.8u as=0 ps=0 w=0.42u l=1u
X311 VPWR _215_.A _221_.Y VPWR sg13_lv_pmos ad=0.3808p pd=2.92u as=0.3808p ps=2.92u w=1.12u l=0.13u
X312 a_2298_11830# a_2232_11722# VGND VGND sg13_lv_nmos ad=0.3367p pd=1.65u as=0.148p ps=1.14u w=0.74u l=0.13u
X313 VGND VPWR VGND VGND sg13_lv_nmos ad=0.1428p pd=1.52u as=0 ps=0 w=0.42u l=1u
X314 VGND VPWR VGND VGND sg13_lv_nmos ad=0.1428p pd=1.52u as=0 ps=0 w=0.42u l=1u
X315 a_3014_5850# _244_.D VPWR VPWR sg13_lv_pmos ad=79.8f pd=0.8u as=0.1428p ps=1.52u w=0.42u l=0.13u
X316 VPWR a_3695_9263# a_4362_9484# VPWR sg13_lv_pmos ad=0.2128p pd=1.5u as=0.3864p ps=2.93u w=1.12u l=0.13u
X317 VPWR VGND VPWR VPWR sg13_lv_pmos ad=0.19p pd=1.38u as=0 ps=0 w=1u l=1u
X318 a_7451_14484# _191_.Y _202_.Y VPWR sg13_lv_pmos ad=0.2128p pd=1.5u as=0.3808p ps=2.92u w=1.12u l=0.13u
X319 a_14698_5380# a_15141_5423# a_15081_5459# VPWR sg13_lv_pmos ad=79.8f pd=0.8u as=63f ps=0.72u w=0.42u l=0.13u
X320 VGND _225_.A _228_.Y VGND sg13_lv_nmos ad=0.2516p pd=2.16u as=0.2516p ps=2.16u w=0.74u l=0.13u
X321 VGND VPWR VGND VGND sg13_lv_nmos ad=0.1428p pd=1.52u as=0 ps=0 w=0.42u l=1u
X322 _143_.A _210_.A VPWR VPWR sg13_lv_pmos ad=0.2128p pd=1.5u as=0.2198p ps=1.53u w=1.12u l=0.13u
X323 VPWR VGND VPWR VPWR sg13_lv_pmos ad=0.34p pd=2.68u as=0 ps=0 w=1u l=1u
X324 a_2244_12528# a_2763_12332# a_3503_12287# VGND sg13_lv_nmos ad=0.3473p pd=2.71u as=0.12665p ps=1.145u w=0.74u l=0.13u
X325 a_9167_16357# a_8325_16007# a_7908_16000# VPWR sg13_lv_pmos ad=0.2048p pd=1.63u as=0.34p ps=2.68u w=1u l=0.13u
X326 a_9765_4629# _251_.CLK a_10225_4946# VPWR sg13_lv_pmos ad=0.4088p pd=2.97u as=0.41165p ps=2.12u w=1.12u l=0.13u
X327 a_8044_4965# a_7984_4870# a_7929_4965# VPWR sg13_lv_pmos ad=0.204p pd=1.835u as=93.45f ps=0.865u w=0.42u l=0.13u
X328 a_10938_5412# _139_.X _144_.B VPWR sg13_lv_pmos ad=0.1428p pd=1.375u as=0.2408p ps=1.55u w=1.12u l=0.13u
X329 _184_.Y _173_.Y a_7064_9194# VGND sg13_lv_nmos ad=0.2516p pd=2.16u as=0.1406p ps=1.12u w=0.74u l=0.13u
X330 VPWR _241_.Y a_11338_16969# VPWR sg13_lv_pmos ad=0.1563p pd=1.22u as=0.147p ps=1.54u w=0.42u l=0.13u
X331 VGND VPWR VGND VGND sg13_lv_nmos ad=79.8f pd=0.8u as=0 ps=0 w=0.42u l=1u
X332 a_15108_11885# a_14820_11464# a_15046_11885# VGND sg13_lv_nmos ad=0.1428p pd=1.52u as=37.8f ps=0.6u w=0.42u l=0.13u
X333 VGND VPWR VGND VGND sg13_lv_nmos ad=0.1428p pd=1.52u as=0 ps=0 w=0.42u l=1u
X334 VPWR VGND VPWR VPWR sg13_lv_pmos ad=0.19p pd=1.38u as=0 ps=0 w=1u l=1u
X335 VPWR VGND VPWR VPWR sg13_lv_pmos ad=0.19p pd=1.38u as=0 ps=0 w=1u l=1u
X336 VPWR VGND VPWR VPWR sg13_lv_pmos ad=0.34p pd=2.68u as=0 ps=0 w=1u l=1u
X337 VGND _210_.A a_6516_4248# VGND sg13_lv_nmos ad=0.2272p pd=1.99u as=78.39999f ps=0.885u w=0.64u l=0.13u
X338 VPWR VGND VPWR VPWR sg13_lv_pmos ad=0.19p pd=1.38u as=0 ps=0 w=1u l=1u
X339 VGND VPWR VGND VGND sg13_lv_nmos ad=79.8f pd=0.8u as=0 ps=0 w=0.42u l=1u
X340 VGND VPWR VGND VGND sg13_lv_nmos ad=0.1428p pd=1.52u as=0 ps=0 w=0.42u l=1u
X341 VPWR VGND VPWR VPWR sg13_lv_pmos ad=0.19p pd=1.38u as=0 ps=0 w=1u l=1u
X342 a_9156_12528# a_9130_12433# VGND VGND sg13_lv_nmos ad=0.2516p pd=2.16u as=0.1626p ps=1.415u w=0.74u l=0.13u
X343 a_2410_8404# a_2853_8447# a_2150_8874# VGND sg13_lv_nmos ad=79.8f pd=0.8u as=0.1296p ps=1.52u w=0.42u l=0.13u
X344 a_14628_15247# a_14859_15356# a_14314_15457# VGND sg13_lv_nmos ad=0.2373p pd=1.97u as=79.8f ps=0.8u w=0.42u l=0.13u
X345 VGND VPWR VGND VGND sg13_lv_nmos ad=79.8f pd=0.8u as=0 ps=0 w=0.42u l=1u
X346 VPWR _234_.Y a_12106_12433# VPWR sg13_lv_pmos ad=0.1563p pd=1.22u as=0.147p ps=1.54u w=0.42u l=0.13u
X347 a_3724_16119# a_3664_16238# a_3609_16119# VPWR sg13_lv_pmos ad=0.204p pd=1.835u as=93.45f ps=0.865u w=0.42u l=0.13u
X348 _247_.CLK a_3380_13690# VPWR VPWR sg13_lv_pmos ad=0.2128p pd=1.5u as=0.2128p ps=1.5u w=1.12u l=0.13u
X349 a_3274_4873# a_3717_4629# a_3657_5041# VPWR sg13_lv_pmos ad=79.8f pd=0.8u as=63f ps=0.72u w=0.42u l=0.13u
X350 VPWR _178_.B1 a_6124_9945# VPWR sg13_lv_pmos ad=0.36195p pd=1.84u as=0.1596p ps=1.22u w=0.84u l=0.13u
X351 _148_.X _148_.B a_12666_4666# VGND sg13_lv_nmos ad=0.1628p pd=1.18u as=88.8f ps=0.98u w=0.74u l=0.13u
X352 VPWR VGND VPWR VPWR sg13_lv_pmos ad=0.34p pd=2.68u as=0 ps=0 w=1u l=1u
X353 VPWR VGND VPWR VPWR sg13_lv_pmos ad=0.19p pd=1.38u as=0 ps=0 w=1u l=1u
X354 _235_.Y _236_.A VGND VGND sg13_lv_nmos ad=0.2516p pd=2.16u as=0.2516p ps=2.16u w=0.74u l=0.13u
X355 VPWR VGND VPWR VPWR sg13_lv_pmos ad=0.34p pd=2.68u as=0 ps=0 w=1u l=1u
X356 a_3664_13214# _221_.Y a_3724_13095# VPWR sg13_lv_pmos ad=79.8f pd=0.8u as=0.204p ps=1.835u w=0.42u l=0.13u
X357 a_15599_15311# a_14757_15213# a_14340_15552# VPWR sg13_lv_pmos ad=0.2048p pd=1.63u as=0.34p ps=2.68u w=1u l=0.13u
X358 a_8146_4650# _224_.Y VGND VGND sg13_lv_nmos ad=37.8f pd=0.6u as=79.8f ps=0.8u w=0.42u l=0.13u
X359 VGND _136_.A a_6810_3863# VGND sg13_lv_nmos ad=0.374p pd=2.46u as=0.17462p ps=1.185u w=0.55u l=0.13u
X360 VGND VPWR VGND VGND sg13_lv_nmos ad=0.1428p pd=1.52u as=0 ps=0 w=0.42u l=1u
X361 a_6771_8436# _168_.A VPWR VPWR sg13_lv_pmos ad=0.1428p pd=1.375u as=0.2891p ps=1.695u w=1.12u l=0.13u
X362 VPWR VGND VPWR VPWR sg13_lv_pmos ad=0.19p pd=1.38u as=0 ps=0 w=1u l=1u
X363 a_13527_11460# _133_.B a_13413_11460# VPWR sg13_lv_pmos ad=0.2128p pd=1.5u as=0.2464p ps=1.56u w=1.12u l=0.13u
X364 a_9169_17042# a_8709_16725# a_8811_16868# VPWR sg13_lv_pmos ad=0.41165p pd=2.12u as=0.3864p ps=2.93u w=1.12u l=0.13u
X365 a_15856_15454# a_15599_15311# a_16018_15234# VGND sg13_lv_nmos ad=0.1428p pd=1.52u as=37.8f ps=0.6u w=0.42u l=0.13u
X366 a_15767_17137# _238_.Y VPWR VPWR sg13_lv_pmos ad=79.8f pd=0.8u as=0.36237p ps=2.605u w=0.42u l=0.13u
X367 a_10799_5782# _147_.A1 VGND VGND sg13_lv_nmos ad=0.2516p pd=2.16u as=0.1898p ps=1.36u w=0.74u l=0.13u
X368 VGND _138_.Y a_8538_5375# VGND sg13_lv_nmos ad=0.374p pd=2.46u as=0.17462p ps=1.185u w=0.55u l=0.13u
X369 VGND a_3886_10702# clkbuf_1_0__f_sclk.A VGND sg13_lv_nmos ad=0.1406p pd=1.12u as=0.1406p ps=1.12u w=0.74u l=0.13u
X370 VGND VPWR VGND VGND sg13_lv_nmos ad=79.8f pd=0.8u as=0 ps=0 w=0.42u l=1u
X371 a_8021_5782# _145_.A2 VGND VGND sg13_lv_nmos ad=0.1406p pd=1.12u as=0.1898p ps=1.36u w=0.74u l=0.13u
X372 VPWR VGND VPWR VPWR sg13_lv_pmos ad=0.34p pd=2.68u as=0 ps=0 w=1u l=1u
X373 VGND VPWR VGND VGND sg13_lv_nmos ad=79.8f pd=0.8u as=0 ps=0 w=0.42u l=1u
X374 VGND VPWR VGND VGND sg13_lv_nmos ad=79.8f pd=0.8u as=0 ps=0 w=0.42u l=1u
X375 a_9574_4663# _225_.Y VGND VGND sg13_lv_nmos ad=37.8f pd=0.6u as=0.1701p ps=1.65u w=0.42u l=0.13u
X376 a_12572_4948# _148_.B VPWR VPWR sg13_lv_pmos ad=0.2128p pd=1.5u as=0.2128p ps=1.5u w=1.12u l=0.13u
X377 VPWR _243_.Q a_10940_3900# VPWR sg13_lv_pmos ad=0.2128p pd=1.5u as=0.3808p ps=2.92u w=1.12u l=0.13u
X378 VGND VPWR VGND VGND sg13_lv_nmos ad=79.8f pd=0.8u as=0 ps=0 w=0.42u l=1u
X379 VPWR VGND VPWR VPWR sg13_lv_pmos ad=0.34p pd=2.68u as=0 ps=0 w=1u l=1u
X380 VGND VPWR VGND VGND sg13_lv_nmos ad=79.8f pd=0.8u as=0 ps=0 w=0.42u l=1u
X381 a_8292_17064# a_8811_16868# a_9551_16823# VGND sg13_lv_nmos ad=0.3473p pd=2.71u as=0.12665p ps=1.145u w=0.74u l=0.13u
X382 VPWR a_14063_16357# a_14320_16238# VPWR sg13_lv_pmos ad=0.4659p pd=3.65u as=79.8f ps=0.8u w=0.42u l=0.13u
X383 a_16402_12210# _235_.Y VGND VGND sg13_lv_nmos ad=37.8f pd=0.6u as=79.8f ps=0.8u w=0.42u l=0.13u
X384 a_12652_6924# _162_.B _162_.Y VPWR sg13_lv_pmos ad=0.1176p pd=1.33u as=0.3808p ps=2.92u w=1.12u l=0.13u
X385 _185_.Y _178_.Y a_7157_9948# VPWR sg13_lv_pmos ad=0.3808p pd=2.92u as=0.2128p ps=1.5u w=1.12u l=0.13u
X386 a_4913_13330# _148_.B a_4881_12972# VPWR sg13_lv_pmos ad=0.34p pd=2.68u as=0.1225p ps=1.245u w=1u l=0.13u
X387 VGND VPWR VGND VGND sg13_lv_nmos ad=0.1428p pd=1.52u as=0 ps=0 w=0.42u l=1u
X388 VPWR VGND VPWR VPWR sg13_lv_pmos ad=0.34p pd=2.68u as=0 ps=0 w=1u l=1u
X389 VGND _215_.A _221_.Y VGND sg13_lv_nmos ad=0.2516p pd=2.16u as=0.2516p ps=2.16u w=0.74u l=0.13u
X390 a_14534_9186# a_15339_9308# a_14794_9409# VPWR sg13_lv_pmos ad=0.1428p pd=1.52u as=79.8f ps=0.8u w=0.42u l=0.13u
X391 a_2148_17064# a_2122_16969# VPWR VPWR sg13_lv_pmos ad=0.34p pd=2.68u as=0.36237p ps=2.605u w=1u l=0.13u
X392 a_3956_6888# clkbuf_1_0__f_sclk.A VPWR VPWR sg13_lv_pmos ad=0.2128p pd=1.5u as=0.2128p ps=1.5u w=1.12u l=0.13u
X393 VGND _136_.A a_7985_7728# VGND sg13_lv_nmos ad=0.15245p pd=1.17u as=0.17462p ps=1.185u w=0.55u l=0.13u
X394 a_2436_8440# a_2410_8404# VGND VGND sg13_lv_nmos ad=0.2516p pd=2.16u as=0.1626p ps=1.415u w=0.74u l=0.13u
X395 VPWR a_3886_10702# clkbuf_1_0__f_sclk.A VPWR sg13_lv_pmos ad=0.2128p pd=1.5u as=0.2128p ps=1.5u w=1.12u l=0.13u
X396 VGND VPWR VGND VGND sg13_lv_nmos ad=0.1428p pd=1.52u as=0 ps=0 w=0.42u l=1u
X397 a_4978_4650# _215_.Y VGND VGND sg13_lv_nmos ad=37.8f pd=0.6u as=79.8f ps=0.8u w=0.42u l=0.13u
X398 VGND a_3886_10702# clkbuf_1_0__f_sclk.A VGND sg13_lv_nmos ad=0.1406p pd=1.12u as=0.1406p ps=1.12u w=0.74u l=0.13u
X399 VPWR VGND VPWR VPWR sg13_lv_pmos ad=0.19p pd=1.38u as=0 ps=0 w=1u l=1u
X400 VGND a_14063_16357# a_14730_15996# VGND sg13_lv_nmos ad=0.1406p pd=1.12u as=0.2516p ps=2.16u w=0.74u l=0.13u
X401 a_6106_13726# _189_.X VGND VGND sg13_lv_nmos ad=0.1406p pd=1.12u as=0.2516p ps=2.16u w=0.74u l=0.13u
X402 VGND _148_.B a_12401_4704# VGND sg13_lv_nmos ad=0.15245p pd=1.17u as=0.17462p ps=1.185u w=0.55u l=0.13u
X403 VPWR _154_.X a_10752_7989# VPWR sg13_lv_pmos ad=0.2891p pd=1.695u as=0.1596p ps=1.22u w=0.84u l=0.13u
X404 VGND VPWR VGND VGND sg13_lv_nmos ad=79.8f pd=0.8u as=0 ps=0 w=0.42u l=1u
X405 _174_.Y _168_.A a_6106_9190# VGND sg13_lv_nmos ad=0.2516p pd=2.16u as=0.1406p ps=1.12u w=0.74u l=0.13u
X406 VGND VPWR VGND VGND sg13_lv_nmos ad=0.1428p pd=1.52u as=0 ps=0 w=0.42u l=1u
X407 _129_.Y _129_.B1 VGND VGND sg13_lv_nmos ad=0.1406p pd=1.12u as=0.2516p ps=2.16u w=0.74u l=0.13u
X408 a_2148_16000# a_2122_15964# VGND VGND sg13_lv_nmos ad=0.2516p pd=2.16u as=0.1626p ps=1.415u w=0.74u l=0.13u
X409 VGND _124_.S a_2620_13726# VGND sg13_lv_nmos ad=0.18945p pd=1.27u as=0.13135p ps=1.095u w=0.74u l=0.13u
X410 VGND VPWR VGND VGND sg13_lv_nmos ad=79.8f pd=0.8u as=0 ps=0 w=0.42u l=1u
X411 VGND VPWR VGND VGND sg13_lv_nmos ad=79.8f pd=0.8u as=0 ps=0 w=0.42u l=1u
X412 a_9484_16119# a_9424_16238# a_9369_16119# VPWR sg13_lv_pmos ad=0.204p pd=1.835u as=93.45f ps=0.865u w=0.42u l=0.13u
X413 a_15916_15549# a_15856_15454# a_15801_15549# VPWR sg13_lv_pmos ad=0.204p pd=1.835u as=93.45f ps=0.865u w=0.42u l=0.13u
X414 a_15177_11507# a_14820_11464# VPWR VPWR sg13_lv_pmos ad=63f pd=0.72u as=0.1563p ps=1.22u w=0.42u l=0.13u
X415 a_3952_8678# _218_.Y a_4012_8559# VPWR sg13_lv_pmos ad=79.8f pd=0.8u as=0.204p ps=1.835u w=0.42u l=0.13u
X416 VPWR VGND VPWR VPWR sg13_lv_pmos ad=0.34p pd=2.68u as=0 ps=0 w=1u l=1u
X417 VGND VPWR VGND VGND sg13_lv_nmos ad=79.8f pd=0.8u as=0 ps=0 w=0.42u l=1u
X418 a_3724_17061# a_3664_16966# a_3609_17061# VPWR sg13_lv_pmos ad=0.204p pd=1.835u as=93.45f ps=0.865u w=0.42u l=0.13u
X419 VGND _238_.Y a_14666_16746# VGND sg13_lv_nmos ad=79.8f pd=0.8u as=37.8f ps=0.6u w=0.42u l=0.13u
X420 VGND VPWR VGND VGND sg13_lv_nmos ad=0.1428p pd=1.52u as=0 ps=0 w=0.42u l=1u
X421 a_2126_7864# _122_.A0 a_2298_7678# VGND sg13_lv_nmos ad=0.1628p pd=1.18u as=0.3367p ps=1.65u w=0.74u l=0.13u
X422 a_9551_16823# a_8709_16725# a_9457_16823# VGND sg13_lv_nmos ad=0.12665p pd=1.145u as=0.1428p ps=1.52u w=0.42u l=0.13u
X423 VPWR _136_.A a_11661_4696# VPWR sg13_lv_pmos ad=0.1918p pd=1.5u as=0.1596p ps=1.22u w=0.84u l=0.13u
X424 VGND VPWR VGND VGND sg13_lv_nmos ad=0.1428p pd=1.52u as=0 ps=0 w=0.42u l=1u
X425 VPWR a_3886_10702# clkbuf_1_0__f_sclk.A VPWR sg13_lv_pmos ad=0.2128p pd=1.5u as=0.2128p ps=1.5u w=1.12u l=0.13u
X426 VPWR VGND VPWR VPWR sg13_lv_pmos ad=0.34p pd=2.68u as=0 ps=0 w=1u l=1u
X427 VPWR a_13100_13686# _148_.B VPWR sg13_lv_pmos ad=0.2114p pd=1.54u as=0.42p ps=2.99u w=1.12u l=0.13u
X428 VPWR VGND VPWR VPWR sg13_lv_pmos ad=0.34p pd=2.68u as=0 ps=0 w=1u l=1u
X429 VGND sclk a_3886_10702# VGND sg13_lv_nmos ad=0.1406p pd=1.12u as=0.1406p ps=1.12u w=0.74u l=0.13u
X430 VGND VPWR VGND VGND sg13_lv_nmos ad=79.8f pd=0.8u as=0 ps=0 w=0.42u l=1u
X431 VPWR VGND VPWR VPWR sg13_lv_pmos ad=0.19p pd=1.38u as=0 ps=0 w=1u l=1u
X432 a_13073_5770# _157_.B a_13041_5412# VPWR sg13_lv_pmos ad=0.34p pd=2.68u as=0.1225p ps=1.245u w=1u l=0.13u
X433 _235_.Y _236_.A VPWR VPWR sg13_lv_pmos ad=0.3808p pd=2.92u as=0.3808p ps=2.92u w=1.12u l=0.13u
X434 a_9808_16966# _232_.Y a_9868_17061# VPWR sg13_lv_pmos ad=79.8f pd=0.8u as=0.204p ps=1.835u w=0.42u l=0.13u
X435 VPWR VGND VPWR VPWR sg13_lv_pmos ad=0.34p pd=2.68u as=0 ps=0 w=1u l=1u
X436 a_2793_9577# a_2436_9504# VPWR VPWR sg13_lv_pmos ad=63f pd=0.72u as=0.1563p ps=1.22u w=0.42u l=0.13u
X437 VPWR _145_.A2 a_8386_3900# VPWR sg13_lv_pmos ad=0.19p pd=1.38u as=0.34p ps=2.68u w=1u l=0.13u
X438 VGND VPWR VGND VGND sg13_lv_nmos ad=0.1428p pd=1.52u as=0 ps=0 w=0.42u l=1u
X439 a_10415_13799# a_9573_13701# a_10321_13799# VGND sg13_lv_nmos ad=0.12665p pd=1.145u as=0.1428p ps=1.52u w=0.42u l=0.13u
X440 a_4144_4142# a_3887_4261# a_4306_4338# VGND sg13_lv_nmos ad=0.1428p pd=1.52u as=37.8f ps=0.6u w=0.42u l=0.13u
X441 VPWR VGND VPWR VPWR sg13_lv_pmos ad=0.19p pd=1.38u as=0 ps=0 w=1u l=1u
X442 VGND _192_.B a_6881_13320# VGND sg13_lv_nmos ad=0.2516p pd=2.16u as=0.1406p ps=1.12u w=0.74u l=0.13u
X443 VGND a_13073_5770# _151_.B VGND sg13_lv_nmos ad=0.3108p pd=2.32u as=0.1628p ps=1.18u w=0.74u l=0.13u
X444 VGND VPWR VGND VGND sg13_lv_nmos ad=79.8f pd=0.8u as=0 ps=0 w=0.42u l=1u
X445 a_14628_15247# a_14340_15552# a_14566_15247# VGND sg13_lv_nmos ad=0.1428p pd=1.52u as=37.8f ps=0.6u w=0.42u l=0.13u
X446 VGND VPWR VGND VGND sg13_lv_nmos ad=79.8f pd=0.8u as=0 ps=0 w=0.42u l=1u
X447 a_6468_4968# a_6442_4873# VGND VGND sg13_lv_nmos ad=0.2516p pd=2.16u as=0.1626p ps=1.415u w=0.74u l=0.13u
X448 a_2150_8874# a_2955_8447# a_2410_8404# VPWR sg13_lv_pmos ad=0.1428p pd=1.52u as=79.8f ps=0.8u w=0.42u l=0.13u
X449 a_3695_9263# a_2853_9165# a_2436_9504# VPWR sg13_lv_pmos ad=0.2048p pd=1.63u as=0.34p ps=2.68u w=1u l=0.13u
X450 a_8156_9928# _183_.Y _186_.Y VPWR sg13_lv_pmos ad=0.2128p pd=1.5u as=0.2128p ps=1.5u w=1.12u l=0.15u
X451 a_15983_5773# a_15141_5423# a_14724_5416# VPWR sg13_lv_pmos ad=0.2048p pd=1.63u as=0.34p ps=2.68u w=1u l=0.13u
X452 VPWR sclk a_3886_10702# VPWR sg13_lv_pmos ad=0.2128p pd=1.5u as=0.2128p ps=1.5u w=1.12u l=0.13u
X453 VGND VPWR VGND VGND sg13_lv_nmos ad=0.1428p pd=1.52u as=0 ps=0 w=0.42u l=1u
X454 _210_.A a_5226_4948# VPWR VPWR sg13_lv_pmos ad=0.3808p pd=2.92u as=0.2128p ps=1.5u w=1.12u l=0.13u
X455 _151_.X a_13649_4704# a_13820_4948# VPWR sg13_lv_pmos ad=0.3808p pd=2.92u as=0.2128p ps=1.5u w=1.12u l=0.13u
X456 VGND VPWR VGND VGND sg13_lv_nmos ad=79.8f pd=0.8u as=0 ps=0 w=0.42u l=1u
X457 a_2232_13916# _124_.S VGND VGND sg13_lv_nmos ad=0.187p pd=1.78u as=0.18945p ps=1.27u w=0.55u l=0.13u
X458 VPWR VGND VPWR VPWR sg13_lv_pmos ad=0.34p pd=2.68u as=0 ps=0 w=1u l=1u
X459 VGND VPWR VGND VGND sg13_lv_nmos ad=0.1428p pd=1.52u as=0 ps=0 w=0.42u l=1u
X460 VGND a_2126_10214# _246_.D VGND sg13_lv_nmos ad=0.148p pd=1.14u as=0.4033p ps=2.57u w=0.74u l=0.13u
X461 VPWR _131_.A2 a_13883_11460# VPWR sg13_lv_pmos ad=0.2128p pd=1.5u as=0.2128p ps=1.5u w=1.12u l=0.13u
X462 VPWR VGND VPWR VPWR sg13_lv_pmos ad=0.19p pd=1.38u as=0 ps=0 w=1u l=1u
X463 a_7008_16035# _201_.Y VPWR VPWR sg13_lv_pmos ad=0.1596p pd=1.22u as=0.4536p ps=2.76u w=0.84u l=0.13u
X464 VGND VPWR VGND VGND sg13_lv_nmos ad=79.8f pd=0.8u as=0 ps=0 w=0.42u l=1u
X465 VGND VPWR VGND VGND sg13_lv_nmos ad=79.8f pd=0.8u as=0 ps=0 w=0.42u l=1u
X466 a_2218_12433# a_2661_12189# a_2601_12601# VPWR sg13_lv_pmos ad=79.8f pd=0.8u as=63f ps=0.72u w=0.42u l=0.13u
X467 a_14950_12223# _235_.Y VGND VGND sg13_lv_nmos ad=37.8f pd=0.6u as=0.1701p ps=1.65u w=0.42u l=0.13u
X468 VPWR a_3956_6888# _243_.CLK VPWR sg13_lv_pmos ad=0.2128p pd=1.5u as=0.2128p ps=1.5u w=1.12u l=0.13u
X469 VGND VPWR VGND VGND sg13_lv_nmos ad=0.1428p pd=1.52u as=0 ps=0 w=0.42u l=1u
X470 a_7716_16434# _203_.Y a_7622_16434# VGND sg13_lv_nmos ad=60.89999f pd=0.71u as=0.1428p ps=1.52u w=0.42u l=0.13u
X471 a_3897_9501# a_2955_9308# a_3695_9263# VPWR sg13_lv_pmos ad=93.45f pd=0.865u as=0.2048p ps=1.63u w=0.42u l=0.13u
X472 VPWR VGND VPWR VPWR sg13_lv_pmos ad=0.19p pd=1.38u as=0 ps=0 w=1u l=1u
X473 VPWR _170_.B _170_.Y VPWR sg13_lv_pmos ad=0.2128p pd=1.5u as=0.2128p ps=1.5u w=1.12u l=0.13u
X474 a_7835_5760# _143_.A VGND VGND sg13_lv_nmos ad=78.39999f pd=0.885u as=0.2272p ps=1.99u w=0.64u l=0.13u
X475 VPWR a_8352_11013# _182_.Y VPWR sg13_lv_pmos ad=0.3808p pd=2.92u as=0.2408p ps=1.55u w=1.12u l=0.13u
X476 a_8580_16759# a_8292_17064# a_8518_16759# VGND sg13_lv_nmos ad=0.1428p pd=1.52u as=37.8f ps=0.6u w=0.42u l=0.13u
X477 VGND VPWR VGND VGND sg13_lv_nmos ad=79.8f pd=0.8u as=0 ps=0 w=0.42u l=1u
X478 VGND VPWR VGND VGND sg13_lv_nmos ad=79.8f pd=0.8u as=0 ps=0 w=0.42u l=1u
X479 a_2244_9186# _246_.D a_2150_9186# VGND sg13_lv_nmos ad=60.89999f pd=0.71u as=0.1428p ps=1.52u w=0.42u l=0.13u
X480 VGND VPWR VGND VGND sg13_lv_nmos ad=79.8f pd=0.8u as=0 ps=0 w=0.42u l=1u
X481 a_4684_15996# a_4462_16052# VPWR VPWR sg13_lv_pmos ad=0.1176p pd=1.33u as=0.2618p ps=1.63u w=1.12u l=0.13u
X482 VGND a_12880_16966# a_12529_16823# VGND sg13_lv_nmos ad=79.8f pd=0.8u as=0.1428p ps=1.52u w=0.42u l=0.13u
X483 VPWR VGND VPWR VPWR sg13_lv_pmos ad=0.19p pd=1.38u as=0 ps=0 w=1u l=1u
X484 VPWR VGND VPWR VPWR sg13_lv_pmos ad=0.19p pd=1.38u as=0 ps=0 w=1u l=1u
X485 a_11781_16725# _214_.A a_12241_16767# VGND sg13_lv_nmos ad=0.2516p pd=2.16u as=0.31732p ps=1.805u w=0.74u l=0.13u
X486 a_8156_7972# _136_.A VPWR VPWR sg13_lv_pmos ad=0.2128p pd=1.5u as=0.2128p ps=1.5u w=1.12u l=0.13u
X487 VGND VPWR VGND VGND sg13_lv_nmos ad=0.1428p pd=1.52u as=0 ps=0 w=0.42u l=1u
X488 a_6442_4873# a_6885_4629# a_6182_4650# VGND sg13_lv_nmos ad=79.8f pd=0.8u as=0.1296p ps=1.52u w=0.42u l=0.13u
X489 a_15697_8438# a_15237_8447# a_15339_8447# VPWR sg13_lv_pmos ad=0.41165p pd=2.12u as=0.3864p ps=2.93u w=1.12u l=0.13u
X490 VGND VPWR VGND VGND sg13_lv_nmos ad=79.8f pd=0.8u as=0 ps=0 w=0.42u l=1u
X491 VPWR VGND VPWR VPWR sg13_lv_pmos ad=0.19p pd=1.38u as=0 ps=0 w=1u l=1u
X492 _260_.RESET_B _225_.A VGND VGND sg13_lv_nmos ad=0.2516p pd=2.16u as=0.2516p ps=2.16u w=0.74u l=0.13u
X493 a_6276_4650# _210_.Y a_6182_4650# VGND sg13_lv_nmos ad=60.89999f pd=0.71u as=0.1428p ps=1.52u w=0.42u l=0.13u
X494 VPWR _148_.B a_12237_5760# VPWR sg13_lv_pmos ad=0.1918p pd=1.5u as=0.1596p ps=1.22u w=0.84u l=0.13u
X495 VPWR _124_.S a_2558_7972# VPWR sg13_lv_pmos ad=0.253p pd=1.53u as=0.3325p ps=1.665u w=1u l=0.13u
X496 _247_.CLK a_3380_13690# VPWR VPWR sg13_lv_pmos ad=0.2128p pd=1.5u as=0.2128p ps=1.5u w=1.12u l=0.13u
X497 _144_.B a_10764_5678# VPWR VPWR sg13_lv_pmos ad=0.2408p pd=1.55u as=0.3808p ps=2.92u w=1.12u l=0.13u
X498 a_2565_16007# _247_.CLK a_3025_16349# VGND sg13_lv_nmos ad=0.2516p pd=2.16u as=0.31732p ps=1.805u w=0.74u l=0.13u
X499 a_9573_13701# fanout7.A a_10033_14018# VPWR sg13_lv_pmos ad=0.4088p pd=2.97u as=0.41165p ps=2.12u w=1.12u l=0.13u
X500 VGND VPWR VGND VGND sg13_lv_nmos ad=0.1428p pd=1.52u as=0 ps=0 w=0.42u l=1u
X501 VPWR VGND VPWR VPWR sg13_lv_pmos ad=0.34p pd=2.68u as=0 ps=0 w=1u l=1u
X502 VGND VPWR VGND VGND sg13_lv_nmos ad=79.8f pd=0.8u as=0 ps=0 w=0.42u l=1u
X503 a_10020_17512# a_9994_17476# VGND VGND sg13_lv_nmos ad=0.2516p pd=2.16u as=0.1626p ps=1.415u w=0.74u l=0.13u
X504 VPWR VGND VPWR VPWR sg13_lv_pmos ad=0.34p pd=2.68u as=0 ps=0 w=1u l=1u
X505 VGND VPWR VGND VGND sg13_lv_nmos ad=79.8f pd=0.8u as=0 ps=0 w=0.42u l=1u
X506 _264_.Q a_14730_15996# VPWR VPWR sg13_lv_pmos ad=0.3808p pd=2.92u as=0.2128p ps=1.5u w=1.12u l=0.13u
X507 VPWR VGND VPWR VPWR sg13_lv_pmos ad=0.19p pd=1.38u as=0 ps=0 w=1u l=1u
X508 a_15046_11885# _236_.Y VGND VGND sg13_lv_nmos ad=37.8f pd=0.6u as=0.1701p ps=1.65u w=0.42u l=0.13u
X509 a_11364_17064# a_11338_16969# VGND VGND sg13_lv_nmos ad=0.2516p pd=2.16u as=0.1626p ps=1.415u w=0.74u l=0.13u
X510 VPWR _224_.Y a_6442_4873# VPWR sg13_lv_pmos ad=0.1563p pd=1.22u as=0.147p ps=1.54u w=0.42u l=0.13u
X511 a_7345_4946# a_6885_4629# a_6987_4772# VPWR sg13_lv_pmos ad=0.41165p pd=2.12u as=0.3864p ps=2.93u w=1.12u l=0.13u
X512 VPWR _235_.Y a_14698_12433# VPWR sg13_lv_pmos ad=0.1563p pd=1.22u as=0.147p ps=1.54u w=0.42u l=0.13u
X513 VGND _240_.Y a_9828_17946# VGND sg13_lv_nmos ad=0.1626p pd=1.415u as=60.89999f ps=0.71u w=0.42u l=0.13u
X514 _247_.CLK a_3380_13690# VGND VGND sg13_lv_nmos ad=0.1406p pd=1.12u as=0.1406p ps=1.12u w=0.74u l=0.13u
X515 a_10020_9504# a_10539_9308# a_11279_9263# VGND sg13_lv_nmos ad=0.3473p pd=2.71u as=0.12665p ps=1.145u w=0.74u l=0.13u
X516 VPWR VGND VPWR VPWR sg13_lv_pmos ad=0.19p pd=1.38u as=0 ps=0 w=1u l=1u
X517 a_2232_13916# _124_.S VPWR VPWR sg13_lv_pmos ad=0.2856p pd=2.36u as=0.253p ps=1.53u w=0.84u l=0.13u
X518 a_13184_7183# _160_.B VPWR VPWR sg13_lv_pmos ad=0.1596p pd=1.22u as=0.1918p ps=1.5u w=0.84u l=0.13u
X519 VGND VPWR VGND VGND sg13_lv_nmos ad=0.1428p pd=1.52u as=0 ps=0 w=0.42u l=1u
X520 a_10437_9165# _251_.CLK a_10897_9482# VPWR sg13_lv_pmos ad=0.4088p pd=2.97u as=0.41165p ps=2.12u w=1.12u l=0.13u
X521 VGND VPWR VGND VGND sg13_lv_nmos ad=0.1428p pd=1.52u as=0 ps=0 w=0.42u l=1u
X522 VGND _210_.B a_6095_4270# VGND sg13_lv_nmos ad=0.1898p pd=1.36u as=0.1406p ps=1.12u w=0.74u l=0.13u
X523 a_2620_15238# _119_.A0 a_2126_15424# VGND sg13_lv_nmos ad=0.13135p pd=1.095u as=0.1628p ps=1.18u w=0.74u l=0.13u
X524 VGND VPWR VGND VGND sg13_lv_nmos ad=0.1428p pd=1.52u as=0 ps=0 w=0.42u l=1u
X525 VGND VPWR VGND VGND sg13_lv_nmos ad=0.1428p pd=1.52u as=0 ps=0 w=0.42u l=1u
X526 VPWR VGND VPWR VPWR sg13_lv_pmos ad=0.34p pd=2.68u as=0 ps=0 w=1u l=1u
X527 VGND VPWR VGND VGND sg13_lv_nmos ad=79.8f pd=0.8u as=0 ps=0 w=0.42u l=1u
X528 VPWR a_3887_4261# a_4554_3900# VPWR sg13_lv_pmos ad=0.2128p pd=1.5u as=0.3864p ps=2.93u w=1.12u l=0.13u
X529 a_3407_16357# a_2565_16007# a_3313_16357# VGND sg13_lv_nmos ad=0.12665p pd=1.145u as=0.1428p ps=1.52u w=0.42u l=0.13u
X530 VGND VPWR VGND VGND sg13_lv_nmos ad=79.8f pd=0.8u as=0 ps=0 w=0.42u l=1u
X531 VPWR a_3380_13690# _247_.CLK VPWR sg13_lv_pmos ad=0.2128p pd=1.5u as=0.2128p ps=1.5u w=1.12u l=0.13u
X532 _225_.A a_9352_17508# VGND VGND sg13_lv_nmos ad=0.2886p pd=2.26u as=0.14875p ps=1.16u w=0.74u l=0.13u
X533 VGND VPWR VGND VGND sg13_lv_nmos ad=0.1428p pd=1.52u as=0 ps=0 w=0.42u l=1u
X534 VPWR VGND VPWR VPWR sg13_lv_pmos ad=0.34p pd=2.68u as=0 ps=0 w=1u l=1u
X535 VGND VPWR VGND VGND sg13_lv_nmos ad=0.1428p pd=1.52u as=0 ps=0 w=0.42u l=1u
X536 _147_.A1 a_11274_4948# VPWR VPWR sg13_lv_pmos ad=0.3808p pd=2.92u as=0.2128p ps=1.5u w=1.12u l=0.13u
X537 a_13130_4948# _147_.Y VPWR VPWR sg13_lv_pmos ad=0.1176p pd=1.33u as=0.4032p ps=2.96u w=1.12u l=0.13u
X538 a_2505_17137# a_2148_17064# VPWR VPWR sg13_lv_pmos ad=63f pd=0.72u as=0.1563p ps=1.22u w=0.42u l=0.13u
X539 VGND VPWR VGND VGND sg13_lv_nmos ad=0.1428p pd=1.52u as=0 ps=0 w=0.42u l=1u
X540 VGND VPWR VGND VGND sg13_lv_nmos ad=0.1428p pd=1.52u as=0 ps=0 w=0.42u l=1u
X541 VGND VPWR VGND VGND sg13_lv_nmos ad=79.8f pd=0.8u as=0 ps=0 w=0.42u l=1u
X542 VPWR VGND VPWR VPWR sg13_lv_pmos ad=0.34p pd=2.68u as=0 ps=0 w=1u l=1u
X543 VPWR a_3380_13690# _247_.CLK VPWR sg13_lv_pmos ad=0.2128p pd=1.5u as=0.2128p ps=1.5u w=1.12u l=0.13u
X544 VPWR VGND VPWR VPWR sg13_lv_pmos ad=0.19p pd=1.38u as=0 ps=0 w=1u l=1u
X545 VGND _148_.B a_12886_13350# VGND sg13_lv_nmos ad=0.1406p pd=1.12u as=0.2516p ps=2.16u w=0.74u l=0.15u
X546 VGND _148_.B a_8488_8436# VGND sg13_lv_nmos ad=0.14875p pd=1.16u as=0.187p ps=1.78u w=0.55u l=0.13u
X547 _126_.Y _126_.B1 VGND VGND sg13_lv_nmos ad=0.1406p pd=1.12u as=0.2516p ps=2.16u w=0.74u l=0.13u
X548 VGND VPWR VGND VGND sg13_lv_nmos ad=0.1428p pd=1.52u as=0 ps=0 w=0.42u l=1u
X549 VGND VPWR VGND VGND sg13_lv_nmos ad=79.8f pd=0.8u as=0 ps=0 w=0.42u l=1u
X550 a_2126_10214# _173_.A a_2298_10318# VGND sg13_lv_nmos ad=0.1628p pd=1.18u as=0.3367p ps=1.65u w=0.74u l=0.13u
X551 a_13810_12210# _234_.Y VGND VGND sg13_lv_nmos ad=37.8f pd=0.6u as=79.8f ps=0.8u w=0.42u l=0.13u
X552 VPWR _138_.Y a_8990_5412# VPWR sg13_lv_pmos ad=0.36p pd=2.72u as=0.1225p ps=1.245u w=1u l=0.13u
X553 a_6963_17044# _205_.Y VPWR VPWR sg13_lv_pmos ad=0.1428p pd=1.375u as=0.2891p ps=1.695u w=1.12u l=0.13u
X554 _144_.Y _138_.Y VGND VGND sg13_lv_nmos ad=0.1406p pd=1.12u as=0.2516p ps=2.16u w=0.74u l=0.13u
X555 a_9120_9501# _164_.Y VPWR VPWR sg13_lv_pmos ad=0.1596p pd=1.22u as=0.4536p ps=2.76u w=0.84u l=0.13u
X556 VGND VPWR VGND VGND sg13_lv_nmos ad=0.1428p pd=1.52u as=0 ps=0 w=0.42u l=1u
X557 VGND clkbuf_1_0__f_sclk.A a_3380_13690# VGND sg13_lv_nmos ad=0.1406p pd=1.12u as=0.1406p ps=1.12u w=0.74u l=0.13u
X558 a_2298_11484# a_2232_11722# VPWR VPWR sg13_lv_pmos ad=0.2975p pd=1.595u as=0.2198p ps=1.52u w=1u l=0.13u
X559 VPWR a_6528_8475# _168_.Y VPWR sg13_lv_pmos ad=0.3808p pd=2.92u as=0.2408p ps=1.55u w=1.12u l=0.13u
X560 a_7739_9484# _168_.Y _171_.A VPWR sg13_lv_pmos ad=0.2128p pd=1.5u as=0.3808p ps=2.92u w=1.12u l=0.13u
X561 _238_.Y _225_.A VGND VGND sg13_lv_nmos ad=0.2516p pd=2.16u as=0.2516p ps=2.16u w=0.74u l=0.13u
X562 a_9156_14040# a_9675_13844# a_10415_13799# VGND sg13_lv_nmos ad=0.3473p pd=2.71u as=0.12665p ps=1.145u w=0.74u l=0.13u
X563 VPWR VGND VPWR VPWR sg13_lv_pmos ad=0.19p pd=1.38u as=0 ps=0 w=1u l=1u
X564 a_14940_16710# a_15071_17016# a_14359_16710# VPWR sg13_lv_pmos ad=0.34p pd=2.68u as=0.2048p ps=1.63u w=1u l=0.13u
X565 VGND _244_.RESET_B a_3108_5850# VGND sg13_lv_nmos ad=0.1626p pd=1.415u as=60.89999f ps=0.71u w=0.42u l=0.13u
X566 a_14820_11464# a_14794_11428# VPWR VPWR sg13_lv_pmos ad=0.34p pd=2.68u as=0.36237p ps=2.605u w=1u l=0.13u
X567 VPWR VGND VPWR VPWR sg13_lv_pmos ad=0.34p pd=2.68u as=0 ps=0 w=1u l=1u
X568 a_14240_16921# a_14359_16710# VGND VGND sg13_lv_nmos ad=0.2516p pd=2.16u as=0.1406p ps=1.12u w=0.74u l=0.13u
X569 VPWR _187_.Y a_6779_12972# VPWR sg13_lv_pmos ad=0.2128p pd=1.5u as=0.2128p ps=1.5u w=1.12u l=0.13u
X570 VGND VPWR VGND VGND sg13_lv_nmos ad=79.8f pd=0.8u as=0 ps=0 w=0.42u l=1u
X571 a_3664_16238# a_3407_16357# a_3826_16434# VGND sg13_lv_nmos ad=0.1428p pd=1.52u as=37.8f ps=0.6u w=0.42u l=0.13u
X572 a_2470_12223# _220_.Y VGND VGND sg13_lv_nmos ad=37.8f pd=0.6u as=0.1701p ps=1.65u w=0.42u l=0.13u
X573 a_10864_4870# a_10607_4727# a_11026_4650# VGND sg13_lv_nmos ad=0.1428p pd=1.52u as=37.8f ps=0.6u w=0.42u l=0.13u
X574 VGND a_15980_7638# _251_.CLK VGND sg13_lv_nmos ad=0.14875p pd=1.16u as=0.2886p ps=2.26u w=0.74u l=0.13u
X575 a_11596_17631# a_11536_17750# a_11481_17631# VPWR sg13_lv_pmos ad=0.204p pd=1.835u as=93.45f ps=0.865u w=0.42u l=0.13u
X576 a_3407_16823# a_2565_16725# a_3313_16823# VGND sg13_lv_nmos ad=0.12665p pd=1.145u as=0.1428p ps=1.52u w=0.42u l=0.13u
X577 a_9167_16357# a_8325_16007# a_9073_16357# VGND sg13_lv_nmos ad=0.12665p pd=1.145u as=0.1428p ps=1.52u w=0.42u l=0.13u
X578 VPWR a_11279_17869# a_11946_17508# VPWR sg13_lv_pmos ad=0.2128p pd=1.5u as=0.3864p ps=2.93u w=1.12u l=0.13u
X579 a_9424_16238# _258_.RESET_B a_9484_16119# VPWR sg13_lv_pmos ad=79.8f pd=0.8u as=0.204p ps=1.835u w=0.42u l=0.13u
X580 VGND VPWR VGND VGND sg13_lv_nmos ad=79.8f pd=0.8u as=0 ps=0 w=0.42u l=1u
X581 VPWR VGND VPWR VPWR sg13_lv_pmos ad=0.19p pd=1.38u as=0 ps=0 w=1u l=1u
X582 VPWR VGND VPWR VPWR sg13_lv_pmos ad=0.19p pd=1.38u as=0 ps=0 w=1u l=1u
X583 VPWR VGND VPWR VPWR sg13_lv_pmos ad=0.19p pd=1.38u as=0 ps=0 w=1u l=1u
X584 VPWR VGND VPWR VPWR sg13_lv_pmos ad=0.34p pd=2.68u as=0 ps=0 w=1u l=1u
X585 a_16079_11821# a_15237_11471# a_14820_11464# VPWR sg13_lv_pmos ad=0.2048p pd=1.63u as=0.34p ps=2.68u w=1u l=0.13u
X586 VGND a_10415_13799# a_11082_14020# VGND sg13_lv_nmos ad=0.1406p pd=1.12u as=0.2516p ps=2.16u w=0.74u l=0.13u
X587 a_12880_16966# _241_.Y a_12940_17061# VPWR sg13_lv_pmos ad=79.8f pd=0.8u as=0.204p ps=1.835u w=0.42u l=0.13u
X588 VGND a_4144_4142# a_3793_4261# VGND sg13_lv_nmos ad=79.8f pd=0.8u as=0.1428p ps=1.52u w=0.42u l=0.13u
X589 a_15963_17137# a_15071_17016# a_15861_16904# VPWR sg13_lv_pmos ad=63f pd=0.72u as=79.8f ps=0.8u w=0.42u l=0.13u
X590 VGND VPWR VGND VGND sg13_lv_nmos ad=79.8f pd=0.8u as=0 ps=0 w=0.42u l=1u
X591 VGND a_7985_13776# _194_.X VGND sg13_lv_nmos ad=0.3108p pd=2.32u as=0.1628p ps=1.18u w=0.74u l=0.13u
X592 VPWR VGND VPWR VPWR sg13_lv_pmos ad=0.19p pd=1.38u as=0 ps=0 w=1u l=1u
X593 a_2436_9504# a_2410_9409# VGND VGND sg13_lv_nmos ad=0.2516p pd=2.16u as=0.1626p ps=1.415u w=0.74u l=0.13u
X594 VPWR _260_.CLK a_12923_11460# VPWR sg13_lv_pmos ad=0.2128p pd=1.5u as=0.2128p ps=1.5u w=1.12u l=0.13u
X595 VPWR VGND VPWR VPWR sg13_lv_pmos ad=0.34p pd=2.68u as=0 ps=0 w=1u l=1u
X596 a_14820_9504# a_15339_9308# a_16079_9263# VGND sg13_lv_nmos ad=0.3473p pd=2.71u as=0.12665p ps=1.145u w=0.74u l=0.13u
X597 VGND VPWR VGND VGND sg13_lv_nmos ad=0.1428p pd=1.52u as=0 ps=0 w=0.42u l=1u
X598 a_14438_12210# _129_.Y VPWR VPWR sg13_lv_pmos ad=79.8f pd=0.8u as=0.1428p ps=1.52u w=0.42u l=0.13u
X599 VGND _190_.A a_6197_13342# VGND sg13_lv_nmos ad=0.1898p pd=1.36u as=0.2516p ps=2.16u w=0.74u l=0.13u
X600 a_11381_3900# _147_.A1 VPWR VPWR sg13_lv_pmos ad=0.2128p pd=1.5u as=0.2128p ps=1.5u w=1.12u l=0.13u
X601 a_13973_7678# _158_.Y VGND VGND sg13_lv_nmos ad=0.1406p pd=1.12u as=0.1898p ps=1.36u w=0.74u l=0.13u
X602 VGND VPWR VGND VGND sg13_lv_nmos ad=0.1428p pd=1.52u as=0 ps=0 w=0.42u l=1u
X603 a_2122_15964# a_2565_16007# a_2505_16043# VPWR sg13_lv_pmos ad=79.8f pd=0.8u as=63f ps=0.72u w=0.42u l=0.13u
X604 VPWR VGND VPWR VPWR sg13_lv_pmos ad=0.19p pd=1.38u as=0 ps=0 w=1u l=1u
X605 VGND VPWR VGND VGND sg13_lv_nmos ad=79.8f pd=0.8u as=0 ps=0 w=0.42u l=1u
X606 a_11279_17869# a_10437_17519# a_11185_17869# VGND sg13_lv_nmos ad=0.12665p pd=1.145u as=0.1428p ps=1.52u w=0.42u l=0.13u
X607 VPWR VGND VPWR VPWR sg13_lv_pmos ad=0.19p pd=1.38u as=0 ps=0 w=1u l=1u
X608 VGND a_16336_8678# a_15985_8797# VGND sg13_lv_nmos ad=79.8f pd=0.8u as=0.1428p ps=1.52u w=0.42u l=0.13u
X609 VPWR VGND VPWR VPWR sg13_lv_pmos ad=0.19p pd=1.38u as=0 ps=0 w=1u l=1u
X610 VGND VPWR VGND VGND sg13_lv_nmos ad=0.1428p pd=1.52u as=0 ps=0 w=0.42u l=1u
X611 VPWR a_4559_4727# a_4816_4870# VPWR sg13_lv_pmos ad=0.4659p pd=3.65u as=79.8f ps=0.8u w=0.42u l=0.13u
X612 VGND VPWR VGND VGND sg13_lv_nmos ad=0.1428p pd=1.52u as=0 ps=0 w=0.42u l=1u
X613 VGND VPWR VGND VGND sg13_lv_nmos ad=0.1428p pd=1.52u as=0 ps=0 w=0.42u l=1u
X614 _133_.Y _126_.B1 VGND VGND sg13_lv_nmos ad=0.1694p pd=1.21u as=0.2618p ps=2.22u w=0.77u l=0.13u
X615 VGND VPWR VGND VGND sg13_lv_nmos ad=0.1428p pd=1.52u as=0 ps=0 w=0.42u l=1u
X616 VGND VPWR VGND VGND sg13_lv_nmos ad=0.1428p pd=1.52u as=0 ps=0 w=0.42u l=1u
X617 VPWR _220_.Y a_2218_12433# VPWR sg13_lv_pmos ad=0.1563p pd=1.22u as=0.147p ps=1.54u w=0.42u l=0.13u
X618 VGND VPWR VGND VGND sg13_lv_nmos ad=79.8f pd=0.8u as=0 ps=0 w=0.42u l=1u
X619 a_9424_16238# a_9167_16357# a_9586_16434# VGND sg13_lv_nmos ad=0.1428p pd=1.52u as=37.8f ps=0.6u w=0.42u l=0.13u
X620 VPWR VGND VPWR VPWR sg13_lv_pmos ad=0.34p pd=2.68u as=0 ps=0 w=1u l=1u
X621 a_14054_15234# _135_.A VPWR VPWR sg13_lv_pmos ad=79.8f pd=0.8u as=0.1428p ps=1.52u w=0.42u l=0.13u
X622 VGND a_3664_13214# a_3313_13333# VGND sg13_lv_nmos ad=79.8f pd=0.8u as=0.1428p ps=1.52u w=0.42u l=0.13u
X623 VGND _136_.A a_11755_4696# VGND sg13_lv_nmos ad=0.1331p pd=1.12u as=0.1216p ps=1.02u w=0.64u l=0.13u
X624 VPWR VGND VPWR VPWR sg13_lv_pmos ad=0.34p pd=2.68u as=0 ps=0 w=1u l=1u
X625 a_6677_8806# _168_.B VGND VGND sg13_lv_nmos ad=0.1406p pd=1.12u as=0.1898p ps=1.36u w=0.74u l=0.13u
X626 VPWR VGND VPWR VPWR sg13_lv_pmos ad=0.19p pd=1.38u as=0 ps=0 w=1u l=1u
X627 VGND a_12623_16823# a_13290_17044# VGND sg13_lv_nmos ad=0.1406p pd=1.12u as=0.2516p ps=2.16u w=0.74u l=0.13u
X628 a_12549_12189# _133_.B a_13009_12231# VGND sg13_lv_nmos ad=0.2516p pd=2.16u as=0.31732p ps=1.805u w=0.74u l=0.13u
X629 VGND VPWR VGND VGND sg13_lv_nmos ad=79.8f pd=0.8u as=0 ps=0 w=0.42u l=1u
X630 _165_.Y _122_.A0 a_7258_8806# VGND sg13_lv_nmos ad=0.2516p pd=2.16u as=0.1406p ps=1.12u w=0.74u l=0.13u
X631 a_15801_15549# a_14859_15356# a_15599_15311# VPWR sg13_lv_pmos ad=93.45f pd=0.865u as=0.2048p ps=1.63u w=0.42u l=0.13u
X632 a_5372_9484# _136_.A VPWR VPWR sg13_lv_pmos ad=0.2128p pd=1.5u as=0.2128p ps=1.5u w=1.12u l=0.13u
X633 _138_.Y _136_.B a_8042_3900# VPWR sg13_lv_pmos ad=0.3808p pd=2.92u as=0.1176p ps=1.33u w=1.12u l=0.13u
X634 a_4661_17878# fanout6.A VGND VGND sg13_lv_nmos ad=0.1406p pd=1.12u as=0.1898p ps=1.36u w=0.74u l=0.13u
X635 VGND VPWR VGND VGND sg13_lv_nmos ad=79.8f pd=0.8u as=0 ps=0 w=0.42u l=1u
X636 VGND VPWR VGND VGND sg13_lv_nmos ad=79.8f pd=0.8u as=0 ps=0 w=0.42u l=1u
X637 VGND VPWR VGND VGND sg13_lv_nmos ad=0.1428p pd=1.52u as=0 ps=0 w=0.42u l=1u
X638 _205_.Y _199_.Y VGND VGND sg13_lv_nmos ad=0.2516p pd=2.16u as=0.1406p ps=1.12u w=0.74u l=0.13u
X639 VPWR VGND VPWR VPWR sg13_lv_pmos ad=0.34p pd=2.68u as=0 ps=0 w=1u l=1u
X640 a_2558_17532# _250_.Q a_2126_17774# VPWR sg13_lv_pmos ad=0.3325p pd=1.665u as=0.2225p ps=1.445u w=1u l=0.13u
X641 a_2410_9409# a_2853_9165# a_2793_9577# VPWR sg13_lv_pmos ad=79.8f pd=0.8u as=63f ps=0.72u w=0.42u l=0.13u
X642 a_10809_4965# a_9867_4772# a_10607_4727# VPWR sg13_lv_pmos ad=93.45f pd=0.865u as=0.2048p ps=1.63u w=0.42u l=0.13u
X643 a_12241_16767# a_11781_16725# a_11883_16868# VGND sg13_lv_nmos ad=0.31732p pd=1.805u as=0.2516p ps=2.16u w=0.74u l=0.13u
X644 VGND VPWR VGND VGND sg13_lv_nmos ad=0.1428p pd=1.52u as=0 ps=0 w=0.42u l=1u
X645 a_11974_8436# _164_.B1 a_11731_8698# VPWR sg13_lv_pmos ad=0.2125p pd=1.425u as=0.35p ps=2.7u w=1u l=0.13u
X646 a_11596_9501# a_11536_9406# a_11481_9501# VPWR sg13_lv_pmos ad=0.204p pd=1.835u as=93.45f ps=0.865u w=0.42u l=0.13u
X647 VPWR _147_.A1 a_10938_5412# VPWR sg13_lv_pmos ad=0.2891p pd=1.695u as=0.1428p ps=1.375u w=1.12u l=0.13u
X648 _118_.A0 a_4074_17044# VPWR VPWR sg13_lv_pmos ad=0.3808p pd=2.92u as=0.2128p ps=1.5u w=1.12u l=0.13u
X649 VGND _136_.A a_5201_9240# VGND sg13_lv_nmos ad=0.15245p pd=1.17u as=0.17462p ps=1.185u w=0.55u l=0.13u
X650 a_11536_17750# a_11279_17869# a_11698_17946# VGND sg13_lv_nmos ad=0.1428p pd=1.52u as=37.8f ps=0.6u w=0.42u l=0.13u
X651 VPWR VGND VPWR VPWR sg13_lv_pmos ad=0.34p pd=2.68u as=0 ps=0 w=1u l=1u
X652 VPWR VGND VPWR VPWR sg13_lv_pmos ad=0.19p pd=1.38u as=0 ps=0 w=1u l=1u
X653 a_7882_15964# a_8325_16007# a_8265_16043# VPWR sg13_lv_pmos ad=79.8f pd=0.8u as=63f ps=0.72u w=0.42u l=0.13u
X654 a_10033_14018# a_9573_13701# a_9675_13844# VPWR sg13_lv_pmos ad=0.41165p pd=2.12u as=0.3864p ps=2.93u w=1.12u l=0.13u
X655 VGND VPWR VGND VGND sg13_lv_nmos ad=0.1428p pd=1.52u as=0 ps=0 w=0.42u l=1u
X656 a_10897_17510# a_10437_17519# a_10539_17519# VPWR sg13_lv_pmos ad=0.41165p pd=2.12u as=0.3864p ps=2.93u w=1.12u l=0.13u
X657 VGND VPWR VGND VGND sg13_lv_nmos ad=0.1428p pd=1.52u as=0 ps=0 w=0.42u l=1u
X658 a_11781_16725# _214_.A a_12241_17042# VPWR sg13_lv_pmos ad=0.4088p pd=2.97u as=0.41165p ps=2.12u w=1.12u l=0.13u
X659 VPWR VGND VPWR VPWR sg13_lv_pmos ad=0.34p pd=2.68u as=0 ps=0 w=1u l=1u
X660 VPWR VGND VPWR VPWR sg13_lv_pmos ad=0.34p pd=2.68u as=0 ps=0 w=1u l=1u
X661 VGND VPWR VGND VGND sg13_lv_nmos ad=0.1428p pd=1.52u as=0 ps=0 w=0.42u l=1u
X662 VGND a_3380_13690# _247_.CLK VGND sg13_lv_nmos ad=0.1406p pd=1.12u as=0.1406p ps=1.12u w=0.74u l=0.13u
X663 VGND VPWR VGND VGND sg13_lv_nmos ad=79.8f pd=0.8u as=0 ps=0 w=0.42u l=1u
X664 VGND VPWR VGND VGND sg13_lv_nmos ad=0.1428p pd=1.52u as=0 ps=0 w=0.42u l=1u
X665 VGND VPWR VGND VGND sg13_lv_nmos ad=0.1428p pd=1.52u as=0 ps=0 w=0.42u l=1u
X666 VGND VPWR VGND VGND sg13_lv_nmos ad=79.8f pd=0.8u as=0 ps=0 w=0.42u l=1u
X667 VPWR _219_.Y a_2150_9186# VPWR sg13_lv_pmos ad=0.36237p pd=2.605u as=79.8f ps=0.8u w=0.42u l=0.13u
X668 VPWR VGND VPWR VPWR sg13_lv_pmos ad=0.19p pd=1.38u as=0 ps=0 w=1u l=1u
X669 VGND VPWR VGND VGND sg13_lv_nmos ad=79.8f pd=0.8u as=0 ps=0 w=0.42u l=1u
X670 a_3588_5837# a_3300_5416# a_3526_5837# VGND sg13_lv_nmos ad=0.1428p pd=1.52u as=37.8f ps=0.6u w=0.42u l=0.13u
X671 VPWR VGND VPWR VPWR sg13_lv_pmos ad=0.19p pd=1.38u as=0 ps=0 w=1u l=1u
X672 VGND VPWR VGND VGND sg13_lv_nmos ad=0.1428p pd=1.52u as=0 ps=0 w=0.42u l=1u
X673 VGND a_4816_5654# a_4465_5773# VGND sg13_lv_nmos ad=79.8f pd=0.8u as=0.1428p ps=1.52u w=0.42u l=0.13u
X674 VGND _171_.A _171_.Y VGND sg13_lv_nmos ad=0.2516p pd=2.16u as=0.1406p ps=1.12u w=0.74u l=0.13u
X675 VPWR _131_.A2 _128_.B1 VPWR sg13_lv_pmos ad=0.3808p pd=2.92u as=0.2128p ps=1.5u w=1.12u l=0.13u
X676 _166_.A a_16746_8436# VGND VGND sg13_lv_nmos ad=0.2516p pd=2.16u as=0.1406p ps=1.12u w=0.74u l=0.13u
X677 VPWR VGND VPWR VPWR sg13_lv_pmos ad=0.19p pd=1.38u as=0 ps=0 w=1u l=1u
X678 a_4881_12972# _119_.A0 VPWR VPWR sg13_lv_pmos ad=0.1225p pd=1.245u as=0.36p ps=2.72u w=1u l=0.13u
X679 a_6008_15242# _196_.Y a_5906_15242# VGND sg13_lv_nmos ad=0.1406p pd=1.12u as=0.1406p ps=1.12u w=0.74u l=0.13u
X680 VGND a_3380_13690# _247_.CLK VGND sg13_lv_nmos ad=0.1406p pd=1.12u as=0.1406p ps=1.12u w=0.74u l=0.13u
X681 a_9994_17476# a_10437_17519# a_10377_17555# VPWR sg13_lv_pmos ad=79.8f pd=0.8u as=63f ps=0.72u w=0.42u l=0.13u
X682 VPWR a_10607_4727# a_10864_4870# VPWR sg13_lv_pmos ad=0.4659p pd=3.65u as=79.8f ps=0.8u w=0.42u l=0.13u
X683 a_9290_3900# _138_.Y VPWR VPWR sg13_lv_pmos ad=0.1176p pd=1.33u as=0.4032p ps=2.96u w=1.12u l=0.13u
X684 VGND VPWR VGND VGND sg13_lv_nmos ad=0.1428p pd=1.52u as=0 ps=0 w=0.42u l=1u
X685 a_14196_5760# _148_.X a_13740_5678# VGND sg13_lv_nmos ad=78.39999f pd=0.885u as=0.2176p ps=1.96u w=0.64u l=0.13u
X686 VGND VPWR VGND VGND sg13_lv_nmos ad=79.8f pd=0.8u as=0 ps=0 w=0.42u l=1u
X687 a_15237_11471# _133_.B a_15697_11462# VPWR sg13_lv_pmos ad=0.4088p pd=2.97u as=0.41165p ps=2.12u w=1.12u l=0.13u
X688 VGND a_2126_11726# _120_.X VGND sg13_lv_nmos ad=0.148p pd=1.14u as=0.4033p ps=2.57u w=0.74u l=0.13u
X689 _152_.X a_12237_5760# VGND VGND sg13_lv_nmos ad=0.2516p pd=2.16u as=0.1331p ps=1.12u w=0.74u l=0.13u
X690 VGND a_14320_16238# a_13969_16357# VGND sg13_lv_nmos ad=79.8f pd=0.8u as=0.1428p ps=1.52u w=0.42u l=0.13u
X691 a_16336_11702# _236_.Y a_16396_11583# VPWR sg13_lv_pmos ad=79.8f pd=0.8u as=0.204p ps=1.835u w=0.42u l=0.13u
X692 a_10437_17519# freq_in a_10897_17861# VGND sg13_lv_nmos ad=0.2516p pd=2.16u as=0.31732p ps=1.805u w=0.74u l=0.13u
X693 VGND a_9551_16823# a_10218_17044# VGND sg13_lv_nmos ad=0.1406p pd=1.12u as=0.2516p ps=2.16u w=0.74u l=0.13u
X694 VPWR VGND VPWR VPWR sg13_lv_pmos ad=0.19p pd=1.38u as=0 ps=0 w=1u l=1u
X695 a_9062_4650# _252_.D VPWR VPWR sg13_lv_pmos ad=79.8f pd=0.8u as=0.1428p ps=1.52u w=0.42u l=0.13u
X696 _207_.A1 a_9834_15996# VGND VGND sg13_lv_nmos ad=0.2516p pd=2.16u as=0.1406p ps=1.12u w=0.74u l=0.13u
X697 a_14628_8874# _159_.Y a_14534_8874# VGND sg13_lv_nmos ad=60.89999f pd=0.71u as=0.1428p ps=1.52u w=0.42u l=0.13u
X698 a_14628_11898# _131_.Y a_14534_11898# VGND sg13_lv_nmos ad=60.89999f pd=0.71u as=0.1428p ps=1.52u w=0.42u l=0.13u
X699 VPWR VGND VPWR VPWR sg13_lv_pmos ad=0.34p pd=2.68u as=0 ps=0 w=1u l=1u
X700 VGND VPWR VGND VGND sg13_lv_nmos ad=79.8f pd=0.8u as=0 ps=0 w=0.42u l=1u
X701 VGND VPWR VGND VGND sg13_lv_nmos ad=79.8f pd=0.8u as=0 ps=0 w=0.42u l=1u
X702 VGND VPWR VGND VGND sg13_lv_nmos ad=0.1428p pd=1.52u as=0 ps=0 w=0.42u l=1u
X703 a_9130_12433# a_9573_12189# a_9513_12601# VPWR sg13_lv_pmos ad=79.8f pd=0.8u as=63f ps=0.72u w=0.42u l=0.13u
X704 _168_.Y _168_.B a_6771_8436# VPWR sg13_lv_pmos ad=0.2408p pd=1.55u as=0.1428p ps=1.375u w=1.12u l=0.13u
X705 VGND a_3886_10702# clkbuf_1_0__f_sclk.A VGND sg13_lv_nmos ad=0.1406p pd=1.12u as=0.1406p ps=1.12u w=0.74u l=0.13u
X706 a_1958_12210# _120_.X VPWR VPWR sg13_lv_pmos ad=79.8f pd=0.8u as=0.1428p ps=1.52u w=0.42u l=0.13u
X707 VPWR VGND VPWR VPWR sg13_lv_pmos ad=0.34p pd=2.68u as=0 ps=0 w=1u l=1u
X708 a_4913_13330# _119_.A0 VGND VGND sg13_lv_nmos ad=0.17462p pd=1.185u as=0.374p ps=2.46u w=0.55u l=0.13u
X709 VPWR _260_.CLK a_14651_10996# VPWR sg13_lv_pmos ad=0.2128p pd=1.5u as=0.2128p ps=1.5u w=1.12u l=0.13u
X710 a_10672_13942# _230_.Y a_10732_14037# VPWR sg13_lv_pmos ad=79.8f pd=0.8u as=0.204p ps=1.835u w=0.42u l=0.13u
X711 VPWR VGND VPWR VPWR sg13_lv_pmos ad=0.19p pd=1.38u as=0 ps=0 w=1u l=1u
X712 a_4512_17547# _118_.A0 VPWR VPWR sg13_lv_pmos ad=0.1596p pd=1.22u as=0.4536p ps=2.76u w=0.84u l=0.13u
X713 _196_.Y _189_.X VPWR VPWR sg13_lv_pmos ad=0.2128p pd=1.5u as=0.3808p ps=2.92u w=1.12u l=0.13u
X714 VPWR VGND VPWR VPWR sg13_lv_pmos ad=0.34p pd=2.68u as=0 ps=0 w=1u l=1u
X715 a_13161_16043# a_12804_16000# VPWR VPWR sg13_lv_pmos ad=63f pd=0.72u as=0.1563p ps=1.22u w=0.42u l=0.13u
X716 _162_.Y _162_.B VGND VGND sg13_lv_nmos ad=0.1406p pd=1.12u as=0.2516p ps=2.16u w=0.74u l=0.13u
X717 _171_.A _168_.Y VGND VGND sg13_lv_nmos ad=0.1406p pd=1.12u as=0.2516p ps=2.16u w=0.74u l=0.13u
X718 a_3826_16434# _250_.RESET_B VGND VGND sg13_lv_nmos ad=37.8f pd=0.6u as=79.8f ps=0.8u w=0.42u l=0.13u
X719 a_7616_15437# _201_.Y VPWR VPWR sg13_lv_pmos ad=0.1596p pd=1.22u as=0.1918p ps=1.5u w=0.84u l=0.13u
X720 VPWR _124_.S a_2558_14020# VPWR sg13_lv_pmos ad=0.253p pd=1.53u as=0.3325p ps=1.665u w=1u l=0.13u
X721 a_3380_13690# clkbuf_1_0__f_sclk.A VGND VGND sg13_lv_nmos ad=0.1406p pd=1.12u as=0.1406p ps=1.12u w=0.74u l=0.13u
X722 VPWR _168_.B a_6528_8475# VPWR sg13_lv_pmos ad=0.2891p pd=1.695u as=0.1596p ps=1.22u w=0.84u l=0.13u
X723 VPWR _266_.CLK _212_.Y VPWR sg13_lv_pmos ad=0.3808p pd=2.92u as=0.3808p ps=2.92u w=1.12u l=0.13u
X724 VPWR VGND VPWR VPWR sg13_lv_pmos ad=0.34p pd=2.68u as=0 ps=0 w=1u l=1u
X725 VGND VPWR VGND VGND sg13_lv_nmos ad=0.1428p pd=1.52u as=0 ps=0 w=0.42u l=1u
X726 fanout7.A a_16746_9484# VGND VGND sg13_lv_nmos ad=0.2516p pd=2.16u as=0.1406p ps=1.12u w=0.74u l=0.13u
X727 VGND VPWR VGND VGND sg13_lv_nmos ad=0.1428p pd=1.52u as=0 ps=0 w=0.42u l=1u
X728 VPWR a_3886_10702# clkbuf_1_0__f_sclk.A VPWR sg13_lv_pmos ad=0.2128p pd=1.5u as=0.2128p ps=1.5u w=1.12u l=0.13u
X729 VGND VPWR VGND VGND sg13_lv_nmos ad=79.8f pd=0.8u as=0 ps=0 w=0.42u l=1u
X730 VGND _218_.Y a_2244_8874# VGND sg13_lv_nmos ad=0.1626p pd=1.415u as=60.89999f ps=0.71u w=0.42u l=0.13u
X731 VGND VPWR VGND VGND sg13_lv_nmos ad=79.8f pd=0.8u as=0 ps=0 w=0.42u l=1u
X732 VGND VPWR VGND VGND sg13_lv_nmos ad=0.1428p pd=1.52u as=0 ps=0 w=0.42u l=1u
X733 VPWR VGND VPWR VPWR sg13_lv_pmos ad=0.34p pd=2.68u as=0 ps=0 w=1u l=1u
X734 a_16396_9501# a_16336_9406# a_16281_9501# VPWR sg13_lv_pmos ad=0.204p pd=1.835u as=93.45f ps=0.865u w=0.42u l=0.13u
X735 a_16118_16759# a_14940_16710# a_15722_16904# VGND sg13_lv_nmos ad=37.8f pd=0.6u as=0.1428p ps=1.52u w=0.42u l=0.13u
X736 VGND VPWR VGND VGND sg13_lv_nmos ad=0.1428p pd=1.52u as=0 ps=0 w=0.42u l=1u
X737 _131_.B1 _131_.A2 a_14451_13320# VGND sg13_lv_nmos ad=0.1406p pd=1.12u as=0.1406p ps=1.12u w=0.74u l=0.13u
X738 VPWR VGND VPWR VPWR sg13_lv_pmos ad=0.34p pd=2.68u as=0 ps=0 w=1u l=1u
X739 a_13041_5412# _147_.Y VPWR VPWR sg13_lv_pmos ad=0.1225p pd=1.245u as=0.36p ps=2.72u w=1u l=0.13u
X740 a_7985_7728# _136_.A a_7953_7996# VPWR sg13_lv_pmos ad=0.34p pd=2.68u as=0.1225p ps=1.245u w=1u l=0.13u
X741 VPWR VGND VPWR VPWR sg13_lv_pmos ad=0.34p pd=2.68u as=0 ps=0 w=1u l=1u
X742 a_6756_4663# a_6468_4968# a_6694_4663# VGND sg13_lv_nmos ad=0.1428p pd=1.52u as=37.8f ps=0.6u w=0.42u l=0.13u
X743 VGND VPWR VGND VGND sg13_lv_nmos ad=0.1428p pd=1.52u as=0 ps=0 w=0.42u l=1u
X744 a_3380_13690# clkbuf_1_0__f_sclk.A VGND VGND sg13_lv_nmos ad=0.1406p pd=1.12u as=0.1406p ps=1.12u w=0.74u l=0.13u
X745 a_10020_17512# a_9994_17476# VPWR VPWR sg13_lv_pmos ad=0.34p pd=2.68u as=0.36237p ps=2.605u w=1u l=0.13u
X746 VPWR a_15983_5773# a_16650_5412# VPWR sg13_lv_pmos ad=0.2128p pd=1.5u as=0.3864p ps=2.93u w=1.12u l=0.13u
X747 VPWR VGND VPWR VPWR sg13_lv_pmos ad=0.34p pd=2.68u as=0 ps=0 w=1u l=1u
X748 a_12401_4704# _148_.B a_12369_4972# VPWR sg13_lv_pmos ad=0.34p pd=2.68u as=0.1225p ps=1.245u w=1u l=0.13u
X749 a_2232_7868# _124_.S VPWR VPWR sg13_lv_pmos ad=0.2856p pd=2.36u as=0.253p ps=1.53u w=0.84u l=0.13u
X750 VGND VPWR VGND VGND sg13_lv_nmos ad=79.8f pd=0.8u as=0 ps=0 w=0.42u l=1u
X751 a_3274_4873# a_3717_4629# a_3014_4650# VGND sg13_lv_nmos ad=79.8f pd=0.8u as=0.1296p ps=1.52u w=0.42u l=0.13u
X752 a_7157_16366# _202_.Y VGND VGND sg13_lv_nmos ad=0.1406p pd=1.12u as=0.1898p ps=1.36u w=0.74u l=0.13u
X753 a_4816_5654# a_4559_5773# a_4978_5850# VGND sg13_lv_nmos ad=0.1428p pd=1.52u as=37.8f ps=0.6u w=0.42u l=0.13u
X754 a_5050_15238# _119_.A0 _195_.Y VGND sg13_lv_nmos ad=0.1406p pd=1.12u as=0.2516p ps=2.16u w=0.74u l=0.13u
X755 VPWR _176_.A _192_.B VPWR sg13_lv_pmos ad=0.3808p pd=2.92u as=0.2128p ps=1.5u w=1.12u l=0.13u
X756 VGND VPWR VGND VGND sg13_lv_nmos ad=79.8f pd=0.8u as=0 ps=0 w=0.42u l=1u
X757 a_11846_12210# _126_.Y VPWR VPWR sg13_lv_pmos ad=79.8f pd=0.8u as=0.1428p ps=1.52u w=0.42u l=0.13u
X758 VPWR VGND VPWR VPWR sg13_lv_pmos ad=0.19p pd=1.38u as=0 ps=0 w=1u l=1u
X759 VPWR _158_.Y a_13824_7989# VPWR sg13_lv_pmos ad=0.2891p pd=1.695u as=0.1596p ps=1.22u w=0.84u l=0.13u
X760 VGND VPWR VGND VGND sg13_lv_nmos ad=0.1428p pd=1.52u as=0 ps=0 w=0.42u l=1u
X761 a_6182_4650# a_6987_4772# a_6442_4873# VPWR sg13_lv_pmos ad=0.1428p pd=1.52u as=79.8f ps=0.8u w=0.42u l=0.13u
X762 VGND VPWR VGND VGND sg13_lv_nmos ad=0.1428p pd=1.52u as=0 ps=0 w=0.42u l=1u
X763 VGND _199_.B1 _199_.Y VGND sg13_lv_nmos ad=0.2516p pd=2.16u as=0.1406p ps=1.12u w=0.74u l=0.13u
X764 a_10897_9207# a_10437_9165# a_10539_9308# VGND sg13_lv_nmos ad=0.31732p pd=1.805u as=0.2516p ps=2.16u w=0.74u l=0.13u
X765 VGND VPWR VGND VGND sg13_lv_nmos ad=79.8f pd=0.8u as=0 ps=0 w=0.42u l=1u
X766 a_4144_4142# _243_.RESET_B a_4204_4023# VPWR sg13_lv_pmos ad=79.8f pd=0.8u as=0.204p ps=1.835u w=0.42u l=0.13u
X767 VGND _147_.A1 a_11220_5760# VGND sg13_lv_nmos ad=0.2272p pd=1.99u as=78.39999f ps=0.885u w=0.64u l=0.13u
X768 a_6482_12218# _192_.C VGND VGND sg13_lv_nmos ad=0.1406p pd=1.12u as=0.2886p ps=2.26u w=0.74u l=0.13u
X769 VGND VPWR VGND VGND sg13_lv_nmos ad=79.8f pd=0.8u as=0 ps=0 w=0.42u l=1u
X770 a_6720_17061# _205_.Y VPWR VPWR sg13_lv_pmos ad=0.1596p pd=1.22u as=0.4536p ps=2.76u w=0.84u l=0.13u
X771 VPWR _215_.Y a_3014_4650# VPWR sg13_lv_pmos ad=0.36237p pd=2.605u as=79.8f ps=0.8u w=0.42u l=0.13u
X772 a_11974_8436# _160_.X VPWR VPWR sg13_lv_pmos ad=0.34p pd=2.68u as=0.19p ps=1.38u w=1u l=0.13u
X773 a_15141_12189# _133_.B a_15601_12231# VGND sg13_lv_nmos ad=0.2516p pd=2.16u as=0.31732p ps=1.805u w=0.74u l=0.13u
X774 a_6579_11460# _176_.A VPWR VPWR sg13_lv_pmos ad=0.1428p pd=1.375u as=0.2891p ps=1.695u w=1.12u l=0.13u
X775 VGND a_13391_12287# a_14058_12508# VGND sg13_lv_nmos ad=0.1406p pd=1.12u as=0.2516p ps=2.16u w=0.74u l=0.13u
X776 _145_.A2 a_8538_5375# VGND VGND sg13_lv_nmos ad=0.1628p pd=1.18u as=0.3108p ps=2.32u w=0.74u l=0.13u
X777 a_2122_12940# a_2565_12983# a_2505_13019# VPWR sg13_lv_pmos ad=79.8f pd=0.8u as=63f ps=0.72u w=0.42u l=0.13u
X778 VGND VPWR VGND VGND sg13_lv_nmos ad=79.8f pd=0.8u as=0 ps=0 w=0.42u l=1u
X779 a_12685_7700# _157_.Y a_12215_7664# VGND sg13_lv_nmos ad=94.35f pd=0.995u as=0.1406p ps=1.12u w=0.74u l=0.13u
X780 a_4858_12214# _120_.A0 _187_.Y VGND sg13_lv_nmos ad=0.1406p pd=1.12u as=0.2516p ps=2.16u w=0.74u l=0.13u
X781 a_8006_16746# _209_.Y VPWR VPWR sg13_lv_pmos ad=79.8f pd=0.8u as=0.1428p ps=1.52u w=0.42u l=0.13u
X782 VPWR VGND VPWR VPWR sg13_lv_pmos ad=0.19p pd=1.38u as=0 ps=0 w=1u l=1u
X783 VGND VPWR VGND VGND sg13_lv_nmos ad=79.8f pd=0.8u as=0 ps=0 w=0.42u l=1u
X784 _266_.CLK a_13290_17044# VGND VGND sg13_lv_nmos ad=0.2516p pd=2.16u as=0.1406p ps=1.12u w=0.74u l=0.13u
X785 VGND VPWR VGND VGND sg13_lv_nmos ad=0.1428p pd=1.52u as=0 ps=0 w=0.42u l=1u
X786 a_11481_17631# a_10539_17519# a_11279_17869# VPWR sg13_lv_pmos ad=93.45f pd=0.865u as=0.2048p ps=1.63u w=0.42u l=0.13u
X787 VGND VPWR VGND VGND sg13_lv_nmos ad=79.8f pd=0.8u as=0 ps=0 w=0.42u l=1u
X788 a_2126_11726# _120_.A0 a_2298_11830# VGND sg13_lv_nmos ad=0.1628p pd=1.18u as=0.3367p ps=1.65u w=0.74u l=0.13u
X789 _243_.CLK a_3956_6888# VGND VGND sg13_lv_nmos ad=0.1406p pd=1.12u as=0.1406p ps=1.12u w=0.74u l=0.13u
X790 VGND VPWR VGND VGND sg13_lv_nmos ad=0.1428p pd=1.52u as=0 ps=0 w=0.42u l=1u
X791 VGND VPWR VGND VGND sg13_lv_nmos ad=79.8f pd=0.8u as=0 ps=0 w=0.42u l=1u
X792 a_2436_16759# a_2667_16868# a_2122_16969# VGND sg13_lv_nmos ad=0.2373p pd=1.97u as=79.8f ps=0.8u w=0.42u l=0.13u
X793 VPWR VGND VPWR VPWR sg13_lv_pmos ad=0.34p pd=2.68u as=0 ps=0 w=1u l=1u
X794 VPWR VGND VPWR VPWR sg13_lv_pmos ad=0.19p pd=1.38u as=0 ps=0 w=1u l=1u
X795 a_2436_9504# a_2955_9308# a_3695_9263# VGND sg13_lv_nmos ad=0.3473p pd=2.71u as=0.12665p ps=1.145u w=0.74u l=0.13u
X796 VPWR VGND VPWR VPWR sg13_lv_pmos ad=0.34p pd=2.68u as=0 ps=0 w=1u l=1u
X797 VGND VPWR VGND VGND sg13_lv_nmos ad=0.1428p pd=1.52u as=0 ps=0 w=0.42u l=1u
X798 VGND VPWR VGND VGND sg13_lv_nmos ad=0.1428p pd=1.52u as=0 ps=0 w=0.42u l=1u
X799 a_2853_9165# _243_.CLK a_3313_9482# VPWR sg13_lv_pmos ad=0.4088p pd=2.97u as=0.41165p ps=2.12u w=1.12u l=0.13u
X800 VPWR _186_.Y a_8156_14020# VPWR sg13_lv_pmos ad=0.2128p pd=1.5u as=0.3808p ps=2.92u w=1.12u l=0.13u
X801 VPWR _243_.RESET_B a_2342_4338# VPWR sg13_lv_pmos ad=0.36237p pd=2.605u as=79.8f ps=0.8u w=0.42u l=0.13u
X802 VGND VPWR VGND VGND sg13_lv_nmos ad=0.1428p pd=1.52u as=0 ps=0 w=0.42u l=1u
X803 a_3922_12210# _220_.Y VGND VGND sg13_lv_nmos ad=37.8f pd=0.6u as=79.8f ps=0.8u w=0.42u l=0.13u
X804 VGND a_3956_6888# _243_.CLK VGND sg13_lv_nmos ad=0.1406p pd=1.12u as=0.1406p ps=1.12u w=0.74u l=0.13u
X805 a_7953_7996# _122_.A0 VPWR VPWR sg13_lv_pmos ad=0.1225p pd=1.245u as=0.36p ps=2.72u w=1u l=0.13u
X806 VPWR VGND VPWR VPWR sg13_lv_pmos ad=0.34p pd=2.68u as=0 ps=0 w=1u l=1u
X807 a_6234_3900# _210_.B _210_.Y VPWR sg13_lv_pmos ad=0.1428p pd=1.375u as=0.2408p ps=1.55u w=1.12u l=0.13u
X808 VGND VPWR VGND VGND sg13_lv_nmos ad=79.8f pd=0.8u as=0 ps=0 w=0.42u l=1u
X809 VPWR VGND VPWR VPWR sg13_lv_pmos ad=0.19p pd=1.38u as=0 ps=0 w=1u l=1u
X810 VPWR VGND VPWR VPWR sg13_lv_pmos ad=0.19p pd=1.38u as=0 ps=0 w=1u l=1u
X811 a_2232_10210# _124_.S VPWR VPWR sg13_lv_pmos ad=0.2856p pd=2.36u as=0.253p ps=1.53u w=0.84u l=0.13u
X812 _247_.CLK a_3380_13690# VPWR VPWR sg13_lv_pmos ad=0.2128p pd=1.5u as=0.2128p ps=1.5u w=1.12u l=0.13u
X813 a_9269_9190# _171_.Y VGND VGND sg13_lv_nmos ad=0.1406p pd=1.12u as=0.1898p ps=1.36u w=0.74u l=0.13u
X814 VPWR VGND VPWR VPWR sg13_lv_pmos ad=0.34p pd=2.68u as=0 ps=0 w=1u l=1u
X815 VPWR VGND VPWR VPWR sg13_lv_pmos ad=0.34p pd=2.68u as=0 ps=0 w=1u l=1u
X816 _258_.RESET_B _222_.A VPWR VPWR sg13_lv_pmos ad=0.3808p pd=2.92u as=0.3808p ps=2.92u w=1.12u l=0.13u
X817 a_9382_12223# _229_.Y VGND VGND sg13_lv_nmos ad=37.8f pd=0.6u as=0.1701p ps=1.65u w=0.42u l=0.13u
X818 a_11475_4248# _139_.X VGND VGND sg13_lv_nmos ad=0.1406p pd=1.12u as=0.2516p ps=2.16u w=0.74u l=0.13u
X819 VGND a_3952_8678# a_3601_8797# VGND sg13_lv_nmos ad=79.8f pd=0.8u as=0.1428p ps=1.52u w=0.42u l=0.13u
X820 a_3588_5837# a_3819_5423# a_3274_5380# VGND sg13_lv_nmos ad=0.2373p pd=1.97u as=79.8f ps=0.8u w=0.42u l=0.13u
X821 a_14724_5416# a_15243_5423# a_15983_5773# VGND sg13_lv_nmos ad=0.3473p pd=2.71u as=0.12665p ps=1.145u w=0.74u l=0.13u
X822 a_2436_9504# a_2410_9409# VPWR VPWR sg13_lv_pmos ad=0.34p pd=2.68u as=0.36237p ps=2.605u w=1u l=0.13u
X823 a_10220_18222# _225_.A VPWR VPWR sg13_lv_pmos ad=0.2856p pd=2.36u as=0.2114p ps=1.54u w=0.84u l=0.13u
X824 VGND VPWR VGND VGND sg13_lv_nmos ad=0.1428p pd=1.52u as=0 ps=0 w=0.42u l=1u
X825 VPWR VGND VPWR VPWR sg13_lv_pmos ad=0.34p pd=2.68u as=0 ps=0 w=1u l=1u
X826 a_14830_17061# a_14572_16746# a_14728_17061# VPWR sg13_lv_pmos ad=93.45f pd=0.865u as=0.204p ps=1.835u w=0.42u l=0.13u
X827 a_7985_7728# _122_.A0 VGND VGND sg13_lv_nmos ad=0.17462p pd=1.185u as=0.374p ps=2.46u w=0.55u l=0.13u
X828 VPWR VGND VPWR VPWR sg13_lv_pmos ad=0.34p pd=2.68u as=0 ps=0 w=1u l=1u
X829 _222_.Y _222_.A VGND VGND sg13_lv_nmos ad=0.2516p pd=2.16u as=0.2516p ps=2.16u w=0.74u l=0.13u
X830 a_12241_17042# a_11781_16725# a_11883_16868# VPWR sg13_lv_pmos ad=0.41165p pd=2.12u as=0.3864p ps=2.93u w=1.12u l=0.13u
X831 VGND VPWR VGND VGND sg13_lv_nmos ad=0.1428p pd=1.52u as=0 ps=0 w=0.42u l=1u
X832 VPWR VGND VPWR VPWR sg13_lv_pmos ad=0.34p pd=2.68u as=0 ps=0 w=1u l=1u
X833 a_3274_5380# a_3717_5423# a_3657_5459# VPWR sg13_lv_pmos ad=79.8f pd=0.8u as=63f ps=0.72u w=0.42u l=0.13u
X834 a_7985_13776# _193_.Y a_7953_14044# VPWR sg13_lv_pmos ad=0.34p pd=2.68u as=0.1225p ps=1.245u w=1u l=0.13u
X835 VPWR a_4559_5773# a_5226_5412# VPWR sg13_lv_pmos ad=0.2128p pd=1.5u as=0.3864p ps=2.93u w=1.12u l=0.13u
X836 VPWR VGND VPWR VPWR sg13_lv_pmos ad=0.34p pd=2.68u as=0 ps=0 w=1u l=1u
X837 a_2558_15532# _118_.A0 a_2126_15424# VPWR sg13_lv_pmos ad=0.3325p pd=1.665u as=0.2225p ps=1.445u w=1u l=0.13u
X838 a_14724_5416# a_14698_5380# VGND VGND sg13_lv_nmos ad=0.2516p pd=2.16u as=0.1626p ps=1.415u w=0.74u l=0.13u
X839 VPWR _147_.Y a_13244_5412# VPWR sg13_lv_pmos ad=0.2128p pd=1.5u as=0.3808p ps=2.92u w=1.12u l=0.13u
X840 VGND VPWR VGND VGND sg13_lv_nmos ad=0.1428p pd=1.52u as=0 ps=0 w=0.42u l=1u
X841 a_8325_16007# fanout7.A a_8785_15998# VPWR sg13_lv_pmos ad=0.4088p pd=2.97u as=0.41165p ps=2.12u w=1.12u l=0.13u
X842 a_15983_12287# a_15141_12189# a_14724_12528# VPWR sg13_lv_pmos ad=0.2048p pd=1.63u as=0.34p ps=2.68u w=1u l=0.13u
X843 a_6970_12214# _176_.B VGND VGND sg13_lv_nmos ad=0.1406p pd=1.12u as=0.2516p ps=2.16u w=0.74u l=0.13u
X844 a_3657_5041# a_3300_4968# VPWR VPWR sg13_lv_pmos ad=63f pd=0.72u as=0.1563p ps=1.22u w=0.42u l=0.13u
X845 _226_.Y _225_.A VGND VGND sg13_lv_nmos ad=0.2516p pd=2.16u as=0.2516p ps=2.16u w=0.74u l=0.13u
X846 a_15697_9207# a_15237_9165# a_15339_9308# VGND sg13_lv_nmos ad=0.31732p pd=1.805u as=0.2516p ps=2.16u w=0.74u l=0.13u
X847 VGND VPWR VGND VGND sg13_lv_nmos ad=0.1428p pd=1.52u as=0 ps=0 w=0.42u l=1u
X848 a_11364_17064# a_11883_16868# a_12623_16823# VGND sg13_lv_nmos ad=0.3473p pd=2.71u as=0.12665p ps=1.145u w=0.74u l=0.13u
X849 VPWR VGND VPWR VPWR sg13_lv_pmos ad=0.19p pd=1.38u as=0 ps=0 w=1u l=1u
X850 VGND a_3664_16966# a_3313_16823# VGND sg13_lv_nmos ad=79.8f pd=0.8u as=0.1428p ps=1.52u w=0.42u l=0.13u
X851 VGND VPWR VGND VGND sg13_lv_nmos ad=0.1428p pd=1.52u as=0 ps=0 w=0.42u l=1u
X852 VGND VPWR VGND VGND sg13_lv_nmos ad=0.1428p pd=1.52u as=0 ps=0 w=0.42u l=1u
X853 VPWR VGND VPWR VPWR sg13_lv_pmos ad=0.34p pd=2.68u as=0 ps=0 w=1u l=1u
X854 a_13184_7183# _151_.B a_13321_7272# VGND sg13_lv_nmos ad=0.2176p pd=1.96u as=0.1216p ps=1.02u w=0.64u l=0.13u
X855 VGND VPWR VGND VGND sg13_lv_nmos ad=0.1428p pd=1.52u as=0 ps=0 w=0.42u l=1u
X856 a_16240_5654# _226_.Y a_16300_5535# VPWR sg13_lv_pmos ad=79.8f pd=0.8u as=0.204p ps=1.835u w=0.42u l=0.13u
X857 VGND _235_.Y a_14532_12210# VGND sg13_lv_nmos ad=0.1626p pd=1.415u as=60.89999f ps=0.71u w=0.42u l=0.13u
X858 a_12880_16966# a_12623_16823# a_13042_16746# VGND sg13_lv_nmos ad=0.1428p pd=1.52u as=37.8f ps=0.6u w=0.42u l=0.13u
X859 VPWR _200_.Y a_6286_15276# VPWR sg13_lv_pmos ad=0.2618p pd=1.63u as=0.2856p ps=2.36u w=0.84u l=0.13u
X860 a_3505_4253# a_3045_3911# a_3147_3911# VGND sg13_lv_nmos ad=0.31732p pd=1.805u as=0.2516p ps=2.16u w=0.74u l=0.13u
X861 VPWR VGND VPWR VPWR sg13_lv_pmos ad=0.34p pd=2.68u as=0 ps=0 w=1u l=1u
X862 VGND VPWR VGND VGND sg13_lv_nmos ad=79.8f pd=0.8u as=0 ps=0 w=0.42u l=1u
X863 VGND VPWR VGND VGND sg13_lv_nmos ad=0.1428p pd=1.52u as=0 ps=0 w=0.42u l=1u
X864 VPWR _126_.B1 a_14357_12972# VPWR sg13_lv_pmos ad=0.2128p pd=1.5u as=0.3808p ps=2.92u w=1.12u l=0.13u
X865 VGND VPWR VGND VGND sg13_lv_nmos ad=79.8f pd=0.8u as=0 ps=0 w=0.42u l=1u
X866 a_9970_16746# _232_.Y VGND VGND sg13_lv_nmos ad=37.8f pd=0.6u as=79.8f ps=0.8u w=0.42u l=0.13u
X867 a_6862_15532# _204_.X a_7074_15532# VPWR sg13_lv_pmos ad=0.2128p pd=1.5u as=0.3808p ps=2.92u w=1.12u l=0.13u
X868 VPWR VGND VPWR VPWR sg13_lv_pmos ad=0.19p pd=1.38u as=0 ps=0 w=1u l=1u
X869 VGND VPWR VGND VGND sg13_lv_nmos ad=0.1428p pd=1.52u as=0 ps=0 w=0.42u l=1u
X870 VGND _166_.A a_10901_7678# VGND sg13_lv_nmos ad=0.1898p pd=1.36u as=0.2516p ps=2.16u w=0.74u l=0.13u
X871 a_2126_17774# _118_.A0 a_2298_17532# VPWR sg13_lv_pmos ad=0.2225p pd=1.445u as=0.2975p ps=1.595u w=1u l=0.13u
X872 a_5525_16750# _207_.A2 VGND VGND sg13_lv_nmos ad=0.1406p pd=1.12u as=0.1898p ps=1.36u w=0.74u l=0.13u
X873 a_14753_10724# _260_.CLK _131_.Y VGND sg13_lv_nmos ad=0.1406p pd=1.12u as=0.1406p ps=1.12u w=0.74u l=0.13u
X874 VPWR clkbuf_1_0__f_sclk.A a_3380_13690# VPWR sg13_lv_pmos ad=0.2128p pd=1.5u as=0.2128p ps=1.5u w=1.12u l=0.13u
X875 VGND VPWR VGND VGND sg13_lv_nmos ad=79.8f pd=0.8u as=0 ps=0 w=0.42u l=1u
X876 VGND VPWR VGND VGND sg13_lv_nmos ad=79.8f pd=0.8u as=0 ps=0 w=0.42u l=1u
X877 VPWR a_10415_13799# a_10672_13942# VPWR sg13_lv_pmos ad=0.4659p pd=3.65u as=79.8f ps=0.8u w=0.42u l=0.13u
X878 a_12106_12433# a_12549_12189# a_12489_12601# VPWR sg13_lv_pmos ad=79.8f pd=0.8u as=63f ps=0.72u w=0.42u l=0.13u
X879 VPWR VGND VPWR VPWR sg13_lv_pmos ad=0.34p pd=2.68u as=0 ps=0 w=1u l=1u
X880 a_14438_12210# a_15243_12332# a_14698_12433# VPWR sg13_lv_pmos ad=0.1428p pd=1.52u as=79.8f ps=0.8u w=0.42u l=0.13u
X881 VPWR VGND VPWR VPWR sg13_lv_pmos ad=0.34p pd=2.68u as=0 ps=0 w=1u l=1u
X882 a_13100_13686# fanout6.A VPWR VPWR sg13_lv_pmos ad=0.2856p pd=2.36u as=0.2114p ps=1.54u w=0.84u l=0.13u
X883 a_10764_5678# _139_.X VPWR VPWR sg13_lv_pmos ad=0.1596p pd=1.22u as=0.2891p ps=1.695u w=0.84u l=0.13u
X884 VGND VPWR VGND VGND sg13_lv_nmos ad=79.8f pd=0.8u as=0 ps=0 w=0.42u l=1u
X885 a_14534_9186# _213_.Y VPWR VPWR sg13_lv_pmos ad=79.8f pd=0.8u as=0.1428p ps=1.52u w=0.42u l=0.13u
X886 VPWR en a_1192_11460# VPWR sg13_lv_pmos ad=0.2114p pd=1.54u as=0.2856p ps=2.36u w=0.84u l=0.13u
X887 VPWR VGND VPWR VPWR sg13_lv_pmos ad=0.34p pd=2.68u as=0 ps=0 w=1u l=1u
X888 a_16300_12525# a_16240_12430# a_16185_12525# VPWR sg13_lv_pmos ad=0.204p pd=1.835u as=93.45f ps=0.865u w=0.42u l=0.13u
X889 VGND VPWR VGND VGND sg13_lv_nmos ad=0.1428p pd=1.52u as=0 ps=0 w=0.42u l=1u
X890 VPWR VGND VPWR VPWR sg13_lv_pmos ad=0.19p pd=1.38u as=0 ps=0 w=1u l=1u
X891 a_9828_17946# _214_.Y a_9734_17946# VGND sg13_lv_nmos ad=60.89999f pd=0.71u as=0.1428p ps=1.52u w=0.42u l=0.13u
X892 a_2661_12189# _247_.CLK a_3121_12231# VGND sg13_lv_nmos ad=0.2516p pd=2.16u as=0.31732p ps=1.805u w=0.74u l=0.13u
X893 _165_.Y _136_.A VPWR VPWR sg13_lv_pmos ad=0.2128p pd=1.5u as=0.3808p ps=2.92u w=1.12u l=0.13u
X894 a_5619_17044# _207_.A1 VPWR VPWR sg13_lv_pmos ad=0.1428p pd=1.375u as=0.2891p ps=1.695u w=1.12u l=0.13u
X895 VPWR VGND VPWR VPWR sg13_lv_pmos ad=0.19p pd=1.38u as=0 ps=0 w=1u l=1u
X896 clkbuf_1_0__f_sclk.A a_3886_10702# VGND VGND sg13_lv_nmos ad=0.1406p pd=1.12u as=0.1406p ps=1.12u w=0.74u l=0.13u
X897 VGND VPWR VGND VGND sg13_lv_nmos ad=0.1428p pd=1.52u as=0 ps=0 w=0.42u l=1u
X898 VGND a_11279_9263# a_11946_9484# VGND sg13_lv_nmos ad=0.1406p pd=1.12u as=0.2516p ps=2.16u w=0.74u l=0.13u
X899 VPWR _136_.A _173_.Y VPWR sg13_lv_pmos ad=0.3808p pd=2.92u as=0.2128p ps=1.5u w=1.12u l=0.13u
X900 VGND VPWR VGND VGND sg13_lv_nmos ad=79.8f pd=0.8u as=0 ps=0 w=0.42u l=1u
X901 VGND VPWR VGND VGND sg13_lv_nmos ad=79.8f pd=0.8u as=0 ps=0 w=0.42u l=1u
X902 _201_.Y _199_.Y a_6508_15532# VPWR sg13_lv_pmos ad=0.3808p pd=2.92u as=0.1176p ps=1.33u w=1.12u l=0.13u
X903 VPWR VGND VPWR VPWR sg13_lv_pmos ad=0.19p pd=1.38u as=0 ps=0 w=1u l=1u
X904 VPWR _226_.Y a_14438_5850# VPWR sg13_lv_pmos ad=0.36237p pd=2.605u as=79.8f ps=0.8u w=0.42u l=0.13u
X905 VPWR VGND VPWR VPWR sg13_lv_pmos ad=0.34p pd=2.68u as=0 ps=0 w=1u l=1u
X906 VGND VPWR VGND VGND sg13_lv_nmos ad=79.8f pd=0.8u as=0 ps=0 w=0.42u l=1u
X907 VPWR VGND VPWR VPWR sg13_lv_pmos ad=0.34p pd=2.68u as=0 ps=0 w=1u l=1u
X908 VGND a_2171_6204# a_2608_6166# VGND sg13_lv_nmos ad=0.148p pd=1.14u as=0.3367p ps=1.65u w=0.74u l=0.13u
X909 _182_.Y a_8352_11013# a_8501_10702# VGND sg13_lv_nmos ad=0.2516p pd=2.16u as=0.1406p ps=1.12u w=0.74u l=0.13u
X910 VGND VPWR VGND VGND sg13_lv_nmos ad=0.1428p pd=1.52u as=0 ps=0 w=0.42u l=1u
X911 VGND VPWR VGND VGND sg13_lv_nmos ad=0.1428p pd=1.52u as=0 ps=0 w=0.42u l=1u
X912 a_8564_5412# a_8538_5375# _145_.A2 VPWR sg13_lv_pmos ad=0.2128p pd=1.5u as=0.3808p ps=2.92u w=1.12u l=0.13u
X913 VGND VPWR VGND VGND sg13_lv_nmos ad=0.1428p pd=1.52u as=0 ps=0 w=0.42u l=1u
X914 _203_.Y a_7008_16035# a_7157_16366# VGND sg13_lv_nmos ad=0.2516p pd=2.16u as=0.1406p ps=1.12u w=0.74u l=0.13u
X915 VPWR _124_.S a_2075_5468# VPWR sg13_lv_pmos ad=0.253p pd=1.53u as=0.2856p ps=2.36u w=0.84u l=0.13u
X916 clkbuf_1_0__f_sclk.A a_3886_10702# VPWR VPWR sg13_lv_pmos ad=0.2128p pd=1.5u as=0.2128p ps=1.5u w=1.12u l=0.13u
X917 a_9573_12189# _251_.CLK a_10033_12506# VPWR sg13_lv_pmos ad=0.4088p pd=2.97u as=0.41165p ps=2.12u w=1.12u l=0.13u
X918 VGND _214_.A _214_.Y VGND sg13_lv_nmos ad=0.2516p pd=2.16u as=0.2516p ps=2.16u w=0.74u l=0.13u
X919 VGND _193_.Y a_7553_14832# VGND sg13_lv_nmos ad=0.2516p pd=2.16u as=0.1406p ps=1.12u w=0.74u l=0.13u
X920 clkbuf_1_0__f_sclk.A a_3886_10702# VGND VGND sg13_lv_nmos ad=0.1406p pd=1.12u as=0.1406p ps=1.12u w=0.74u l=0.13u
X921 a_3886_10702# sclk VGND VGND sg13_lv_nmos ad=0.1406p pd=1.12u as=0.2516p ps=2.16u w=0.74u l=0.13u
X922 VGND VPWR VGND VGND sg13_lv_nmos ad=79.8f pd=0.8u as=0 ps=0 w=0.42u l=1u
X923 a_15237_8447# _251_.CLK a_15697_8789# VGND sg13_lv_nmos ad=0.2516p pd=2.16u as=0.31732p ps=1.805u w=0.74u l=0.13u
X924 a_13617_4972# _145_.X VPWR VPWR sg13_lv_pmos ad=0.1225p pd=1.245u as=0.36p ps=2.72u w=1u l=0.13u
X925 VGND _260_.RESET_B a_14628_9186# VGND sg13_lv_nmos ad=0.1626p pd=1.415u as=60.89999f ps=0.71u w=0.42u l=0.13u
X926 a_1862_13410# _119_.X VPWR VPWR sg13_lv_pmos ad=79.8f pd=0.8u as=0.1428p ps=1.52u w=0.42u l=0.13u
X927 VGND VPWR VGND VGND sg13_lv_nmos ad=0.1428p pd=1.52u as=0 ps=0 w=0.42u l=1u
X928 VGND VPWR VGND VGND sg13_lv_nmos ad=79.8f pd=0.8u as=0 ps=0 w=0.42u l=1u
X929 VGND _178_.B1 a_6320_10296# VGND sg13_lv_nmos ad=0.1371p pd=1.12u as=0.1216p ps=1.02u w=0.64u l=0.13u
X930 VGND a_15983_12287# a_16650_12508# VGND sg13_lv_nmos ad=0.1406p pd=1.12u as=0.2516p ps=2.16u w=0.74u l=0.13u
X931 VPWR VGND VPWR VPWR sg13_lv_pmos ad=0.34p pd=2.68u as=0 ps=0 w=1u l=1u
X932 a_11652_16759# a_11364_17064# a_11590_16759# VGND sg13_lv_nmos ad=0.1428p pd=1.52u as=37.8f ps=0.6u w=0.42u l=0.13u
X933 a_3300_4968# a_3274_4873# VPWR VPWR sg13_lv_pmos ad=0.34p pd=2.68u as=0.36237p ps=2.605u w=1u l=0.13u
X934 _195_.Y _119_.A0 VPWR VPWR sg13_lv_pmos ad=0.2128p pd=1.5u as=0.3808p ps=2.92u w=1.12u l=0.13u
X935 VGND _199_.Y _201_.Y VGND sg13_lv_nmos ad=0.2516p pd=2.16u as=0.1406p ps=1.12u w=0.74u l=0.13u
X936 VGND en a_1192_11460# VGND sg13_lv_nmos ad=0.14875p pd=1.16u as=0.187p ps=1.78u w=0.55u l=0.13u
X937 VPWR VGND VPWR VPWR sg13_lv_pmos ad=0.19p pd=1.38u as=0 ps=0 w=1u l=1u
X938 VGND VPWR VGND VGND sg13_lv_nmos ad=79.8f pd=0.8u as=0 ps=0 w=0.42u l=1u
X939 a_14724_12528# a_14698_12433# VPWR VPWR sg13_lv_pmos ad=0.34p pd=2.68u as=0.36237p ps=2.605u w=1u l=0.13u
X940 a_7872_5451# _143_.A VPWR VPWR sg13_lv_pmos ad=0.1596p pd=1.22u as=0.4536p ps=2.76u w=0.84u l=0.13u
X941 _160_.B _162_.B a_13338_7690# VGND sg13_lv_nmos ad=0.1628p pd=1.18u as=88.8f ps=0.98u w=0.74u l=0.13u
X942 VPWR VGND VPWR VPWR sg13_lv_pmos ad=0.34p pd=2.68u as=0 ps=0 w=1u l=1u
X943 _136_.A a_8488_8436# VPWR VPWR sg13_lv_pmos ad=0.42p pd=2.99u as=0.2114p ps=1.54u w=1.12u l=0.13u
X944 a_2620_13726# _120_.A0 a_2126_13912# VGND sg13_lv_nmos ad=0.13135p pd=1.095u as=0.1628p ps=1.18u w=0.74u l=0.13u
X945 VGND VPWR VGND VGND sg13_lv_nmos ad=79.8f pd=0.8u as=0 ps=0 w=0.42u l=1u
X946 VPWR a_4559_5773# a_4816_5654# VPWR sg13_lv_pmos ad=0.4659p pd=3.65u as=79.8f ps=0.8u w=0.42u l=0.13u
X947 clkbuf_1_0__f_sclk.A a_3886_10702# VPWR VPWR sg13_lv_pmos ad=0.2128p pd=1.5u as=0.2128p ps=1.5u w=1.12u l=0.13u
X948 a_3886_10702# sclk VPWR VPWR sg13_lv_pmos ad=0.2128p pd=1.5u as=0.3808p ps=2.92u w=1.12u l=0.13u
X949 a_13221_16007# _266_.CLK a_13681_16349# VGND sg13_lv_nmos ad=0.2516p pd=2.16u as=0.31732p ps=1.805u w=0.74u l=0.13u
X950 VGND a_13649_4704# _151_.X VGND sg13_lv_nmos ad=0.3108p pd=2.32u as=0.1628p ps=1.18u w=0.74u l=0.13u
X951 a_3300_5416# a_3274_5380# VGND VGND sg13_lv_nmos ad=0.2516p pd=2.16u as=0.1626p ps=1.415u w=0.74u l=0.13u
X952 a_15861_16904# a_14919_16964# a_15722_16904# VGND sg13_lv_nmos ad=79.8f pd=0.8u as=0.2373p ps=1.97u w=0.42u l=0.13u
X953 _243_.CLK a_3956_6888# VPWR VPWR sg13_lv_pmos ad=0.2128p pd=1.5u as=0.2128p ps=1.5u w=1.12u l=0.13u
X954 a_6890_9948# _177_.X VPWR VPWR sg13_lv_pmos ad=0.1176p pd=1.33u as=0.4032p ps=2.96u w=1.12u l=0.13u
X955 VGND _200_.Y a_6286_15276# VGND sg13_lv_nmos ad=0.17255p pd=1.25u as=0.187p ps=1.78u w=0.55u l=0.13u
X956 _160_.B a_13073_7728# a_13244_7972# VPWR sg13_lv_pmos ad=0.3808p pd=2.92u as=0.2128p ps=1.5u w=1.12u l=0.13u
X957 a_8236_8436# a_8014_8492# VPWR VPWR sg13_lv_pmos ad=0.1176p pd=1.33u as=0.2618p ps=1.63u w=1.12u l=0.13u
X958 VGND _178_.Y _179_.Y VGND sg13_lv_nmos ad=0.2516p pd=2.16u as=0.1406p ps=1.12u w=0.74u l=0.13u
X959 VPWR VGND VPWR VPWR sg13_lv_pmos ad=0.19p pd=1.38u as=0 ps=0 w=1u l=1u
X960 a_2436_13397# a_2667_12983# a_2122_12940# VGND sg13_lv_nmos ad=0.2373p pd=1.97u as=79.8f ps=0.8u w=0.42u l=0.13u
X961 VGND VPWR VGND VGND sg13_lv_nmos ad=79.8f pd=0.8u as=0 ps=0 w=0.42u l=1u
X962 VGND VPWR VGND VGND sg13_lv_nmos ad=0.1428p pd=1.52u as=0 ps=0 w=0.42u l=1u
X963 VPWR VGND VPWR VPWR sg13_lv_pmos ad=0.19p pd=1.38u as=0 ps=0 w=1u l=1u
X964 VPWR a_3956_6888# _243_.CLK VPWR sg13_lv_pmos ad=0.2128p pd=1.5u as=0.2128p ps=1.5u w=1.12u l=0.13u
X965 a_4012_9501# a_3952_9406# a_3897_9501# VPWR sg13_lv_pmos ad=0.204p pd=1.835u as=93.45f ps=0.865u w=0.42u l=0.13u
X966 VPWR _237_.Y a_12518_16434# VPWR sg13_lv_pmos ad=0.36237p pd=2.605u as=79.8f ps=0.8u w=0.42u l=0.13u
X967 a_10901_7678# _154_.X VGND VGND sg13_lv_nmos ad=0.1406p pd=1.12u as=0.1898p ps=1.36u w=0.74u l=0.13u
X968 VPWR _222_.Y a_2122_16969# VPWR sg13_lv_pmos ad=0.1563p pd=1.22u as=0.147p ps=1.54u w=0.42u l=0.13u
X969 VPWR _192_.B _192_.Y VPWR sg13_lv_pmos ad=0.2128p pd=1.5u as=0.2128p ps=1.5u w=1.12u l=0.13u
X970 VPWR _181_.Y a_8352_11013# VPWR sg13_lv_pmos ad=0.2891p pd=1.695u as=0.1596p ps=1.22u w=0.84u l=0.13u
X971 a_5466_9202# _173_.A VGND VGND sg13_lv_nmos ad=88.8f pd=0.98u as=0.15245p ps=1.17u w=0.74u l=0.13u
X972 VGND VPWR VGND VGND sg13_lv_nmos ad=0.1428p pd=1.52u as=0 ps=0 w=0.42u l=1u
X973 a_3717_4629# _243_.CLK a_4177_4946# VPWR sg13_lv_pmos ad=0.4088p pd=2.97u as=0.41165p ps=2.12u w=1.12u l=0.13u
X974 a_3025_15998# a_2565_16007# a_2667_16007# VPWR sg13_lv_pmos ad=0.41165p pd=2.12u as=0.3864p ps=2.93u w=1.12u l=0.13u
X975 VPWR VGND VPWR VPWR sg13_lv_pmos ad=0.34p pd=2.68u as=0 ps=0 w=1u l=1u
X976 VGND VPWR VGND VGND sg13_lv_nmos ad=79.8f pd=0.8u as=0 ps=0 w=0.42u l=1u
X977 VPWR VGND VPWR VPWR sg13_lv_pmos ad=0.34p pd=2.68u as=0 ps=0 w=1u l=1u
X978 VPWR a_16079_11821# a_16746_11460# VPWR sg13_lv_pmos ad=0.2128p pd=1.5u as=0.3864p ps=2.93u w=1.12u l=0.13u
X979 _205_.Y _191_.Y a_6862_15260# VGND sg13_lv_nmos ad=0.2516p pd=2.16u as=0.1406p ps=1.12u w=0.74u l=0.13u
X980 VGND VPWR VGND VGND sg13_lv_nmos ad=0.1428p pd=1.52u as=0 ps=0 w=0.42u l=1u
X981 VGND clkbuf_1_0__f_sclk.A a_3956_6888# VGND sg13_lv_nmos ad=0.1406p pd=1.12u as=0.1406p ps=1.12u w=0.74u l=0.13u
X982 a_9994_9409# a_10437_9165# a_9734_9186# VGND sg13_lv_nmos ad=79.8f pd=0.8u as=0.1296p ps=1.52u w=0.42u l=0.13u
X983 VPWR a_1580_12936# _215_.A VPWR sg13_lv_pmos ad=0.2114p pd=1.54u as=0.42p ps=2.99u w=1.12u l=0.13u
X984 a_2985_3947# a_2628_3904# VPWR VPWR sg13_lv_pmos ad=63f pd=0.72u as=0.1563p ps=1.22u w=0.42u l=0.13u
X985 VPWR rst a_1192_17508# VPWR sg13_lv_pmos ad=0.2114p pd=1.54u as=0.2856p ps=2.36u w=0.84u l=0.13u
X986 VPWR a_3380_13690# _247_.CLK VPWR sg13_lv_pmos ad=0.2128p pd=1.5u as=0.2128p ps=1.5u w=1.12u l=0.13u
X987 VPWR a_12215_7664# _164_.B1 VPWR sg13_lv_pmos ad=0.3808p pd=2.92u as=0.2128p ps=1.5u w=1.12u l=0.13u
X988 VPWR _196_.Y a_5333_15532# VPWR sg13_lv_pmos ad=0.2128p pd=1.5u as=0.3808p ps=2.92u w=1.12u l=0.13u
X989 _133_.B a_16266_15532# VGND VGND sg13_lv_nmos ad=0.2516p pd=2.16u as=0.1406p ps=1.12u w=0.74u l=0.13u
X990 VGND VPWR VGND VGND sg13_lv_nmos ad=79.8f pd=0.8u as=0 ps=0 w=0.42u l=1u
X991 VGND VPWR VGND VGND sg13_lv_nmos ad=0.1428p pd=1.52u as=0 ps=0 w=0.42u l=1u
X992 _243_.CLK a_3956_6888# VGND VGND sg13_lv_nmos ad=0.1406p pd=1.12u as=0.1406p ps=1.12u w=0.74u l=0.13u
X993 VPWR _202_.Y a_7008_16035# VPWR sg13_lv_pmos ad=0.2891p pd=1.695u as=0.1596p ps=1.22u w=0.84u l=0.13u
X994 VGND VPWR VGND VGND sg13_lv_nmos ad=0.1428p pd=1.52u as=0 ps=0 w=0.42u l=1u
X995 VPWR VGND VPWR VPWR sg13_lv_pmos ad=0.34p pd=2.68u as=0 ps=0 w=1u l=1u
X996 VGND VPWR VGND VGND sg13_lv_nmos ad=0.1428p pd=1.52u as=0 ps=0 w=0.42u l=1u
X997 VPWR _148_.B _187_.Y VPWR sg13_lv_pmos ad=0.3808p pd=2.92u as=0.2128p ps=1.5u w=1.12u l=0.13u
X998 a_10415_12287# a_9573_12189# a_10321_12287# VGND sg13_lv_nmos ad=0.12665p pd=1.145u as=0.1428p ps=1.52u w=0.42u l=0.13u
X999 VGND VPWR VGND VGND sg13_lv_nmos ad=0.1428p pd=1.52u as=0 ps=0 w=0.42u l=1u
X1000 VPWR _244_.RESET_B a_3014_5850# VPWR sg13_lv_pmos ad=0.36237p pd=2.605u as=79.8f ps=0.8u w=0.42u l=0.13u
X1001 _173_.A a_4362_9484# VPWR VPWR sg13_lv_pmos ad=0.3808p pd=2.92u as=0.2128p ps=1.5u w=1.12u l=0.13u
X1002 a_2148_12976# a_2667_12983# a_3407_13333# VGND sg13_lv_nmos ad=0.3473p pd=2.71u as=0.12665p ps=1.145u w=0.74u l=0.13u
X1003 a_14438_5850# a_15243_5423# a_14698_5380# VPWR sg13_lv_pmos ad=0.1428p pd=1.52u as=79.8f ps=0.8u w=0.42u l=0.13u
X1004 a_6299_11808# _176_.A VGND VGND sg13_lv_nmos ad=78.39999f pd=0.885u as=0.2272p ps=1.99u w=0.64u l=0.13u
X1005 VGND VPWR VGND VGND sg13_lv_nmos ad=0.1428p pd=1.52u as=0 ps=0 w=0.42u l=1u
X1006 VGND VPWR VGND VGND sg13_lv_nmos ad=79.8f pd=0.8u as=0 ps=0 w=0.42u l=1u
X1007 VGND a_3956_6888# _243_.CLK VGND sg13_lv_nmos ad=0.1406p pd=1.12u as=0.1406p ps=1.12u w=0.74u l=0.13u
X1008 VGND VPWR VGND VGND sg13_lv_nmos ad=79.8f pd=0.8u as=0 ps=0 w=0.42u l=1u
X1009 VPWR a_3407_16357# a_4074_15996# VPWR sg13_lv_pmos ad=0.2128p pd=1.5u as=0.3864p ps=2.93u w=1.12u l=0.13u
X1010 VGND _258_.RESET_B a_7716_16434# VGND sg13_lv_nmos ad=0.1626p pd=1.415u as=60.89999f ps=0.71u w=0.42u l=0.13u
X1011 VPWR a_3380_13690# _247_.CLK VPWR sg13_lv_pmos ad=0.2128p pd=1.5u as=0.2128p ps=1.5u w=1.12u l=0.13u
X1012 a_13391_12287# a_12549_12189# a_12132_12528# VPWR sg13_lv_pmos ad=0.2048p pd=1.63u as=0.34p ps=2.68u w=1u l=0.13u
X1013 VPWR a_3695_8797# a_4362_8436# VPWR sg13_lv_pmos ad=0.2128p pd=1.5u as=0.3864p ps=2.93u w=1.12u l=0.13u
X1014 VPWR a_14240_16921# _135_.A VPWR sg13_lv_pmos ad=0.2128p pd=1.5u as=0.3808p ps=2.92u w=1.12u l=0.13u
X1015 VPWR VGND VPWR VPWR sg13_lv_pmos ad=0.34p pd=2.68u as=0 ps=0 w=1u l=1u
X1016 VGND VPWR VGND VGND sg13_lv_nmos ad=0.1428p pd=1.52u as=0 ps=0 w=0.42u l=1u
X1017 VPWR VGND VPWR VPWR sg13_lv_pmos ad=0.19p pd=1.38u as=0 ps=0 w=1u l=1u
X1018 VGND VPWR VGND VGND sg13_lv_nmos ad=79.8f pd=0.8u as=0 ps=0 w=0.42u l=1u
X1019 VGND VPWR VGND VGND sg13_lv_nmos ad=79.8f pd=0.8u as=0 ps=0 w=0.42u l=1u
X1020 a_13042_16746# _241_.Y VGND VGND sg13_lv_nmos ad=37.8f pd=0.6u as=79.8f ps=0.8u w=0.42u l=0.13u
X1021 a_8785_15998# a_8325_16007# a_8427_16007# VPWR sg13_lv_pmos ad=0.41165p pd=2.12u as=0.3864p ps=2.93u w=1.12u l=0.13u
X1022 VGND a_5297_12264# _176_.B VGND sg13_lv_nmos ad=0.3108p pd=2.32u as=0.1628p ps=1.18u w=0.74u l=0.13u
X1023 VPWR VGND VPWR VPWR sg13_lv_pmos ad=0.34p pd=2.68u as=0 ps=0 w=1u l=1u
X1024 VPWR VGND VPWR VPWR sg13_lv_pmos ad=0.19p pd=1.38u as=0 ps=0 w=1u l=1u
X1025 a_9363_9484# _164_.Y VPWR VPWR sg13_lv_pmos ad=0.1428p pd=1.375u as=0.2891p ps=1.695u w=1.12u l=0.13u
X1026 VGND a_16079_11821# a_16746_11460# VGND sg13_lv_nmos ad=0.1406p pd=1.12u as=0.2516p ps=2.16u w=0.74u l=0.13u
X1027 VGND a_3380_13690# _247_.CLK VGND sg13_lv_nmos ad=0.1406p pd=1.12u as=0.1406p ps=1.12u w=0.74u l=0.13u
X1028 a_2724_8861# a_2955_8447# a_2410_8404# VGND sg13_lv_nmos ad=0.2373p pd=1.97u as=79.8f ps=0.8u w=0.42u l=0.13u
X1029 VGND VPWR VGND VGND sg13_lv_nmos ad=0.1428p pd=1.52u as=0 ps=0 w=0.42u l=1u
X1030 a_11536_9406# a_11279_9263# a_11698_9186# VGND sg13_lv_nmos ad=0.1428p pd=1.52u as=37.8f ps=0.6u w=0.42u l=0.13u
X1031 a_11078_16746# a_11883_16868# a_11338_16969# VPWR sg13_lv_pmos ad=0.1428p pd=1.52u as=79.8f ps=0.8u w=0.42u l=0.13u
X1032 a_13092_16421# a_13323_16007# a_12778_15964# VGND sg13_lv_nmos ad=0.2373p pd=1.97u as=79.8f ps=0.8u w=0.42u l=0.13u
X1033 a_3014_4650# a_3819_4772# a_3274_4873# VPWR sg13_lv_pmos ad=0.1428p pd=1.52u as=79.8f ps=0.8u w=0.42u l=0.13u
X1034 VPWR VGND VPWR VPWR sg13_lv_pmos ad=0.34p pd=2.68u as=0 ps=0 w=1u l=1u
X1035 a_8196_16421# a_7908_16000# a_8134_16421# VGND sg13_lv_nmos ad=0.1428p pd=1.52u as=37.8f ps=0.6u w=0.42u l=0.13u
X1036 VPWR VGND VPWR VPWR sg13_lv_pmos ad=0.34p pd=2.68u as=0 ps=0 w=1u l=1u
X1037 VGND VPWR VGND VGND sg13_lv_nmos ad=79.8f pd=0.8u as=0 ps=0 w=0.42u l=1u
X1038 VGND _179_.Y a_8506_10318# VGND sg13_lv_nmos ad=0.2516p pd=2.16u as=0.1406p ps=1.12u w=0.74u l=0.13u
X1039 a_9444_13735# a_9156_14040# a_9382_13735# VGND sg13_lv_nmos ad=0.1428p pd=1.52u as=37.8f ps=0.6u w=0.42u l=0.13u
X1040 a_3025_13325# a_2565_12983# a_2667_12983# VGND sg13_lv_nmos ad=0.31732p pd=1.805u as=0.2516p ps=2.16u w=0.74u l=0.13u
X1041 VPWR VGND VPWR VPWR sg13_lv_pmos ad=0.34p pd=2.68u as=0 ps=0 w=1u l=1u
X1042 VPWR VGND VPWR VPWR sg13_lv_pmos ad=0.19p pd=1.38u as=0 ps=0 w=1u l=1u
X1043 a_3380_13690# clkbuf_1_0__f_sclk.A VPWR VPWR sg13_lv_pmos ad=0.2128p pd=1.5u as=0.2128p ps=1.5u w=1.12u l=0.13u
X1044 VGND VPWR VGND VGND sg13_lv_nmos ad=79.8f pd=0.8u as=0 ps=0 w=0.42u l=1u
X1045 VGND a_3503_12287# a_4170_12508# VGND sg13_lv_nmos ad=0.1406p pd=1.12u as=0.2516p ps=2.16u w=0.74u l=0.13u
X1046 a_11846_12210# a_12651_12332# a_12106_12433# VPWR sg13_lv_pmos ad=0.1428p pd=1.52u as=79.8f ps=0.8u w=0.42u l=0.13u
X1047 _227_.Y _225_.A VGND VGND sg13_lv_nmos ad=0.2516p pd=2.16u as=0.2516p ps=2.16u w=0.74u l=0.13u
X1048 VGND VPWR VGND VGND sg13_lv_nmos ad=0.1428p pd=1.52u as=0 ps=0 w=0.42u l=1u
X1049 _209_.Y _208_.X a_6963_17044# VPWR sg13_lv_pmos ad=0.2408p pd=1.55u as=0.1428p ps=1.375u w=1.12u l=0.13u
X1050 a_10995_7972# _166_.A VPWR VPWR sg13_lv_pmos ad=0.1428p pd=1.375u as=0.2891p ps=1.695u w=1.12u l=0.13u
X1051 a_4114_9186# _219_.Y VGND VGND sg13_lv_nmos ad=37.8f pd=0.6u as=79.8f ps=0.8u w=0.42u l=0.13u
X1052 VPWR VGND VPWR VPWR sg13_lv_pmos ad=0.34p pd=2.68u as=0 ps=0 w=1u l=1u
X1053 VPWR VGND VPWR VPWR sg13_lv_pmos ad=0.34p pd=2.68u as=0 ps=0 w=1u l=1u
X1054 a_5249_16344# _207_.A1 _207_.Y VGND sg13_lv_nmos ad=0.1406p pd=1.12u as=0.1406p ps=1.12u w=0.74u l=0.13u
X1055 a_13708_12525# a_13648_12430# a_13593_12525# VPWR sg13_lv_pmos ad=0.204p pd=1.835u as=93.45f ps=0.865u w=0.42u l=0.13u
X1056 _252_.D a_7872_5451# a_8021_5782# VGND sg13_lv_nmos ad=0.2516p pd=2.16u as=0.1406p ps=1.12u w=0.74u l=0.13u
X1057 VGND a_16336_11702# a_15985_11821# VGND sg13_lv_nmos ad=79.8f pd=0.8u as=0.1428p ps=1.52u w=0.42u l=0.13u
X1058 VPWR VGND VPWR VPWR sg13_lv_pmos ad=0.34p pd=2.68u as=0 ps=0 w=1u l=1u
X1059 VGND _205_.Y a_6869_16750# VGND sg13_lv_nmos ad=0.1898p pd=1.36u as=0.2516p ps=2.16u w=0.74u l=0.13u
X1060 VGND VPWR VGND VGND sg13_lv_nmos ad=79.8f pd=0.8u as=0 ps=0 w=0.42u l=1u
X1061 _189_.X a_4913_13330# a_5084_12972# VPWR sg13_lv_pmos ad=0.3808p pd=2.92u as=0.2128p ps=1.5u w=1.12u l=0.13u
X1062 VGND _136_.A a_10769_4258# VGND sg13_lv_nmos ad=0.15245p pd=1.17u as=0.17462p ps=1.185u w=0.55u l=0.13u
X1063 VGND VPWR VGND VGND sg13_lv_nmos ad=0.1428p pd=1.52u as=0 ps=0 w=0.42u l=1u
X1064 _148_.X a_12401_4704# a_12572_4948# VPWR sg13_lv_pmos ad=0.3808p pd=2.92u as=0.2128p ps=1.5u w=1.12u l=0.13u
X1065 VPWR VGND VPWR VPWR sg13_lv_pmos ad=0.19p pd=1.38u as=0 ps=0 w=1u l=1u
X1066 a_3380_13690# clkbuf_1_0__f_sclk.A VPWR VPWR sg13_lv_pmos ad=0.2128p pd=1.5u as=0.2128p ps=1.5u w=1.12u l=0.13u
X1067 a_13073_5770# _147_.Y VGND VGND sg13_lv_nmos ad=0.17462p pd=1.185u as=0.374p ps=2.46u w=0.55u l=0.13u
X1068 a_3897_8559# a_2955_8447# a_3695_8797# VPWR sg13_lv_pmos ad=93.45f pd=0.865u as=0.2048p ps=1.63u w=0.42u l=0.13u
X1069 VPWR VGND VPWR VPWR sg13_lv_pmos ad=0.34p pd=2.68u as=0 ps=0 w=1u l=1u
X1070 VPWR _219_.Y a_2410_9409# VPWR sg13_lv_pmos ad=0.1563p pd=1.22u as=0.147p ps=1.54u w=0.42u l=0.13u
X1071 a_10308_17933# a_10020_17512# a_10246_17933# VGND sg13_lv_nmos ad=0.1428p pd=1.52u as=37.8f ps=0.6u w=0.42u l=0.13u
X1072 a_2126_15424# _119_.A0 a_2298_15532# VPWR sg13_lv_pmos ad=0.2225p pd=1.445u as=0.2975p ps=1.595u w=1u l=0.13u
X1073 _203_.Y _202_.Y a_7251_15996# VPWR sg13_lv_pmos ad=0.2408p pd=1.55u as=0.1428p ps=1.375u w=1.12u l=0.13u
X1074 VPWR VGND VPWR VPWR sg13_lv_pmos ad=0.19p pd=1.38u as=0 ps=0 w=1u l=1u
X1075 a_14794_9409# a_15237_9165# a_14534_9186# VGND sg13_lv_nmos ad=79.8f pd=0.8u as=0.1296p ps=1.52u w=0.42u l=0.13u
X1076 _145_.X a_8557_4248# VPWR VPWR sg13_lv_pmos ad=0.2128p pd=1.5u as=0.3808p ps=2.92u w=1.12u l=0.13u
X1077 VGND VPWR VGND VGND sg13_lv_nmos ad=79.8f pd=0.8u as=0 ps=0 w=0.42u l=1u
X1078 a_4177_5765# a_3717_5423# a_3819_5423# VGND sg13_lv_nmos ad=0.31732p pd=1.805u as=0.2516p ps=2.16u w=0.74u l=0.13u
X1079 VGND VPWR VGND VGND sg13_lv_nmos ad=79.8f pd=0.8u as=0 ps=0 w=0.42u l=1u
X1080 VGND VPWR VGND VGND sg13_lv_nmos ad=0.1428p pd=1.52u as=0 ps=0 w=0.42u l=1u
X1081 VPWR VGND VPWR VPWR sg13_lv_pmos ad=0.19p pd=1.38u as=0 ps=0 w=1u l=1u
X1082 a_2298_17878# a_2232_17770# VGND VGND sg13_lv_nmos ad=0.3367p pd=1.65u as=0.148p ps=1.14u w=0.74u l=0.13u
X1083 _247_.CLK a_3380_13690# VGND VGND sg13_lv_nmos ad=0.1406p pd=1.12u as=0.1406p ps=1.12u w=0.74u l=0.13u
X1084 a_4876_4965# a_4816_4870# a_4761_4965# VPWR sg13_lv_pmos ad=0.204p pd=1.835u as=93.45f ps=0.865u w=0.42u l=0.13u
X1085 _226_.Y _225_.A VPWR VPWR sg13_lv_pmos ad=0.3808p pd=2.92u as=0.3808p ps=2.92u w=1.12u l=0.13u
X1086 a_12804_16000# a_13323_16007# a_14063_16357# VGND sg13_lv_nmos ad=0.3473p pd=2.71u as=0.12665p ps=1.145u w=0.74u l=0.13u
X1087 VPWR VGND VPWR VPWR sg13_lv_pmos ad=0.19p pd=1.38u as=0 ps=0 w=1u l=1u
X1088 VGND VPWR VGND VGND sg13_lv_nmos ad=0.1428p pd=1.52u as=0 ps=0 w=0.42u l=1u
X1089 VPWR VGND VPWR VPWR sg13_lv_pmos ad=0.19p pd=1.38u as=0 ps=0 w=1u l=1u
X1090 VGND VPWR VGND VGND sg13_lv_nmos ad=79.8f pd=0.8u as=0 ps=0 w=0.42u l=1u
X1091 VPWR a_2171_6204# a_2671_6460# VPWR sg13_lv_pmos ad=0.2198p pd=1.52u as=0.2975p ps=1.595u w=1u l=0.13u
X1092 VGND VPWR VGND VGND sg13_lv_nmos ad=0.1428p pd=1.52u as=0 ps=0 w=0.42u l=1u
X1093 a_2232_10210# _124_.S VGND VGND sg13_lv_nmos ad=0.187p pd=1.78u as=0.18945p ps=1.27u w=0.55u l=0.13u
X1094 VPWR VGND VPWR VPWR sg13_lv_pmos ad=0.34p pd=2.68u as=0 ps=0 w=1u l=1u
X1095 VGND VPWR VGND VGND sg13_lv_nmos ad=0.1428p pd=1.52u as=0 ps=0 w=0.42u l=1u
X1096 a_10033_12506# a_9573_12189# a_9675_12332# VPWR sg13_lv_pmos ad=0.41165p pd=2.12u as=0.3864p ps=2.93u w=1.12u l=0.13u
X1097 a_3300_4968# a_3819_4772# a_4559_4727# VGND sg13_lv_nmos ad=0.3473p pd=2.71u as=0.12665p ps=1.145u w=0.74u l=0.13u
X1098 a_14054_15234# a_14859_15356# a_14314_15457# VPWR sg13_lv_pmos ad=0.1428p pd=1.52u as=79.8f ps=0.8u w=0.42u l=0.13u
X1099 _131_.A2 a_16650_12508# VGND VGND sg13_lv_nmos ad=0.2516p pd=2.16u as=0.1406p ps=1.12u w=0.74u l=0.13u
X1100 VGND VPWR VGND VGND sg13_lv_nmos ad=0.1428p pd=1.52u as=0 ps=0 w=0.42u l=1u
X1101 VPWR VGND VPWR VPWR sg13_lv_pmos ad=0.34p pd=2.68u as=0 ps=0 w=1u l=1u
X1102 VGND VPWR VGND VGND sg13_lv_nmos ad=0.1428p pd=1.52u as=0 ps=0 w=0.42u l=1u
X1103 VGND VPWR VGND VGND sg13_lv_nmos ad=79.8f pd=0.8u as=0 ps=0 w=0.42u l=1u
X1104 VGND VPWR VGND VGND sg13_lv_nmos ad=0.1428p pd=1.52u as=0 ps=0 w=0.42u l=1u
X1105 _200_.Y _199_.B1 VPWR VPWR sg13_lv_pmos ad=0.2128p pd=1.5u as=0.3808p ps=2.92u w=1.12u l=0.13u
X1106 VGND VPWR VGND VGND sg13_lv_nmos ad=79.8f pd=0.8u as=0 ps=0 w=0.42u l=1u
X1107 a_9765_4629# _251_.CLK a_10225_4671# VGND sg13_lv_nmos ad=0.2516p pd=2.16u as=0.31732p ps=1.805u w=0.74u l=0.13u
X1108 a_8386_3900# _143_.Y VPWR VPWR sg13_lv_pmos ad=0.2125p pd=1.425u as=0.19p ps=1.38u w=1u l=0.13u
X1109 VPWR VGND VPWR VPWR sg13_lv_pmos ad=0.19p pd=1.38u as=0 ps=0 w=1u l=1u
X1110 a_10437_17519# freq_in a_10897_17510# VPWR sg13_lv_pmos ad=0.4088p pd=2.97u as=0.41165p ps=2.12u w=1.12u l=0.13u
X1111 a_16185_12525# a_15243_12332# a_15983_12287# VPWR sg13_lv_pmos ad=93.45f pd=0.865u as=0.2048p ps=1.63u w=0.42u l=0.13u
X1112 a_13681_16349# a_13221_16007# a_13323_16007# VGND sg13_lv_nmos ad=0.31732p pd=1.805u as=0.2516p ps=2.16u w=0.74u l=0.13u
X1113 VPWR VGND VPWR VPWR sg13_lv_pmos ad=0.19p pd=1.38u as=0 ps=0 w=1u l=1u
X1114 a_16336_9406# a_16079_9263# a_16498_9186# VGND sg13_lv_nmos ad=0.1428p pd=1.52u as=37.8f ps=0.6u w=0.42u l=0.13u
X1115 VPWR VGND VPWR VPWR sg13_lv_pmos ad=0.34p pd=2.68u as=0 ps=0 w=1u l=1u
X1116 VGND _126_.B1 a_13985_11808# VGND sg13_lv_nmos ad=0.2516p pd=2.16u as=0.1406p ps=1.12u w=0.74u l=0.13u
X1117 a_7251_10296# _184_.Y VGND VGND sg13_lv_nmos ad=0.1406p pd=1.12u as=0.2516p ps=2.16u w=0.74u l=0.13u
X1118 VGND a_10672_13942# a_10321_13799# VGND sg13_lv_nmos ad=79.8f pd=0.8u as=0.1428p ps=1.52u w=0.42u l=0.13u
X1119 a_9573_13701# fanout7.A a_10033_13743# VGND sg13_lv_nmos ad=0.2516p pd=2.16u as=0.31732p ps=1.805u w=0.74u l=0.13u
X1120 a_10308_9199# a_10020_9504# a_10246_9199# VGND sg13_lv_nmos ad=0.1428p pd=1.52u as=37.8f ps=0.6u w=0.42u l=0.13u
X1121 _207_.A2 fanout6.A a_4755_17508# VPWR sg13_lv_pmos ad=0.2408p pd=1.55u as=0.1428p ps=1.375u w=1.12u l=0.13u
X1122 a_2148_17064# a_2122_16969# VGND VGND sg13_lv_nmos ad=0.2516p pd=2.16u as=0.1626p ps=1.415u w=0.74u l=0.13u
X1123 VPWR clkbuf_1_0__f_sclk.A a_3956_6888# VPWR sg13_lv_pmos ad=0.2128p pd=1.5u as=0.2128p ps=1.5u w=1.12u l=0.13u
X1124 VGND VPWR VGND VGND sg13_lv_nmos ad=0.1428p pd=1.52u as=0 ps=0 w=0.42u l=1u
X1125 VGND _161_.Y a_12685_7700# VGND sg13_lv_nmos ad=0.2516p pd=2.16u as=94.35f ps=0.995u w=0.74u l=0.13u
X1126 a_11731_8698# _164_.B1 VGND VGND sg13_lv_nmos ad=0.1216p pd=1.02u as=0.15745p ps=1.175u w=0.64u l=0.13u
X1127 _206_.Y fanout6.A a_4684_15996# VPWR sg13_lv_pmos ad=0.3808p pd=2.92u as=0.1176p ps=1.33u w=1.12u l=0.13u
X1128 _192_.Y _187_.Y VPWR VPWR sg13_lv_pmos ad=0.3808p pd=2.92u as=0.2128p ps=1.5u w=1.12u l=0.13u
X1129 VPWR a_13391_12287# a_14058_12508# VPWR sg13_lv_pmos ad=0.2128p pd=1.5u as=0.3864p ps=2.93u w=1.12u l=0.13u
X1130 a_10672_13942# a_10415_13799# a_10834_13722# VGND sg13_lv_nmos ad=0.1428p pd=1.52u as=37.8f ps=0.6u w=0.42u l=0.13u
X1131 a_9156_12528# a_9675_12332# a_10415_12287# VGND sg13_lv_nmos ad=0.3473p pd=2.71u as=0.12665p ps=1.145u w=0.74u l=0.13u
X1132 VPWR _229_.Y a_8870_12210# VPWR sg13_lv_pmos ad=0.36237p pd=2.605u as=79.8f ps=0.8u w=0.42u l=0.13u
X1133 a_6485_11830# _176_.B VGND VGND sg13_lv_nmos ad=0.1406p pd=1.12u as=0.1898p ps=1.36u w=0.74u l=0.13u
X1134 VGND VPWR VGND VGND sg13_lv_nmos ad=0.1428p pd=1.52u as=0 ps=0 w=0.42u l=1u
X1135 VGND VPWR VGND VGND sg13_lv_nmos ad=79.8f pd=0.8u as=0 ps=0 w=0.42u l=1u
X1136 a_10220_18222# _225_.A VGND VGND sg13_lv_nmos ad=0.187p pd=1.78u as=0.14875p ps=1.16u w=0.55u l=0.13u
X1137 a_13740_5678# _148_.X VPWR VPWR sg13_lv_pmos ad=0.1596p pd=1.22u as=0.2891p ps=1.695u w=0.84u l=0.13u
X1138 VPWR VGND VPWR VPWR sg13_lv_pmos ad=0.19p pd=1.38u as=0 ps=0 w=1u l=1u
X1139 VPWR VGND VPWR VPWR sg13_lv_pmos ad=0.19p pd=1.38u as=0 ps=0 w=1u l=1u
X1140 a_8870_13722# a_9675_13844# a_9130_13945# VPWR sg13_lv_pmos ad=0.1428p pd=1.52u as=79.8f ps=0.8u w=0.42u l=0.13u
X1141 VPWR VGND VPWR VPWR sg13_lv_pmos ad=0.19p pd=1.38u as=0 ps=0 w=1u l=1u
X1142 _243_.CLK a_3956_6888# VPWR VPWR sg13_lv_pmos ad=0.2128p pd=1.5u as=0.2128p ps=1.5u w=1.12u l=0.13u
X1143 VGND VPWR VGND VGND sg13_lv_nmos ad=0.1428p pd=1.52u as=0 ps=0 w=0.42u l=1u
X1144 a_3505_3902# a_3045_3911# a_3147_3911# VPWR sg13_lv_pmos ad=0.41165p pd=2.12u as=0.3864p ps=2.93u w=1.12u l=0.13u
X1145 VPWR VGND VPWR VPWR sg13_lv_pmos ad=0.19p pd=1.38u as=0 ps=0 w=1u l=1u
X1146 VGND VPWR VGND VGND sg13_lv_nmos ad=79.8f pd=0.8u as=0 ps=0 w=0.42u l=1u
X1147 a_10924_4965# a_10864_4870# a_10809_4965# VPWR sg13_lv_pmos ad=0.204p pd=1.835u as=93.45f ps=0.865u w=0.42u l=0.13u
X1148 _170_.Y _165_.Y VPWR VPWR sg13_lv_pmos ad=0.3808p pd=2.92u as=0.2128p ps=1.5u w=1.12u l=0.13u
X1149 a_7622_16434# _203_.Y VPWR VPWR sg13_lv_pmos ad=79.8f pd=0.8u as=0.1428p ps=1.52u w=0.42u l=0.13u
X1150 VGND VPWR VGND VGND sg13_lv_nmos ad=79.8f pd=0.8u as=0 ps=0 w=0.42u l=1u
X1151 VGND VPWR VGND VGND sg13_lv_nmos ad=79.8f pd=0.8u as=0 ps=0 w=0.42u l=1u
X1152 VGND a_5201_9240# _168_.B VGND sg13_lv_nmos ad=0.3108p pd=2.32u as=0.1628p ps=1.18u w=0.74u l=0.13u
X1153 VPWR VGND VPWR VPWR sg13_lv_pmos ad=0.19p pd=1.38u as=0 ps=0 w=1u l=1u
X1154 a_5297_12264# _148_.B a_5265_12532# VPWR sg13_lv_pmos ad=0.34p pd=2.68u as=0.1225p ps=1.245u w=1u l=0.13u
X1155 a_10672_12430# _229_.Y a_10732_12525# VPWR sg13_lv_pmos ad=79.8f pd=0.8u as=0.204p ps=1.835u w=0.42u l=0.13u
X1156 VGND VPWR VGND VGND sg13_lv_nmos ad=79.8f pd=0.8u as=0 ps=0 w=0.42u l=1u
X1157 a_6836_3900# _136_.A VPWR VPWR sg13_lv_pmos ad=0.3808p pd=2.92u as=0.2128p ps=1.5u w=1.12u l=0.13u
X1158 VPWR VGND VPWR VPWR sg13_lv_pmos ad=0.19p pd=1.38u as=0 ps=0 w=1u l=1u
X1159 _154_.X _136_.A a_8250_7690# VGND sg13_lv_nmos ad=0.1628p pd=1.18u as=88.8f ps=0.98u w=0.74u l=0.13u
X1160 a_7008_16035# _202_.Y a_6971_16344# VGND sg13_lv_nmos ad=0.2176p pd=1.96u as=78.39999f ps=0.885u w=0.64u l=0.13u
X1161 VGND VPWR VGND VGND sg13_lv_nmos ad=79.8f pd=0.8u as=0 ps=0 w=0.42u l=1u
X1162 VGND VPWR VGND VGND sg13_lv_nmos ad=79.8f pd=0.8u as=0 ps=0 w=0.42u l=1u
X1163 a_14148_15234# _135_.A a_14054_15234# VGND sg13_lv_nmos ad=60.89999f pd=0.71u as=0.1428p ps=1.52u w=0.42u l=0.13u
X1164 VGND a_10415_12287# a_11082_12508# VGND sg13_lv_nmos ad=0.1406p pd=1.12u as=0.2516p ps=2.16u w=0.74u l=0.13u
X1165 VPWR a_3956_6888# _243_.CLK VPWR sg13_lv_pmos ad=0.2128p pd=1.5u as=0.2128p ps=1.5u w=1.12u l=0.13u
X1166 a_5468_12508# _148_.B VPWR VPWR sg13_lv_pmos ad=0.2128p pd=1.5u as=0.2128p ps=1.5u w=1.12u l=0.13u
X1167 a_11034_4258# _243_.Q VGND VGND sg13_lv_nmos ad=88.8f pd=0.98u as=0.15245p ps=1.17u w=0.74u l=0.13u
X1168 VPWR VGND VPWR VPWR sg13_lv_pmos ad=0.34p pd=2.68u as=0 ps=0 w=1u l=1u
X1169 VPWR VGND VPWR VPWR sg13_lv_pmos ad=0.34p pd=2.68u as=0 ps=0 w=1u l=1u
X1170 a_9348_4968# a_9867_4772# a_10607_4727# VGND sg13_lv_nmos ad=0.3473p pd=2.71u as=0.12665p ps=1.145u w=0.74u l=0.13u
X1171 _144_.Y _144_.B a_9290_3900# VPWR sg13_lv_pmos ad=0.3808p pd=2.92u as=0.1176p ps=1.33u w=1.12u l=0.13u
X1172 VPWR VGND VPWR VPWR sg13_lv_pmos ad=0.34p pd=2.68u as=0 ps=0 w=1u l=1u
X1173 VPWR VGND VPWR VPWR sg13_lv_pmos ad=0.34p pd=2.68u as=0 ps=0 w=1u l=1u
X1174 a_2298_9972# a_2232_10210# VPWR VPWR sg13_lv_pmos ad=0.2975p pd=1.595u as=0.2198p ps=1.52u w=1u l=0.13u
X1175 _154_.X a_7985_7728# a_8156_7972# VPWR sg13_lv_pmos ad=0.3808p pd=2.92u as=0.2128p ps=1.5u w=1.12u l=0.13u
X1176 a_6756_4663# a_6987_4772# a_6442_4873# VGND sg13_lv_nmos ad=0.2373p pd=1.97u as=79.8f ps=0.8u w=0.42u l=0.13u
X1177 VGND VPWR VGND VGND sg13_lv_nmos ad=0.1428p pd=1.52u as=0 ps=0 w=0.42u l=1u
X1178 _152_.X a_12237_5760# VPWR VPWR sg13_lv_pmos ad=0.3808p pd=2.92u as=0.1918p ps=1.5u w=1.12u l=0.13u
X1179 _164_.Y _164_.B1 VGND VGND sg13_lv_nmos ad=0.1406p pd=1.12u as=0.1406p ps=1.12u w=0.74u l=0.13u
X1180 VPWR VGND VPWR VPWR sg13_lv_pmos ad=0.34p pd=2.68u as=0 ps=0 w=1u l=1u
X1181 VPWR VGND VPWR VPWR sg13_lv_pmos ad=0.34p pd=2.68u as=0 ps=0 w=1u l=1u
X1182 VPWR VGND VPWR VPWR sg13_lv_pmos ad=0.34p pd=2.68u as=0 ps=0 w=1u l=1u
X1183 a_16240_12430# a_15983_12287# a_16402_12210# VGND sg13_lv_nmos ad=0.1428p pd=1.52u as=37.8f ps=0.6u w=0.42u l=0.13u
X1184 VPWR VGND VPWR VPWR sg13_lv_pmos ad=0.34p pd=2.68u as=0 ps=0 w=1u l=1u
X1185 VPWR VGND VPWR VPWR sg13_lv_pmos ad=0.19p pd=1.38u as=0 ps=0 w=1u l=1u
X1186 VPWR VGND VPWR VPWR sg13_lv_pmos ad=0.34p pd=2.68u as=0 ps=0 w=1u l=1u
X1187 _157_.Y _147_.Y VGND VGND sg13_lv_nmos ad=0.1406p pd=1.12u as=0.2516p ps=2.16u w=0.74u l=0.13u
X1188 VGND VPWR VGND VGND sg13_lv_nmos ad=79.8f pd=0.8u as=0 ps=0 w=0.42u l=1u
X1189 VGND VPWR VGND VGND sg13_lv_nmos ad=79.8f pd=0.8u as=0 ps=0 w=0.42u l=1u
X1190 VGND a_1580_12936# _215_.A VGND sg13_lv_nmos ad=0.14875p pd=1.16u as=0.2886p ps=2.26u w=0.74u l=0.13u
X1191 VPWR VGND VPWR VPWR sg13_lv_pmos ad=0.34p pd=2.68u as=0 ps=0 w=1u l=1u
X1192 a_2298_7678# a_2232_7868# VGND VGND sg13_lv_nmos ad=0.3367p pd=1.65u as=0.148p ps=1.14u w=0.74u l=0.13u
X1193 VPWR _218_.Y a_2150_8874# VPWR sg13_lv_pmos ad=0.36237p pd=2.605u as=79.8f ps=0.8u w=0.42u l=0.13u
X1194 VGND VPWR VGND VGND sg13_lv_nmos ad=79.8f pd=0.8u as=0 ps=0 w=0.42u l=1u
X1195 VPWR VGND VPWR VPWR sg13_lv_pmos ad=0.19p pd=1.38u as=0 ps=0 w=1u l=1u
X1196 _164_.Y _145_.X a_10989_8784# VGND sg13_lv_nmos ad=0.1406p pd=1.12u as=0.1406p ps=1.12u w=0.74u l=0.13u
X1197 _125_.A1 a_1192_7712# VGND VGND sg13_lv_nmos ad=0.2886p pd=2.26u as=0.14875p ps=1.16u w=0.74u l=0.13u
X1198 a_8100_16746# _209_.Y a_8006_16746# VGND sg13_lv_nmos ad=60.89999f pd=0.71u as=0.1428p ps=1.52u w=0.42u l=0.13u
X1199 _145_.X a_8557_4248# VGND VGND sg13_lv_nmos ad=0.1406p pd=1.12u as=0.2516p ps=2.16u w=0.74u l=0.13u
X1200 VGND VPWR VGND VGND sg13_lv_nmos ad=79.8f pd=0.8u as=0 ps=0 w=0.42u l=1u
X1201 a_5147_15996# _206_.Y _207_.Y VPWR sg13_lv_pmos ad=0.2128p pd=1.5u as=0.3808p ps=2.92u w=1.12u l=0.13u
X1202 VPWR VGND VPWR VPWR sg13_lv_pmos ad=0.34p pd=2.68u as=0 ps=0 w=1u l=1u
X1203 a_2916_4325# a_2628_3904# a_2854_4325# VGND sg13_lv_nmos ad=0.1428p pd=1.52u as=37.8f ps=0.6u w=0.42u l=0.13u
X1204 VPWR VGND VPWR VPWR sg13_lv_pmos ad=0.19p pd=1.38u as=0 ps=0 w=1u l=1u
X1205 VPWR _151_.B a_13184_7183# VPWR sg13_lv_pmos ad=0.2856p pd=2.36u as=0.1596p ps=1.22u w=0.84u l=0.13u
X1206 VGND VPWR VGND VGND sg13_lv_nmos ad=0.1428p pd=1.52u as=0 ps=0 w=0.42u l=1u
X1207 VPWR _186_.Y a_7451_14484# VPWR sg13_lv_pmos ad=0.2128p pd=1.5u as=0.2128p ps=1.5u w=1.12u l=0.13u
X1208 VPWR VGND VPWR VPWR sg13_lv_pmos ad=0.19p pd=1.38u as=0 ps=0 w=1u l=1u
X1209 VGND VPWR VGND VGND sg13_lv_nmos ad=0.1428p pd=1.52u as=0 ps=0 w=0.42u l=1u
X1210 VGND VPWR VGND VGND sg13_lv_nmos ad=79.8f pd=0.8u as=0 ps=0 w=0.42u l=1u
X1211 VGND VPWR VGND VGND sg13_lv_nmos ad=79.8f pd=0.8u as=0 ps=0 w=0.42u l=1u
X1212 VGND VPWR VGND VGND sg13_lv_nmos ad=79.8f pd=0.8u as=0 ps=0 w=0.42u l=1u
X1213 _243_.Q a_4554_3900# VPWR VPWR sg13_lv_pmos ad=0.3808p pd=2.92u as=0.2128p ps=1.5u w=1.12u l=0.13u
X1214 _211_.Y _264_.Q VGND VGND sg13_lv_nmos ad=0.2516p pd=2.16u as=0.2516p ps=2.16u w=0.74u l=0.13u
X1215 VPWR VGND VPWR VPWR sg13_lv_pmos ad=0.34p pd=2.68u as=0 ps=0 w=1u l=1u
X1216 VGND VPWR VGND VGND sg13_lv_nmos ad=79.8f pd=0.8u as=0 ps=0 w=0.42u l=1u
X1217 VPWR VGND VPWR VPWR sg13_lv_pmos ad=0.34p pd=2.68u as=0 ps=0 w=1u l=1u
X1218 VPWR VGND VPWR VPWR sg13_lv_pmos ad=0.19p pd=1.38u as=0 ps=0 w=1u l=1u
X1219 VPWR a_3695_9263# a_3952_9406# VPWR sg13_lv_pmos ad=0.4659p pd=3.65u as=79.8f ps=0.8u w=0.42u l=0.13u
X1220 a_15108_9199# a_14820_9504# a_15046_9199# VGND sg13_lv_nmos ad=0.1428p pd=1.52u as=37.8f ps=0.6u w=0.42u l=0.13u
X1221 _120_.A0 a_4170_12508# VGND VGND sg13_lv_nmos ad=0.2516p pd=2.16u as=0.1406p ps=1.12u w=0.74u l=0.13u
X1222 VPWR _124_.S a_2075_4692# VPWR sg13_lv_pmos ad=0.253p pd=1.53u as=0.2856p ps=2.36u w=0.84u l=0.13u
X1223 a_13100_13686# fanout6.A VGND VGND sg13_lv_nmos ad=0.187p pd=1.78u as=0.14875p ps=1.16u w=0.55u l=0.13u
X1224 a_10617_14037# a_9675_13844# a_10415_13799# VPWR sg13_lv_pmos ad=93.45f pd=0.865u as=0.2048p ps=1.63u w=0.42u l=0.13u
X1225 VPWR a_3407_13333# a_3664_13214# VPWR sg13_lv_pmos ad=0.4659p pd=3.65u as=79.8f ps=0.8u w=0.42u l=0.13u
X1226 VGND a_7727_4727# a_8394_4948# VGND sg13_lv_nmos ad=0.1406p pd=1.12u as=0.2516p ps=2.16u w=0.74u l=0.13u
X1227 VPWR a_9120_9501# _172_.Y VPWR sg13_lv_pmos ad=0.3808p pd=2.92u as=0.2408p ps=1.55u w=1.12u l=0.13u
X1228 a_3407_16357# a_2565_16007# a_2148_16000# VPWR sg13_lv_pmos ad=0.2048p pd=1.63u as=0.34p ps=2.68u w=1u l=0.13u
X1229 VPWR a_16079_9263# a_16746_9484# VPWR sg13_lv_pmos ad=0.2128p pd=1.5u as=0.3864p ps=2.93u w=1.12u l=0.13u
X1230 VGND VPWR VGND VGND sg13_lv_nmos ad=79.8f pd=0.8u as=0 ps=0 w=0.42u l=1u
X1231 VPWR _225_.A _228_.Y VPWR sg13_lv_pmos ad=0.3808p pd=2.92u as=0.3808p ps=2.92u w=1.12u l=0.13u
X1232 a_10246_17933# _240_.Y VGND VGND sg13_lv_nmos ad=37.8f pd=0.6u as=0.1701p ps=1.65u w=0.42u l=0.13u
X1233 VPWR _237_.Y a_12778_15964# VPWR sg13_lv_pmos ad=0.1563p pd=1.22u as=0.147p ps=1.54u w=0.42u l=0.13u
X1234 a_14698_12433# a_15141_12189# a_14438_12210# VGND sg13_lv_nmos ad=79.8f pd=0.8u as=0.1296p ps=1.52u w=0.42u l=0.13u
X1235 VPWR VGND VPWR VPWR sg13_lv_pmos ad=0.34p pd=2.68u as=0 ps=0 w=1u l=1u
X1236 VPWR VGND VPWR VPWR sg13_lv_pmos ad=0.19p pd=1.38u as=0 ps=0 w=1u l=1u
X1237 a_7753_15280# _201_.Y VGND VGND sg13_lv_nmos ad=0.1216p pd=1.02u as=0.1331p ps=1.12u w=0.64u l=0.13u
X1238 a_13073_7728# _162_.B a_13041_7996# VPWR sg13_lv_pmos ad=0.34p pd=2.68u as=0.1225p ps=1.245u w=1u l=0.13u
X1239 a_3313_8789# a_2853_8447# a_2955_8447# VGND sg13_lv_nmos ad=0.31732p pd=1.805u as=0.2516p ps=2.16u w=0.74u l=0.13u
X1240 VPWR _171_.Y a_9120_9501# VPWR sg13_lv_pmos ad=0.2891p pd=1.695u as=0.1596p ps=1.22u w=0.84u l=0.13u
X1241 _133_.Y _132_.Y a_13527_11460# VPWR sg13_lv_pmos ad=0.3808p pd=2.92u as=0.2128p ps=1.5u w=1.12u l=0.13u
X1242 VGND _144_.B _144_.Y VGND sg13_lv_nmos ad=0.2516p pd=2.16u as=0.1406p ps=1.12u w=0.74u l=0.13u
X1243 VGND VPWR VGND VGND sg13_lv_nmos ad=79.8f pd=0.8u as=0 ps=0 w=0.42u l=1u
X1244 VPWR _211_.Y a_15767_17137# VPWR sg13_lv_pmos ad=0.1428p pd=1.52u as=79.8f ps=0.8u w=0.42u l=0.13u
X1245 VGND VPWR VGND VGND sg13_lv_nmos ad=79.8f pd=0.8u as=0 ps=0 w=0.42u l=1u
X1246 a_2148_17064# a_2667_16868# a_3407_16823# VGND sg13_lv_nmos ad=0.3473p pd=2.71u as=0.12665p ps=1.145u w=0.74u l=0.13u
X1247 VPWR a_14940_16710# a_15963_17137# VPWR sg13_lv_pmos ad=0.1563p pd=1.22u as=63f ps=0.72u w=0.42u l=0.13u
X1248 VPWR VGND VPWR VPWR sg13_lv_pmos ad=0.34p pd=2.68u as=0 ps=0 w=1u l=1u
X1249 VPWR a_6720_17061# _209_.Y VPWR sg13_lv_pmos ad=0.3808p pd=2.92u as=0.2408p ps=1.55u w=1.12u l=0.13u
X1250 a_4559_4727# a_3717_4629# a_4465_4727# VGND sg13_lv_nmos ad=0.12665p pd=1.145u as=0.1428p ps=1.52u w=0.42u l=0.13u
X1251 VPWR a_7616_15437# _204_.X VPWR sg13_lv_pmos ad=0.1918p pd=1.5u as=0.3808p ps=2.92u w=1.12u l=0.13u
X1252 _143_.Y _143_.A VPWR VPWR sg13_lv_pmos ad=0.3808p pd=2.92u as=0.3808p ps=2.92u w=1.12u l=0.13u
X1253 VPWR _165_.Y a_7739_9484# VPWR sg13_lv_pmos ad=0.2128p pd=1.5u as=0.2128p ps=1.5u w=1.12u l=0.13u
X1254 _200_.Y _195_.Y a_6008_15242# VGND sg13_lv_nmos ad=0.2516p pd=2.16u as=0.1406p ps=1.12u w=0.74u l=0.13u
X1255 a_2126_10214# _122_.A0 a_2298_9972# VPWR sg13_lv_pmos ad=0.2225p pd=1.445u as=0.2975p ps=1.595u w=1u l=0.13u
X1256 a_5169_9508# _173_.A VPWR VPWR sg13_lv_pmos ad=0.1225p pd=1.245u as=0.36p ps=2.72u w=1u l=0.13u
X1257 VPWR VGND VPWR VPWR sg13_lv_pmos ad=0.19p pd=1.38u as=0 ps=0 w=1u l=1u
X1258 VPWR VGND VPWR VPWR sg13_lv_pmos ad=0.19p pd=1.38u as=0 ps=0 w=1u l=1u
X1259 VGND VPWR VGND VGND sg13_lv_nmos ad=0.1428p pd=1.52u as=0 ps=0 w=0.42u l=1u
X1260 VPWR VGND VPWR VPWR sg13_lv_pmos ad=0.19p pd=1.38u as=0 ps=0 w=1u l=1u
X1261 VGND a_3407_16823# a_4074_17044# VGND sg13_lv_nmos ad=0.1406p pd=1.12u as=0.2516p ps=2.16u w=0.74u l=0.13u
X1262 VGND VPWR VGND VGND sg13_lv_nmos ad=79.8f pd=0.8u as=0 ps=0 w=0.42u l=1u
X1263 VGND _151_.B a_13505_8784# VGND sg13_lv_nmos ad=0.2516p pd=2.16u as=0.1406p ps=1.12u w=0.74u l=0.13u
X1264 VGND VPWR VGND VGND sg13_lv_nmos ad=0.1428p pd=1.52u as=0 ps=0 w=0.42u l=1u
X1265 a_11078_16746# _212_.Y VPWR VPWR sg13_lv_pmos ad=79.8f pd=0.8u as=0.1428p ps=1.52u w=0.42u l=0.13u
X1266 VPWR _136_.A a_7262_3900# VPWR sg13_lv_pmos ad=0.36p pd=2.72u as=0.1225p ps=1.245u w=1u l=0.13u
X1267 a_7908_16000# a_7882_15964# VPWR VPWR sg13_lv_pmos ad=0.34p pd=2.68u as=0.36237p ps=2.605u w=1u l=0.13u
X1268 VGND VPWR VGND VGND sg13_lv_nmos ad=79.8f pd=0.8u as=0 ps=0 w=0.42u l=1u
X1269 clkbuf_1_0__f_sclk.A a_3886_10702# VGND VGND sg13_lv_nmos ad=0.1406p pd=1.12u as=0.1406p ps=1.12u w=0.74u l=0.13u
X1270 VPWR a_7008_16035# _203_.Y VPWR sg13_lv_pmos ad=0.3808p pd=2.92u as=0.2408p ps=1.55u w=1.12u l=0.13u
X1271 VGND VPWR VGND VGND sg13_lv_nmos ad=0.1428p pd=1.52u as=0 ps=0 w=0.42u l=1u
X1272 VGND VPWR VGND VGND sg13_lv_nmos ad=79.8f pd=0.8u as=0 ps=0 w=0.42u l=1u
X1273 VGND VPWR VGND VGND sg13_lv_nmos ad=79.8f pd=0.8u as=0 ps=0 w=0.42u l=1u
X1274 a_4559_4727# a_3717_4629# a_3300_4968# VPWR sg13_lv_pmos ad=0.2048p pd=1.63u as=0.34p ps=2.68u w=1u l=0.13u
X1275 VPWR VGND VPWR VPWR sg13_lv_pmos ad=0.34p pd=2.68u as=0 ps=0 w=1u l=1u
X1276 a_10799_5782# a_10764_5678# _144_.B VGND sg13_lv_nmos ad=0.1406p pd=1.12u as=0.2516p ps=2.16u w=0.74u l=0.13u
X1277 _196_.Y _190_.A a_6106_13726# VGND sg13_lv_nmos ad=0.2516p pd=2.16u as=0.1406p ps=1.12u w=0.74u l=0.13u
X1278 a_13338_7690# _153_.Y VGND VGND sg13_lv_nmos ad=88.8f pd=0.98u as=0.15245p ps=1.17u w=0.74u l=0.13u
X1279 a_13985_11808# _131_.A2 _129_.Y VGND sg13_lv_nmos ad=0.1406p pd=1.12u as=0.1406p ps=1.12u w=0.74u l=0.13u
X1280 a_15856_15454# _239_.Y a_15916_15549# VPWR sg13_lv_pmos ad=79.8f pd=0.8u as=0.204p ps=1.835u w=0.42u l=0.13u
X1281 VGND a_11731_8698# _180_.X VGND sg13_lv_nmos ad=0.15745p pd=1.175u as=0.2351p ps=2.16u w=0.74u l=0.13u
X1282 VPWR VGND VPWR VPWR sg13_lv_pmos ad=0.34p pd=2.68u as=0 ps=0 w=1u l=1u
X1283 a_13824_7989# _158_.Y a_13787_7720# VGND sg13_lv_nmos ad=0.2176p pd=1.96u as=78.39999f ps=0.885u w=0.64u l=0.13u
X1284 a_15389_16767# _266_.CLK a_15071_17016# VGND sg13_lv_nmos ad=0.31732p pd=1.805u as=0.2516p ps=2.16u w=0.74u l=0.13u
X1285 a_14830_16746# a_14572_16746# VGND VGND sg13_lv_nmos ad=0.1428p pd=1.52u as=79.8f ps=0.8u w=0.42u l=0.13u
X1286 a_7345_4671# a_6885_4629# a_6987_4772# VGND sg13_lv_nmos ad=0.31732p pd=1.805u as=0.2516p ps=2.16u w=0.74u l=0.13u
X1287 VGND VPWR VGND VGND sg13_lv_nmos ad=0.1428p pd=1.52u as=0 ps=0 w=0.42u l=1u
X1288 a_13593_12525# a_12651_12332# a_13391_12287# VPWR sg13_lv_pmos ad=93.45f pd=0.865u as=0.2048p ps=1.63u w=0.42u l=0.13u
X1289 VPWR a_15983_12287# a_16650_12508# VPWR sg13_lv_pmos ad=0.2128p pd=1.5u as=0.3864p ps=2.93u w=1.12u l=0.13u
X1290 clkbuf_1_0__f_sclk.A a_3886_10702# VPWR VPWR sg13_lv_pmos ad=0.2128p pd=1.5u as=0.2128p ps=1.5u w=1.12u l=0.13u
X1291 a_3503_12287# a_2661_12189# a_2244_12528# VPWR sg13_lv_pmos ad=0.2048p pd=1.63u as=0.34p ps=2.68u w=1u l=0.13u
X1292 a_15012_5837# a_14724_5416# a_14950_5837# VGND sg13_lv_nmos ad=0.1428p pd=1.52u as=37.8f ps=0.6u w=0.42u l=0.13u
X1293 a_13914_5412# _148_.X _157_.B VPWR sg13_lv_pmos ad=0.1428p pd=1.375u as=0.2408p ps=1.55u w=1.12u l=0.13u
X1294 a_8870_12210# _182_.Y VPWR VPWR sg13_lv_pmos ad=79.8f pd=0.8u as=0.1428p ps=1.52u w=0.42u l=0.13u
X1295 _159_.Y a_13824_7989# a_13973_7678# VGND sg13_lv_nmos ad=0.2516p pd=2.16u as=0.1406p ps=1.12u w=0.74u l=0.13u
X1296 VPWR VGND VPWR VPWR sg13_lv_pmos ad=0.34p pd=2.68u as=0 ps=0 w=1u l=1u
X1297 a_3886_10702# sclk VGND VGND sg13_lv_nmos ad=0.1406p pd=1.12u as=0.1406p ps=1.12u w=0.74u l=0.13u
X1298 _258_.RESET_B _222_.A VGND VGND sg13_lv_nmos ad=0.2516p pd=2.16u as=0.2516p ps=2.16u w=0.74u l=0.13u
X1299 _147_.Y _147_.B1 a_11381_3900# VPWR sg13_lv_pmos ad=0.3808p pd=2.92u as=0.2128p ps=1.5u w=1.12u l=0.13u
X1300 VPWR VGND VPWR VPWR sg13_lv_pmos ad=0.34p pd=2.68u as=0 ps=0 w=1u l=1u
X1301 a_16498_8874# _227_.Y VGND VGND sg13_lv_nmos ad=37.8f pd=0.6u as=79.8f ps=0.8u w=0.42u l=0.13u
X1302 VPWR VGND VPWR VPWR sg13_lv_pmos ad=0.19p pd=1.38u as=0 ps=0 w=1u l=1u
X1303 VPWR VGND VPWR VPWR sg13_lv_pmos ad=0.19p pd=1.38u as=0 ps=0 w=1u l=1u
X1304 VGND VPWR VGND VGND sg13_lv_nmos ad=0.1428p pd=1.52u as=0 ps=0 w=0.42u l=1u
X1305 VPWR VGND VPWR VPWR sg13_lv_pmos ad=0.34p pd=2.68u as=0 ps=0 w=1u l=1u
X1306 VPWR VGND VPWR VPWR sg13_lv_pmos ad=0.34p pd=2.68u as=0 ps=0 w=1u l=1u
X1307 a_10033_13743# a_9573_13701# a_9675_13844# VGND sg13_lv_nmos ad=0.31732p pd=1.805u as=0.2516p ps=2.16u w=0.74u l=0.13u
X1308 VGND VPWR VGND VGND sg13_lv_nmos ad=79.8f pd=0.8u as=0 ps=0 w=0.42u l=1u
X1309 a_6336_11499# _176_.A VPWR VPWR sg13_lv_pmos ad=0.1596p pd=1.22u as=0.4536p ps=2.76u w=0.84u l=0.13u
X1310 VPWR VGND VPWR VPWR sg13_lv_pmos ad=0.19p pd=1.38u as=0 ps=0 w=1u l=1u
X1311 _243_.CLK a_3956_6888# VGND VGND sg13_lv_nmos ad=0.1406p pd=1.12u as=0.2516p ps=2.16u w=0.74u l=0.13u
X1312 VPWR VGND VPWR VPWR sg13_lv_pmos ad=0.34p pd=2.68u as=0 ps=0 w=1u l=1u
X1313 a_3886_10702# sclk VPWR VPWR sg13_lv_pmos ad=0.2128p pd=1.5u as=0.2128p ps=1.5u w=1.12u l=0.13u
X1314 VGND VPWR VGND VGND sg13_lv_nmos ad=79.8f pd=0.8u as=0 ps=0 w=0.42u l=1u
X1315 a_14359_16710# a_14919_16964# a_14830_17061# VPWR sg13_lv_pmos ad=0.2048p pd=1.63u as=93.45f ps=0.865u w=0.42u l=0.13u
X1316 VPWR a_15599_15311# a_16266_15532# VPWR sg13_lv_pmos ad=0.2128p pd=1.5u as=0.3864p ps=2.93u w=1.12u l=0.13u
X1317 VPWR a_2075_4692# a_2575_4948# VPWR sg13_lv_pmos ad=0.2198p pd=1.52u as=0.2975p ps=1.595u w=1u l=0.13u
X1318 VPWR _234_.Y a_11846_12210# VPWR sg13_lv_pmos ad=0.36237p pd=2.605u as=79.8f ps=0.8u w=0.42u l=0.13u
X1319 a_11279_17869# a_10437_17519# a_10020_17512# VPWR sg13_lv_pmos ad=0.2048p pd=1.63u as=0.34p ps=2.68u w=1u l=0.13u
X1320 VPWR VGND VPWR VPWR sg13_lv_pmos ad=0.19p pd=1.38u as=0 ps=0 w=1u l=1u
X1321 VGND VPWR VGND VGND sg13_lv_nmos ad=79.8f pd=0.8u as=0 ps=0 w=0.42u l=1u
X1322 VGND VPWR VGND VGND sg13_lv_nmos ad=0.1428p pd=1.52u as=0 ps=0 w=0.42u l=1u
X1323 VPWR a_4512_17547# _207_.A2 VPWR sg13_lv_pmos ad=0.3808p pd=2.92u as=0.2408p ps=1.55u w=1.12u l=0.13u
X1324 _168_.B a_5201_9240# a_5372_9484# VPWR sg13_lv_pmos ad=0.3808p pd=2.92u as=0.2128p ps=1.5u w=1.12u l=0.13u
X1325 VGND _124_.S a_2620_10318# VGND sg13_lv_nmos ad=0.18945p pd=1.27u as=0.13135p ps=1.095u w=0.74u l=0.13u
X1326 a_1958_12210# a_2763_12332# a_2218_12433# VPWR sg13_lv_pmos ad=0.1428p pd=1.52u as=79.8f ps=0.8u w=0.42u l=0.13u
X1327 VPWR a_10415_12287# a_10672_12430# VPWR sg13_lv_pmos ad=0.4659p pd=3.65u as=79.8f ps=0.8u w=0.42u l=0.13u
X1328 VGND VPWR VGND VGND sg13_lv_nmos ad=0.1428p pd=1.52u as=0 ps=0 w=0.42u l=1u
X1329 a_2854_4325# _243_.RESET_B VGND VGND sg13_lv_nmos ad=37.8f pd=0.6u as=0.1701p ps=1.65u w=0.42u l=0.13u
X1330 VPWR VGND VPWR VPWR sg13_lv_pmos ad=0.19p pd=1.38u as=0 ps=0 w=1u l=1u
X1331 _238_.Y _225_.A VPWR VPWR sg13_lv_pmos ad=0.3808p pd=2.92u as=0.3808p ps=2.92u w=1.12u l=0.13u
X1332 _176_.B a_5297_12264# a_5468_12508# VPWR sg13_lv_pmos ad=0.3808p pd=2.92u as=0.2128p ps=1.5u w=1.12u l=0.13u
X1333 VGND VPWR VGND VGND sg13_lv_nmos ad=0.1428p pd=1.52u as=0 ps=0 w=0.42u l=1u
X1334 _164_.B1 a_12215_7664# VGND VGND sg13_lv_nmos ad=0.1406p pd=1.12u as=0.2516p ps=2.16u w=0.74u l=0.13u
X1335 a_3820_12525# a_3760_12430# a_3705_12525# VPWR sg13_lv_pmos ad=0.204p pd=1.835u as=93.45f ps=0.865u w=0.42u l=0.13u
X1336 VPWR VGND VPWR VPWR sg13_lv_pmos ad=0.34p pd=2.68u as=0 ps=0 w=1u l=1u
X1337 a_9734_9186# _172_.Y VPWR VPWR sg13_lv_pmos ad=79.8f pd=0.8u as=0.1428p ps=1.52u w=0.42u l=0.13u
X1338 VPWR VGND VPWR VPWR sg13_lv_pmos ad=0.19p pd=1.38u as=0 ps=0 w=1u l=1u
X1339 a_2150_9186# a_2955_9308# a_2410_9409# VPWR sg13_lv_pmos ad=0.1428p pd=1.52u as=79.8f ps=0.8u w=0.42u l=0.13u
X1340 VGND VPWR VGND VGND sg13_lv_nmos ad=0.1428p pd=1.52u as=0 ps=0 w=0.42u l=1u
X1341 a_11536_9406# _228_.Y a_11596_9501# VPWR sg13_lv_pmos ad=79.8f pd=0.8u as=0.204p ps=1.835u w=0.42u l=0.13u
X1342 a_13648_12430# a_13391_12287# a_13810_12210# VGND sg13_lv_nmos ad=0.1428p pd=1.52u as=37.8f ps=0.6u w=0.42u l=0.13u
X1343 VGND VPWR VGND VGND sg13_lv_nmos ad=79.8f pd=0.8u as=0 ps=0 w=0.42u l=1u
X1344 VGND VPWR VGND VGND sg13_lv_nmos ad=0.1428p pd=1.52u as=0 ps=0 w=0.42u l=1u
X1345 a_15237_8447# _251_.CLK a_15697_8438# VPWR sg13_lv_pmos ad=0.4088p pd=2.97u as=0.41165p ps=2.12u w=1.12u l=0.13u
X1346 _215_.Y _215_.A VGND VGND sg13_lv_nmos ad=0.2516p pd=2.16u as=0.2516p ps=2.16u w=0.74u l=0.13u
X1347 a_3657_5459# a_3300_5416# VPWR VPWR sg13_lv_pmos ad=63f pd=0.72u as=0.1563p ps=1.22u w=0.42u l=0.13u
X1348 VPWR VGND VPWR VPWR sg13_lv_pmos ad=0.34p pd=2.68u as=0 ps=0 w=1u l=1u
X1349 a_13775_5782# _149_.A VGND VGND sg13_lv_nmos ad=0.2516p pd=2.16u as=0.1898p ps=1.36u w=0.74u l=0.13u
X1350 a_8266_16969# a_8709_16725# a_8649_17137# VPWR sg13_lv_pmos ad=79.8f pd=0.8u as=63f ps=0.72u w=0.42u l=0.13u
X1351 VGND VPWR VGND VGND sg13_lv_nmos ad=0.1428p pd=1.52u as=0 ps=0 w=0.42u l=1u
X1352 a_16396_8559# a_16336_8678# a_16281_8559# VPWR sg13_lv_pmos ad=0.204p pd=1.835u as=93.45f ps=0.865u w=0.42u l=0.13u
X1353 a_8990_5412# _144_.B a_8538_5375# VPWR sg13_lv_pmos ad=0.1225p pd=1.245u as=0.34p ps=2.68u w=1u l=0.13u
X1354 a_14697_15625# a_14340_15552# VPWR VPWR sg13_lv_pmos ad=63f pd=0.72u as=0.1563p ps=1.22u w=0.42u l=0.13u
X1355 a_10607_4727# a_9765_4629# a_9348_4968# VPWR sg13_lv_pmos ad=0.2048p pd=1.63u as=0.34p ps=2.68u w=1u l=0.13u
X1356 a_3025_16767# a_2565_16725# a_2667_16868# VGND sg13_lv_nmos ad=0.31732p pd=1.805u as=0.2516p ps=2.16u w=0.74u l=0.13u
X1357 VGND VPWR VGND VGND sg13_lv_nmos ad=0.1428p pd=1.52u as=0 ps=0 w=0.42u l=1u
X1358 VPWR a_3380_13690# _247_.CLK VPWR sg13_lv_pmos ad=0.2128p pd=1.5u as=0.2128p ps=1.5u w=1.12u l=0.13u
X1359 a_2232_11722# _124_.S VGND VGND sg13_lv_nmos ad=0.187p pd=1.78u as=0.18945p ps=1.27u w=0.55u l=0.13u
X1360 VGND VPWR VGND VGND sg13_lv_nmos ad=79.8f pd=0.8u as=0 ps=0 w=0.42u l=1u
X1361 a_1956_16434# _250_.D a_1862_16434# VGND sg13_lv_nmos ad=60.89999f pd=0.71u as=0.1428p ps=1.52u w=0.42u l=0.13u
X1362 VPWR VGND VPWR VPWR sg13_lv_pmos ad=0.34p pd=2.68u as=0 ps=0 w=1u l=1u
X1363 VPWR VGND VPWR VPWR sg13_lv_pmos ad=0.19p pd=1.38u as=0 ps=0 w=1u l=1u
X1364 a_6869_16750# _208_.X VGND VGND sg13_lv_nmos ad=0.1406p pd=1.12u as=0.1898p ps=1.36u w=0.74u l=0.13u
X1365 a_2532_12223# a_2244_12528# a_2470_12223# VGND sg13_lv_nmos ad=0.1428p pd=1.52u as=37.8f ps=0.6u w=0.42u l=0.13u
X1366 VPWR VGND VPWR VPWR sg13_lv_pmos ad=0.19p pd=1.38u as=0 ps=0 w=1u l=1u
X1367 a_16240_5654# a_15983_5773# a_16402_5850# VGND sg13_lv_nmos ad=0.1428p pd=1.52u as=37.8f ps=0.6u w=0.42u l=0.13u
X1368 VPWR VGND VPWR VPWR sg13_lv_pmos ad=0.19p pd=1.38u as=0 ps=0 w=1u l=1u
X1369 VPWR VGND VPWR VPWR sg13_lv_pmos ad=0.19p pd=1.38u as=0 ps=0 w=1u l=1u
X1370 a_2298_7972# a_2232_7868# VPWR VPWR sg13_lv_pmos ad=0.2975p pd=1.595u as=0.2198p ps=1.52u w=1u l=0.13u
X1371 VPWR VGND VPWR VPWR sg13_lv_pmos ad=0.19p pd=1.38u as=0 ps=0 w=1u l=1u
X1372 _213_.Y _251_.CLK VPWR VPWR sg13_lv_pmos ad=0.3808p pd=2.92u as=0.3808p ps=2.92u w=1.12u l=0.13u
X1373 _224_.Y _215_.A VGND VGND sg13_lv_nmos ad=0.2516p pd=2.16u as=0.2516p ps=2.16u w=0.74u l=0.13u
X1374 a_9551_16823# a_8709_16725# a_8292_17064# VPWR sg13_lv_pmos ad=0.2048p pd=1.63u as=0.34p ps=2.68u w=1u l=0.13u
X1375 a_4978_5850# _244_.RESET_B VGND VGND sg13_lv_nmos ad=37.8f pd=0.6u as=79.8f ps=0.8u w=0.42u l=0.13u
X1376 VPWR VGND VPWR VPWR sg13_lv_pmos ad=0.19p pd=1.38u as=0 ps=0 w=1u l=1u
X1377 VGND VPWR VGND VGND sg13_lv_nmos ad=79.8f pd=0.8u as=0 ps=0 w=0.42u l=1u
X1378 VGND _228_.Y a_9828_9186# VGND sg13_lv_nmos ad=0.1626p pd=1.415u as=60.89999f ps=0.71u w=0.42u l=0.13u
X1379 a_16079_8797# a_15237_8447# a_15985_8797# VGND sg13_lv_nmos ad=0.12665p pd=1.145u as=0.1428p ps=1.52u w=0.42u l=0.13u
X1380 _184_.Y _178_.B1 VPWR VPWR sg13_lv_pmos ad=0.2128p pd=1.5u as=0.3808p ps=2.92u w=1.12u l=0.13u
X1381 _177_.X a_6124_9945# VPWR VPWR sg13_lv_pmos ad=0.3808p pd=2.92u as=0.36195p ps=1.84u w=1.12u l=0.13u
X1382 VGND a_3887_4261# a_4554_3900# VGND sg13_lv_nmos ad=0.1406p pd=1.12u as=0.2516p ps=2.16u w=0.74u l=0.13u
X1383 _172_.Y _171_.Y a_9363_9484# VPWR sg13_lv_pmos ad=0.2408p pd=1.55u as=0.1428p ps=1.375u w=1.12u l=0.13u
X1384 VPWR VGND VPWR VPWR sg13_lv_pmos ad=0.34p pd=2.68u as=0 ps=0 w=1u l=1u
X1385 VPWR VGND VPWR VPWR sg13_lv_pmos ad=0.34p pd=2.68u as=0 ps=0 w=1u l=1u
X1386 VGND VPWR VGND VGND sg13_lv_nmos ad=79.8f pd=0.8u as=0 ps=0 w=0.42u l=1u
X1387 VPWR VGND VPWR VPWR sg13_lv_pmos ad=0.19p pd=1.38u as=0 ps=0 w=1u l=1u
X1388 VPWR VGND VPWR VPWR sg13_lv_pmos ad=0.19p pd=1.38u as=0 ps=0 w=1u l=1u
X1389 VGND VPWR VGND VGND sg13_lv_nmos ad=0.1428p pd=1.52u as=0 ps=0 w=0.42u l=1u
X1390 VPWR a_9167_16357# a_9834_15996# VPWR sg13_lv_pmos ad=0.2128p pd=1.5u as=0.3864p ps=2.93u w=1.12u l=0.13u
X1391 a_12666_4666# _148_.A VGND VGND sg13_lv_nmos ad=88.8f pd=0.98u as=0.15245p ps=1.17u w=0.74u l=0.13u
X1392 a_12923_11460# _131_.A2 VPWR VPWR sg13_lv_pmos ad=0.3808p pd=2.92u as=0.2128p ps=1.5u w=1.12u l=0.13u
X1393 a_14794_11428# a_15237_11471# a_14534_11898# VGND sg13_lv_nmos ad=79.8f pd=0.8u as=0.1296p ps=1.52u w=0.42u l=0.13u
X1394 VGND VPWR VGND VGND sg13_lv_nmos ad=79.8f pd=0.8u as=0 ps=0 w=0.42u l=1u
X1395 VGND VPWR VGND VGND sg13_lv_nmos ad=0.1428p pd=1.52u as=0 ps=0 w=0.42u l=1u
X1396 VPWR _225_.Y a_9062_4650# VPWR sg13_lv_pmos ad=0.36237p pd=2.605u as=79.8f ps=0.8u w=0.42u l=0.13u
X1397 VGND VPWR VGND VGND sg13_lv_nmos ad=0.1428p pd=1.52u as=0 ps=0 w=0.42u l=1u
X1398 _208_.X _207_.Y a_4890_16762# VGND sg13_lv_nmos ad=0.1628p pd=1.18u as=88.8f ps=0.98u w=0.74u l=0.13u
X1399 VGND VPWR VGND VGND sg13_lv_nmos ad=0.1428p pd=1.52u as=0 ps=0 w=0.42u l=1u
X1400 VPWR VGND VPWR VPWR sg13_lv_pmos ad=0.34p pd=2.68u as=0 ps=0 w=1u l=1u
X1401 VPWR VGND VPWR VPWR sg13_lv_pmos ad=0.34p pd=2.68u as=0 ps=0 w=1u l=1u
X1402 _171_.Y _171_.A a_8236_8436# VPWR sg13_lv_pmos ad=0.3808p pd=2.92u as=0.1176p ps=1.33u w=1.12u l=0.13u
X1403 a_14534_8874# _159_.Y VPWR VPWR sg13_lv_pmos ad=79.8f pd=0.8u as=0.1428p ps=1.52u w=0.42u l=0.13u
X1404 VGND VPWR VGND VGND sg13_lv_nmos ad=0.1428p pd=1.52u as=0 ps=0 w=0.42u l=1u
X1405 VPWR VGND VPWR VPWR sg13_lv_pmos ad=0.34p pd=2.68u as=0 ps=0 w=1u l=1u
X1406 VGND VPWR VGND VGND sg13_lv_nmos ad=79.8f pd=0.8u as=0 ps=0 w=0.42u l=1u
X1407 VPWR VGND VPWR VPWR sg13_lv_pmos ad=0.34p pd=2.68u as=0 ps=0 w=1u l=1u
X1408 a_11338_16969# a_11781_16725# a_11078_16746# VGND sg13_lv_nmos ad=79.8f pd=0.8u as=0.1296p ps=1.52u w=0.42u l=0.13u
X1409 VPWR a_3503_12287# a_4170_12508# VPWR sg13_lv_pmos ad=0.2128p pd=1.5u as=0.3864p ps=2.93u w=1.12u l=0.13u
X1410 VPWR _250_.Q a_4796_17044# VPWR sg13_lv_pmos ad=0.2128p pd=1.5u as=0.3808p ps=2.92u w=1.12u l=0.13u
X1411 VPWR VGND VPWR VPWR sg13_lv_pmos ad=0.19p pd=1.38u as=0 ps=0 w=1u l=1u
X1412 a_2436_4338# _243_.D a_2342_4338# VGND sg13_lv_nmos ad=60.89999f pd=0.71u as=0.1428p ps=1.52u w=0.42u l=0.13u
X1413 VPWR VGND VPWR VPWR sg13_lv_pmos ad=0.19p pd=1.38u as=0 ps=0 w=1u l=1u
X1414 VPWR VGND VPWR VPWR sg13_lv_pmos ad=0.34p pd=2.68u as=0 ps=0 w=1u l=1u
X1415 _192_.B _176_.A a_6970_12214# VGND sg13_lv_nmos ad=0.2516p pd=2.16u as=0.1406p ps=1.12u w=0.74u l=0.13u
X1416 VGND VPWR VGND VGND sg13_lv_nmos ad=0.1428p pd=1.52u as=0 ps=0 w=0.42u l=1u
X1417 _247_.CLK a_3380_13690# VPWR VPWR sg13_lv_pmos ad=0.2128p pd=1.5u as=0.2128p ps=1.5u w=1.12u l=0.13u
X1418 a_6336_11499# _176_.B a_6299_11808# VGND sg13_lv_nmos ad=0.2176p pd=1.96u as=78.39999f ps=0.885u w=0.64u l=0.13u
X1419 VGND VPWR VGND VGND sg13_lv_nmos ad=0.1428p pd=1.52u as=0 ps=0 w=0.42u l=1u
X1420 VGND _153_.Y _162_.Y VGND sg13_lv_nmos ad=0.2516p pd=2.16u as=0.1406p ps=1.12u w=0.74u l=0.13u
X1421 a_7841_9212# _165_.Y _171_.A VGND sg13_lv_nmos ad=0.1406p pd=1.12u as=0.1406p ps=1.12u w=0.74u l=0.13u
X1422 VGND _224_.Y a_6276_4650# VGND sg13_lv_nmos ad=0.1626p pd=1.415u as=60.89999f ps=0.71u w=0.42u l=0.13u
X1423 VPWR VGND VPWR VPWR sg13_lv_pmos ad=0.19p pd=1.38u as=0 ps=0 w=1u l=1u
X1424 a_6291_12972# _190_.A VPWR VPWR sg13_lv_pmos ad=0.1428p pd=1.375u as=0.2891p ps=1.695u w=1.12u l=0.13u
X1425 VGND _207_.A1 a_5525_16750# VGND sg13_lv_nmos ad=0.1898p pd=1.36u as=0.2516p ps=2.16u w=0.74u l=0.13u
X1426 _179_.Y _178_.Y a_6890_9948# VPWR sg13_lv_pmos ad=0.3808p pd=2.92u as=0.1176p ps=1.33u w=1.12u l=0.13u
X1427 a_13025_11808# _260_.CLK _126_.Y VGND sg13_lv_nmos ad=0.1406p pd=1.12u as=0.1406p ps=1.12u w=0.74u l=0.13u
X1428 a_3300_4968# a_3274_4873# VGND VGND sg13_lv_nmos ad=0.2516p pd=2.16u as=0.1626p ps=1.415u w=0.74u l=0.13u
X1429 a_2148_12976# a_2122_12940# VGND VGND sg13_lv_nmos ad=0.2516p pd=2.16u as=0.1626p ps=1.415u w=0.74u l=0.13u
X1430 a_12730_8806# _162_.B VGND VGND sg13_lv_nmos ad=0.1406p pd=1.12u as=0.2516p ps=2.16u w=0.74u l=0.13u
X1431 VPWR VGND VPWR VPWR sg13_lv_pmos ad=0.34p pd=2.68u as=0 ps=0 w=1u l=1u
X1432 VPWR VGND VPWR VPWR sg13_lv_pmos ad=0.34p pd=2.68u as=0 ps=0 w=1u l=1u
X1433 VPWR VGND VPWR VPWR sg13_lv_pmos ad=0.34p pd=2.68u as=0 ps=0 w=1u l=1u
X1434 a_4876_5535# a_4816_5654# a_4761_5535# VPWR sg13_lv_pmos ad=0.204p pd=1.835u as=93.45f ps=0.865u w=0.42u l=0.13u
X1435 a_2558_14020# _119_.A0 a_2126_13912# VPWR sg13_lv_pmos ad=0.3325p pd=1.665u as=0.2225p ps=1.445u w=1u l=0.13u
X1436 a_6720_17061# _208_.X a_6683_16792# VGND sg13_lv_nmos ad=0.2176p pd=1.96u as=78.39999f ps=0.885u w=0.64u l=0.13u
X1437 a_16336_9406# _260_.RESET_B a_16396_9501# VPWR sg13_lv_pmos ad=79.8f pd=0.8u as=0.204p ps=1.835u w=0.42u l=0.13u
X1438 VGND VPWR VGND VGND sg13_lv_nmos ad=79.8f pd=0.8u as=0 ps=0 w=0.42u l=1u
X1439 a_11026_4650# _225_.Y VGND VGND sg13_lv_nmos ad=37.8f pd=0.6u as=79.8f ps=0.8u w=0.42u l=0.13u
X1440 VGND VPWR VGND VGND sg13_lv_nmos ad=79.8f pd=0.8u as=0 ps=0 w=0.42u l=1u
X1441 a_2565_16007# _247_.CLK a_3025_15998# VPWR sg13_lv_pmos ad=0.4088p pd=2.97u as=0.41165p ps=2.12u w=1.12u l=0.13u
X1442 a_4625_16800# _207_.Y a_4593_17068# VPWR sg13_lv_pmos ad=0.34p pd=2.68u as=0.1225p ps=1.245u w=1u l=0.13u
X1443 a_6779_12972# _192_.B VPWR VPWR sg13_lv_pmos ad=0.3808p pd=2.92u as=0.2128p ps=1.5u w=1.12u l=0.13u
X1444 _157_.B a_13740_5678# VPWR VPWR sg13_lv_pmos ad=0.2408p pd=1.55u as=0.3808p ps=2.92u w=1.12u l=0.13u
X1445 VGND VPWR VGND VGND sg13_lv_nmos ad=0.1428p pd=1.52u as=0 ps=0 w=0.42u l=1u
X1446 a_2724_9199# a_2436_9504# a_2662_9199# VGND sg13_lv_nmos ad=0.1428p pd=1.52u as=37.8f ps=0.6u w=0.42u l=0.13u
X1447 a_3588_4663# a_3819_4772# a_3274_4873# VGND sg13_lv_nmos ad=0.2373p pd=1.97u as=79.8f ps=0.8u w=0.42u l=0.13u
X1448 VPWR VGND VPWR VPWR sg13_lv_pmos ad=0.34p pd=2.68u as=0 ps=0 w=1u l=1u
X1449 a_15108_8861# a_14820_8440# a_15046_8861# VGND sg13_lv_nmos ad=0.1428p pd=1.52u as=37.8f ps=0.6u w=0.42u l=0.13u
X1450 a_11536_17750# _240_.Y a_11596_17631# VPWR sg13_lv_pmos ad=79.8f pd=0.8u as=0.204p ps=1.835u w=0.42u l=0.13u
X1451 _214_.A a_11946_17508# VPWR VPWR sg13_lv_pmos ad=0.3808p pd=2.92u as=0.2128p ps=1.5u w=1.12u l=0.13u
X1452 VPWR a_9167_16357# a_9424_16238# VPWR sg13_lv_pmos ad=0.4659p pd=3.65u as=79.8f ps=0.8u w=0.42u l=0.13u
X1453 a_9705_5041# a_9348_4968# VPWR VPWR sg13_lv_pmos ad=63f pd=0.72u as=0.1563p ps=1.22u w=0.42u l=0.13u
X1454 a_14380_16119# a_14320_16238# a_14265_16119# VPWR sg13_lv_pmos ad=0.204p pd=1.835u as=93.45f ps=0.865u w=0.42u l=0.13u
X1455 VGND VPWR VGND VGND sg13_lv_nmos ad=79.8f pd=0.8u as=0 ps=0 w=0.42u l=1u
X1456 a_2126_7864# _148_.A a_2298_7972# VPWR sg13_lv_pmos ad=0.2225p pd=1.445u as=0.2975p ps=1.595u w=1u l=0.13u
X1457 VGND VPWR VGND VGND sg13_lv_nmos ad=79.8f pd=0.8u as=0 ps=0 w=0.42u l=1u
X1458 a_4559_5773# a_3717_5423# a_4465_5773# VGND sg13_lv_nmos ad=0.12665p pd=1.145u as=0.1428p ps=1.52u w=0.42u l=0.13u
X1459 a_7736_8802# _170_.B a_7634_8802# VGND sg13_lv_nmos ad=0.1406p pd=1.12u as=0.1406p ps=1.12u w=0.74u l=0.13u
X1460 VGND VPWR VGND VGND sg13_lv_nmos ad=79.8f pd=0.8u as=0 ps=0 w=0.42u l=1u
X1461 _190_.A a_11082_14020# VGND VGND sg13_lv_nmos ad=0.2516p pd=2.16u as=0.1406p ps=1.12u w=0.74u l=0.13u
X1462 VGND VPWR VGND VGND sg13_lv_nmos ad=0.1428p pd=1.52u as=0 ps=0 w=0.42u l=1u
X1463 VPWR a_12623_16823# a_12880_16966# VPWR sg13_lv_pmos ad=0.4659p pd=3.65u as=79.8f ps=0.8u w=0.42u l=0.13u
X1464 VPWR VGND VPWR VPWR sg13_lv_pmos ad=0.19p pd=1.38u as=0 ps=0 w=1u l=1u
X1465 VGND VPWR VGND VGND sg13_lv_nmos ad=0.1428p pd=1.52u as=0 ps=0 w=0.42u l=1u
X1466 _243_.CLK a_3956_6888# VPWR VPWR sg13_lv_pmos ad=0.2128p pd=1.5u as=0.3976p ps=2.95u w=1.12u l=0.13u
X1467 _131_.A2 a_16650_12508# VPWR VPWR sg13_lv_pmos ad=0.3808p pd=2.92u as=0.2128p ps=1.5u w=1.12u l=0.13u
X1468 VGND fanout8.A a_9352_17508# VGND sg13_lv_nmos ad=0.14875p pd=1.16u as=0.187p ps=1.78u w=0.55u l=0.13u
X1469 VPWR a_3887_4261# a_4144_4142# VPWR sg13_lv_pmos ad=0.4659p pd=3.65u as=79.8f ps=0.8u w=0.42u l=0.13u
X1470 VGND sclk a_3886_10702# VGND sg13_lv_nmos ad=0.1406p pd=1.12u as=0.1406p ps=1.12u w=0.74u l=0.13u
X1471 VGND VPWR VGND VGND sg13_lv_nmos ad=0.1428p pd=1.52u as=0 ps=0 w=0.42u l=1u
X1472 VGND VPWR VGND VGND sg13_lv_nmos ad=79.8f pd=0.8u as=0 ps=0 w=0.42u l=1u
X1473 VGND VPWR VGND VGND sg13_lv_nmos ad=0.1428p pd=1.52u as=0 ps=0 w=0.42u l=1u
X1474 a_5265_12532# _120_.A0 VPWR VPWR sg13_lv_pmos ad=0.1225p pd=1.245u as=0.36p ps=2.72u w=1u l=0.13u
X1475 VGND VPWR VGND VGND sg13_lv_nmos ad=79.8f pd=0.8u as=0 ps=0 w=0.42u l=1u
X1476 a_3108_4650# _242_.D a_3014_4650# VGND sg13_lv_nmos ad=60.89999f pd=0.71u as=0.1428p ps=1.52u w=0.42u l=0.13u
X1477 VPWR _235_.Y a_14438_12210# VPWR sg13_lv_pmos ad=0.36237p pd=2.605u as=79.8f ps=0.8u w=0.42u l=0.13u
X1478 VGND VPWR VGND VGND sg13_lv_nmos ad=79.8f pd=0.8u as=0 ps=0 w=0.42u l=1u
X1479 VGND VPWR VGND VGND sg13_lv_nmos ad=79.8f pd=0.8u as=0 ps=0 w=0.42u l=1u
X1480 a_3664_16238# _250_.RESET_B a_3724_16119# VPWR sg13_lv_pmos ad=79.8f pd=0.8u as=0.204p ps=1.835u w=0.42u l=0.13u
X1481 VGND VPWR VGND VGND sg13_lv_nmos ad=79.8f pd=0.8u as=0 ps=0 w=0.42u l=1u
X1482 a_7953_14044# _186_.Y VPWR VPWR sg13_lv_pmos ad=0.1225p pd=1.245u as=0.36p ps=2.72u w=1u l=0.13u
X1483 VPWR VGND VPWR VPWR sg13_lv_pmos ad=0.34p pd=2.68u as=0 ps=0 w=1u l=1u
X1484 VGND VPWR VGND VGND sg13_lv_nmos ad=79.8f pd=0.8u as=0 ps=0 w=0.42u l=1u
X1485 VGND a_15983_5773# a_16650_5412# VGND sg13_lv_nmos ad=0.1406p pd=1.12u as=0.2516p ps=2.16u w=0.74u l=0.13u
X1486 a_15389_17042# _266_.CLK a_15071_17016# VPWR sg13_lv_pmos ad=0.41165p pd=2.12u as=0.4088p ps=2.97u w=1.12u l=0.13u
X1487 VGND a_2126_17774# _250_.D VGND sg13_lv_nmos ad=0.148p pd=1.14u as=0.4033p ps=2.57u w=0.74u l=0.13u
X1488 VGND VPWR VGND VGND sg13_lv_nmos ad=79.8f pd=0.8u as=0 ps=0 w=0.42u l=1u
X1489 a_8603_9484# _171_.Y VPWR VPWR sg13_lv_pmos ad=0.3808p pd=2.92u as=0.2128p ps=1.5u w=1.12u l=0.13u
X1490 a_1862_16434# a_2667_16007# a_2122_15964# VPWR sg13_lv_pmos ad=0.1428p pd=1.52u as=79.8f ps=0.8u w=0.42u l=0.13u
X1491 VGND VPWR VGND VGND sg13_lv_nmos ad=79.8f pd=0.8u as=0 ps=0 w=0.42u l=1u
X1492 VPWR sclk a_3886_10702# VPWR sg13_lv_pmos ad=0.2128p pd=1.5u as=0.2128p ps=1.5u w=1.12u l=0.13u
X1493 VPWR _215_.Y a_3274_4873# VPWR sg13_lv_pmos ad=0.1563p pd=1.22u as=0.147p ps=1.54u w=0.42u l=0.13u
X1494 VPWR VGND VPWR VPWR sg13_lv_pmos ad=0.19p pd=1.38u as=0 ps=0 w=1u l=1u
X1495 a_11279_9263# a_10437_9165# a_11185_9263# VGND sg13_lv_nmos ad=0.12665p pd=1.145u as=0.1428p ps=1.52u w=0.42u l=0.13u
X1496 a_2374_16759# _222_.Y VGND VGND sg13_lv_nmos ad=37.8f pd=0.6u as=0.1701p ps=1.65u w=0.42u l=0.13u
X1497 VGND VPWR VGND VGND sg13_lv_nmos ad=0.1428p pd=1.52u as=0 ps=0 w=0.42u l=1u
X1498 VGND VPWR VGND VGND sg13_lv_nmos ad=79.8f pd=0.8u as=0 ps=0 w=0.42u l=1u
X1499 a_8250_7690# _122_.A0 VGND VGND sg13_lv_nmos ad=88.8f pd=0.98u as=0.15245p ps=1.17u w=0.74u l=0.13u
X1500 VPWR _221_.Y a_1862_13410# VPWR sg13_lv_pmos ad=0.36237p pd=2.605u as=79.8f ps=0.8u w=0.42u l=0.13u
X1501 VPWR VGND VPWR VPWR sg13_lv_pmos ad=0.34p pd=2.68u as=0 ps=0 w=1u l=1u
X1502 VPWR VGND VPWR VPWR sg13_lv_pmos ad=0.19p pd=1.38u as=0 ps=0 w=1u l=1u
X1503 VPWR VGND VPWR VPWR sg13_lv_pmos ad=0.34p pd=2.68u as=0 ps=0 w=1u l=1u
X1504 VPWR VGND VPWR VPWR sg13_lv_pmos ad=0.34p pd=2.68u as=0 ps=0 w=1u l=1u
X1505 VPWR VGND VPWR VPWR sg13_lv_pmos ad=0.19p pd=1.38u as=0 ps=0 w=1u l=1u
X1506 a_2298_17532# a_2232_17770# VPWR VPWR sg13_lv_pmos ad=0.2975p pd=1.595u as=0.2198p ps=1.52u w=1u l=0.13u
X1507 VPWR VGND VPWR VPWR sg13_lv_pmos ad=0.34p pd=2.68u as=0 ps=0 w=1u l=1u
X1508 VGND a_3956_6888# _243_.CLK VGND sg13_lv_nmos ad=0.1406p pd=1.12u as=0.1406p ps=1.12u w=0.74u l=0.13u
X1509 a_10897_9482# a_10437_9165# a_10539_9308# VPWR sg13_lv_pmos ad=0.41165p pd=2.12u as=0.3864p ps=2.93u w=1.12u l=0.13u
X1510 VPWR _239_.Y a_14054_15234# VPWR sg13_lv_pmos ad=0.36237p pd=2.605u as=79.8f ps=0.8u w=0.42u l=0.13u
X1511 VPWR VGND VPWR VPWR sg13_lv_pmos ad=0.34p pd=2.68u as=0 ps=0 w=1u l=1u
X1512 VGND VPWR VGND VGND sg13_lv_nmos ad=0.1428p pd=1.52u as=0 ps=0 w=0.42u l=1u
X1513 VGND a_15861_16904# a_14940_16710# VGND sg13_lv_nmos ad=0.1626p pd=1.415u as=0.2516p ps=2.16u w=0.74u l=0.13u
X1514 VGND VPWR VGND VGND sg13_lv_nmos ad=0.1428p pd=1.52u as=0 ps=0 w=0.42u l=1u
X1515 VPWR VGND VPWR VPWR sg13_lv_pmos ad=0.34p pd=2.68u as=0 ps=0 w=1u l=1u
X1516 _191_.Y _192_.C VGND VGND sg13_lv_nmos ad=0.1406p pd=1.12u as=0.2516p ps=2.16u w=0.74u l=0.13u
X1517 VPWR VGND VPWR VPWR sg13_lv_pmos ad=0.19p pd=1.38u as=0 ps=0 w=1u l=1u
X1518 VGND VPWR VGND VGND sg13_lv_nmos ad=0.1428p pd=1.52u as=0 ps=0 w=0.42u l=1u
X1519 VGND VPWR VGND VGND sg13_lv_nmos ad=0.1428p pd=1.52u as=0 ps=0 w=0.42u l=1u
X1520 VGND VPWR VGND VGND sg13_lv_nmos ad=0.1428p pd=1.52u as=0 ps=0 w=0.42u l=1u
X1521 VGND VPWR VGND VGND sg13_lv_nmos ad=79.8f pd=0.8u as=0 ps=0 w=0.42u l=1u
X1522 a_2565_12983# _247_.CLK a_3025_13325# VGND sg13_lv_nmos ad=0.2516p pd=2.16u as=0.31732p ps=1.805u w=0.74u l=0.13u
X1523 _189_.X _148_.B a_5178_13330# VGND sg13_lv_nmos ad=0.1628p pd=1.18u as=88.8f ps=0.98u w=0.74u l=0.13u
X1524 a_4177_5414# a_3717_5423# a_3819_5423# VPWR sg13_lv_pmos ad=0.41165p pd=2.12u as=0.3864p ps=2.93u w=1.12u l=0.13u
X1525 VPWR VGND VPWR VPWR sg13_lv_pmos ad=0.19p pd=1.38u as=0 ps=0 w=1u l=1u
X1526 a_2122_16969# a_2565_16725# a_2505_17137# VPWR sg13_lv_pmos ad=79.8f pd=0.8u as=63f ps=0.72u w=0.42u l=0.13u
X1527 _243_.CLK a_3956_6888# VGND VGND sg13_lv_nmos ad=0.1406p pd=1.12u as=0.1406p ps=1.12u w=0.74u l=0.13u
X1528 VGND VPWR VGND VGND sg13_lv_nmos ad=79.8f pd=0.8u as=0 ps=0 w=0.42u l=1u
X1529 VPWR a_10415_12287# a_11082_12508# VPWR sg13_lv_pmos ad=0.2128p pd=1.5u as=0.3864p ps=2.93u w=1.12u l=0.13u
X1530 VPWR VGND VPWR VPWR sg13_lv_pmos ad=0.34p pd=2.68u as=0 ps=0 w=1u l=1u
X1531 _207_.A2 a_4512_17547# a_4661_17878# VGND sg13_lv_nmos ad=0.2516p pd=2.16u as=0.1406p ps=1.12u w=0.74u l=0.13u
X1532 a_2298_15238# a_2232_15428# VGND VGND sg13_lv_nmos ad=0.3367p pd=1.65u as=0.148p ps=1.14u w=0.74u l=0.13u
X1533 VPWR VGND VPWR VPWR sg13_lv_pmos ad=0.19p pd=1.38u as=0 ps=0 w=1u l=1u
X1534 VGND _241_.Y a_11172_16746# VGND sg13_lv_nmos ad=0.1626p pd=1.415u as=60.89999f ps=0.71u w=0.42u l=0.13u
X1535 VPWR VGND VPWR VPWR sg13_lv_pmos ad=0.34p pd=2.68u as=0 ps=0 w=1u l=1u
X1536 VPWR VGND VPWR VPWR sg13_lv_pmos ad=0.19p pd=1.38u as=0 ps=0 w=1u l=1u
X1537 VGND VPWR VGND VGND sg13_lv_nmos ad=0.1428p pd=1.52u as=0 ps=0 w=0.42u l=1u
X1538 VGND VPWR VGND VGND sg13_lv_nmos ad=79.8f pd=0.8u as=0 ps=0 w=0.42u l=1u
X1539 _172_.Y a_9120_9501# a_9269_9190# VGND sg13_lv_nmos ad=0.2516p pd=2.16u as=0.1406p ps=1.12u w=0.74u l=0.13u
X1540 a_8006_16746# a_8811_16868# a_8266_16969# VPWR sg13_lv_pmos ad=0.1428p pd=1.52u as=79.8f ps=0.8u w=0.42u l=0.13u
X1541 _264_.Q a_14730_15996# VGND VGND sg13_lv_nmos ad=0.2516p pd=2.16u as=0.1406p ps=1.12u w=0.74u l=0.13u
X1542 a_2398_4654# _210_.A a_2301_4654# VGND sg13_lv_nmos ad=0.1628p pd=1.18u as=0.13135p ps=1.095u w=0.74u l=0.13u
X1543 VPWR VGND VPWR VPWR sg13_lv_pmos ad=0.19p pd=1.38u as=0 ps=0 w=1u l=1u
X1544 a_13775_5782# a_13740_5678# _157_.B VGND sg13_lv_nmos ad=0.1406p pd=1.12u as=0.2516p ps=2.16u w=0.74u l=0.13u
X1545 VPWR VGND VPWR VPWR sg13_lv_pmos ad=0.19p pd=1.38u as=0 ps=0 w=1u l=1u
X1546 VGND _225_.A _225_.Y VGND sg13_lv_nmos ad=0.2516p pd=2.16u as=0.2516p ps=2.16u w=0.74u l=0.13u
X1547 VPWR VGND VPWR VPWR sg13_lv_pmos ad=0.19p pd=1.38u as=0 ps=0 w=1u l=1u
X1548 VPWR VGND VPWR VPWR sg13_lv_pmos ad=0.34p pd=2.68u as=0 ps=0 w=1u l=1u
X1549 VPWR a_9551_16823# a_9808_16966# VPWR sg13_lv_pmos ad=0.4659p pd=3.65u as=79.8f ps=0.8u w=0.42u l=0.13u
X1550 a_7622_16434# a_8427_16007# a_7882_15964# VPWR sg13_lv_pmos ad=0.1428p pd=1.52u as=79.8f ps=0.8u w=0.42u l=0.13u
X1551 a_3014_5850# a_3819_5423# a_3274_5380# VPWR sg13_lv_pmos ad=0.1428p pd=1.52u as=79.8f ps=0.8u w=0.42u l=0.13u
X1552 a_3664_16966# _222_.Y a_3724_17061# VPWR sg13_lv_pmos ad=79.8f pd=0.8u as=0.204p ps=1.835u w=0.42u l=0.13u
X1553 a_3407_13333# a_2565_12983# a_3313_13333# VGND sg13_lv_nmos ad=0.12665p pd=1.145u as=0.1428p ps=1.52u w=0.42u l=0.13u
X1554 VPWR VGND VPWR VPWR sg13_lv_pmos ad=0.19p pd=1.38u as=0 ps=0 w=1u l=1u
X1555 VGND _238_.Y a_16118_16759# VGND sg13_lv_nmos ad=0.1701p pd=1.65u as=37.8f ps=0.6u w=0.42u l=0.13u
X1556 VGND VPWR VGND VGND sg13_lv_nmos ad=0.1428p pd=1.52u as=0 ps=0 w=0.42u l=1u
X1557 VGND VPWR VGND VGND sg13_lv_nmos ad=79.8f pd=0.8u as=0 ps=0 w=0.42u l=1u
X1558 _148_.A a_5226_5412# VPWR VPWR sg13_lv_pmos ad=0.3808p pd=2.92u as=0.2128p ps=1.5u w=1.12u l=0.13u
X1559 _244_.D a_2494_6166# VGND VGND sg13_lv_nmos ad=0.4033p pd=2.57u as=0.148p ps=1.14u w=0.74u l=0.13u
X1560 a_12992_15437# _134_.Y VPWR VPWR sg13_lv_pmos ad=0.1596p pd=1.22u as=0.1918p ps=1.5u w=0.84u l=0.13u
X1561 VPWR _230_.Y a_8870_13722# VPWR sg13_lv_pmos ad=0.36237p pd=2.605u as=79.8f ps=0.8u w=0.42u l=0.13u
X1562 a_8250_13738# _186_.Y VGND VGND sg13_lv_nmos ad=88.8f pd=0.98u as=0.15245p ps=1.17u w=0.74u l=0.13u
X1563 a_13244_5412# _157_.B VPWR VPWR sg13_lv_pmos ad=0.2128p pd=1.5u as=0.2128p ps=1.5u w=1.12u l=0.13u
X1564 a_3526_5837# _244_.RESET_B VGND VGND sg13_lv_nmos ad=37.8f pd=0.6u as=0.1701p ps=1.65u w=0.42u l=0.13u
X1565 _178_.Y _178_.B1 a_6389_9484# VPWR sg13_lv_pmos ad=0.3808p pd=2.92u as=0.2128p ps=1.5u w=1.12u l=0.13u
X1566 VPWR VGND VPWR VPWR sg13_lv_pmos ad=0.19p pd=1.38u as=0 ps=0 w=1u l=1u
X1567 VPWR VGND VPWR VPWR sg13_lv_pmos ad=0.19p pd=1.38u as=0 ps=0 w=1u l=1u
X1568 _247_.CLK a_3380_13690# VGND VGND sg13_lv_nmos ad=0.1406p pd=1.12u as=0.1406p ps=1.12u w=0.74u l=0.13u
X1569 VPWR VGND VPWR VPWR sg13_lv_pmos ad=0.19p pd=1.38u as=0 ps=0 w=1u l=1u
X1570 a_8538_5375# _144_.B VGND VGND sg13_lv_nmos ad=0.17462p pd=1.185u as=0.15245p ps=1.17u w=0.55u l=0.13u
X1571 a_3025_17042# a_2565_16725# a_2667_16868# VPWR sg13_lv_pmos ad=0.41165p pd=2.12u as=0.3864p ps=2.93u w=1.12u l=0.13u
X1572 VPWR a_1580_16710# _222_.A VPWR sg13_lv_pmos ad=0.2114p pd=1.54u as=0.42p ps=2.99u w=1.12u l=0.13u
X1573 VPWR VGND VPWR VPWR sg13_lv_pmos ad=0.34p pd=2.68u as=0 ps=0 w=1u l=1u
X1574 a_9348_4968# a_9322_4873# VPWR VPWR sg13_lv_pmos ad=0.34p pd=2.68u as=0.36237p ps=2.605u w=1u l=0.13u
X1575 VPWR VGND VPWR VPWR sg13_lv_pmos ad=0.34p pd=2.68u as=0 ps=0 w=1u l=1u
X1576 VGND VPWR VGND VGND sg13_lv_nmos ad=79.8f pd=0.8u as=0 ps=0 w=0.42u l=1u
X1577 VPWR _236_.Y a_14794_11428# VPWR sg13_lv_pmos ad=0.1563p pd=1.22u as=0.147p ps=1.54u w=0.42u l=0.13u
X1578 _183_.Y _171_.Y VPWR VPWR sg13_lv_pmos ad=0.2128p pd=1.5u as=0.3808p ps=2.92u w=1.12u l=0.13u
X1579 VPWR a_15983_5773# a_16240_5654# VPWR sg13_lv_pmos ad=0.4659p pd=3.65u as=79.8f ps=0.8u w=0.42u l=0.13u
X1580 VPWR _153_.Y a_12652_6924# VPWR sg13_lv_pmos ad=0.4032p pd=2.96u as=0.1176p ps=1.33u w=1.12u l=0.13u
X1581 a_13041_7996# _153_.Y VPWR VPWR sg13_lv_pmos ad=0.1225p pd=1.245u as=0.36p ps=2.72u w=1u l=0.13u
X1582 a_3705_12525# a_2763_12332# a_3503_12287# VPWR sg13_lv_pmos ad=93.45f pd=0.865u as=0.2048p ps=1.63u w=0.42u l=0.13u
X1583 _139_.X _136_.A a_11034_4258# VGND sg13_lv_nmos ad=0.1628p pd=1.18u as=88.8f ps=0.98u w=0.74u l=0.13u
X1584 VPWR VGND VPWR VPWR sg13_lv_pmos ad=0.34p pd=2.68u as=0 ps=0 w=1u l=1u
X1585 VGND VPWR VGND VGND sg13_lv_nmos ad=79.8f pd=0.8u as=0 ps=0 w=0.42u l=1u
X1586 _243_.CLK a_3956_6888# VGND VGND sg13_lv_nmos ad=0.1406p pd=1.12u as=0.1406p ps=1.12u w=0.74u l=0.13u
X1587 VPWR VGND VPWR VPWR sg13_lv_pmos ad=0.34p pd=2.68u as=0 ps=0 w=1u l=1u
X1588 _236_.Y _236_.A VGND VGND sg13_lv_nmos ad=0.2516p pd=2.16u as=0.2516p ps=2.16u w=0.74u l=0.13u
X1589 VPWR _251_.CLK a_16840_4688# VPWR sg13_lv_pmos ad=0.2114p pd=1.54u as=0.2856p ps=2.36u w=0.84u l=0.13u
X1590 VPWR VGND VPWR VPWR sg13_lv_pmos ad=0.19p pd=1.38u as=0 ps=0 w=1u l=1u
X1591 a_3609_13095# a_2667_12983# a_3407_13333# VPWR sg13_lv_pmos ad=93.45f pd=0.865u as=0.2048p ps=1.63u w=0.42u l=0.13u
X1592 _247_.CLK a_3380_13690# VGND VGND sg13_lv_nmos ad=0.1406p pd=1.12u as=0.1406p ps=1.12u w=0.74u l=0.13u
X1593 VPWR VGND VPWR VPWR sg13_lv_pmos ad=0.19p pd=1.38u as=0 ps=0 w=1u l=1u
X1594 a_9734_17946# a_10539_17519# a_9994_17476# VPWR sg13_lv_pmos ad=0.1428p pd=1.52u as=79.8f ps=0.8u w=0.42u l=0.13u
X1595 a_9156_12528# a_9130_12433# VPWR VPWR sg13_lv_pmos ad=0.34p pd=2.68u as=0.36237p ps=2.605u w=1u l=0.13u
X1596 _237_.Y _236_.A VGND VGND sg13_lv_nmos ad=0.2516p pd=2.16u as=0.2516p ps=2.16u w=0.74u l=0.13u
X1597 VGND a_4559_5773# a_5226_5412# VGND sg13_lv_nmos ad=0.1406p pd=1.12u as=0.2516p ps=2.16u w=0.74u l=0.13u
X1598 a_16079_9263# a_15237_9165# a_15985_9263# VGND sg13_lv_nmos ad=0.12665p pd=1.145u as=0.1428p ps=1.52u w=0.42u l=0.13u
X1599 a_12804_16000# a_12778_15964# VGND VGND sg13_lv_nmos ad=0.2516p pd=2.16u as=0.1626p ps=1.415u w=0.74u l=0.13u
X1600 a_2436_16759# a_2148_17064# a_2374_16759# VGND sg13_lv_nmos ad=0.1428p pd=1.52u as=37.8f ps=0.6u w=0.42u l=0.13u
X1601 _120_.A0 a_4170_12508# VPWR VPWR sg13_lv_pmos ad=0.3808p pd=2.92u as=0.2128p ps=1.5u w=1.12u l=0.13u
X1602 VGND a_12401_4704# _148_.X VGND sg13_lv_nmos ad=0.3108p pd=2.32u as=0.1628p ps=1.18u w=0.74u l=0.13u
X1603 VPWR VGND VPWR VPWR sg13_lv_pmos ad=0.34p pd=2.68u as=0 ps=0 w=1u l=1u
X1604 VGND VPWR VGND VGND sg13_lv_nmos ad=79.8f pd=0.8u as=0 ps=0 w=0.42u l=1u
X1605 a_4012_8559# a_3952_8678# a_3897_8559# VPWR sg13_lv_pmos ad=0.204p pd=1.835u as=93.45f ps=0.865u w=0.42u l=0.13u
X1606 _193_.Y a_6958_13764# VGND VGND sg13_lv_nmos ad=0.1406p pd=1.12u as=0.17255p ps=1.25u w=0.74u l=0.13u
X1607 a_14482_16434# _237_.Y VGND VGND sg13_lv_nmos ad=37.8f pd=0.6u as=79.8f ps=0.8u w=0.42u l=0.13u
X1608 a_13073_7728# _153_.Y VGND VGND sg13_lv_nmos ad=0.17462p pd=1.185u as=0.374p ps=2.46u w=0.55u l=0.13u
X1609 VPWR a_16079_11821# a_16336_11702# VPWR sg13_lv_pmos ad=0.4659p pd=3.65u as=79.8f ps=0.8u w=0.42u l=0.13u
X1610 a_2126_17774# _250_.Q a_2298_17878# VGND sg13_lv_nmos ad=0.1628p pd=1.18u as=0.3367p ps=1.65u w=0.74u l=0.13u
X1611 fanout6.A a_10218_17044# VGND VGND sg13_lv_nmos ad=0.2516p pd=2.16u as=0.1406p ps=1.12u w=0.74u l=0.13u
X1612 VPWR a_7727_4727# a_8394_4948# VPWR sg13_lv_pmos ad=0.2128p pd=1.5u as=0.3864p ps=2.93u w=1.12u l=0.13u
X1613 VPWR VGND VPWR VPWR sg13_lv_pmos ad=0.19p pd=1.38u as=0 ps=0 w=1u l=1u
X1614 VPWR VGND VPWR VPWR sg13_lv_pmos ad=0.19p pd=1.38u as=0 ps=0 w=1u l=1u
X1615 VGND _124_.S a_2620_11830# VGND sg13_lv_nmos ad=0.18945p pd=1.27u as=0.13135p ps=1.095u w=0.74u l=0.13u
X1616 VGND VPWR VGND VGND sg13_lv_nmos ad=0.1428p pd=1.52u as=0 ps=0 w=0.42u l=1u
X1617 _215_.Y _215_.A VPWR VPWR sg13_lv_pmos ad=0.3808p pd=2.92u as=0.3808p ps=2.92u w=1.12u l=0.13u
X1618 VPWR _147_.A1 a_10764_5678# VPWR sg13_lv_pmos ad=0.4536p pd=2.76u as=0.1596p ps=1.22u w=0.84u l=0.13u
X1619 VGND VPWR VGND VGND sg13_lv_nmos ad=79.8f pd=0.8u as=0 ps=0 w=0.42u l=1u
X1620 a_15697_9482# a_15237_9165# a_15339_9308# VPWR sg13_lv_pmos ad=0.41165p pd=2.12u as=0.3864p ps=2.93u w=1.12u l=0.13u
X1621 VPWR _260_.RESET_B a_14534_9186# VPWR sg13_lv_pmos ad=0.36237p pd=2.605u as=79.8f ps=0.8u w=0.42u l=0.13u
X1622 VGND VPWR VGND VGND sg13_lv_nmos ad=79.8f pd=0.8u as=0 ps=0 w=0.42u l=1u
X1623 a_8870_12210# a_9675_12332# a_9130_12433# VPWR sg13_lv_pmos ad=0.1428p pd=1.52u as=79.8f ps=0.8u w=0.42u l=0.13u
X1624 _151_.X _151_.B a_13914_4666# VGND sg13_lv_nmos ad=0.1628p pd=1.18u as=88.8f ps=0.98u w=0.74u l=0.13u
X1625 a_3664_13214# a_3407_13333# a_3826_13410# VGND sg13_lv_nmos ad=0.1428p pd=1.52u as=37.8f ps=0.6u w=0.42u l=0.13u
X1626 VPWR _220_.Y a_1958_12210# VPWR sg13_lv_pmos ad=0.36237p pd=2.605u as=79.8f ps=0.8u w=0.42u l=0.13u
X1627 a_9734_17946# _214_.Y VPWR VPWR sg13_lv_pmos ad=79.8f pd=0.8u as=0.1428p ps=1.52u w=0.42u l=0.13u
X1628 a_6694_4663# _224_.Y VGND VGND sg13_lv_nmos ad=37.8f pd=0.6u as=0.1701p ps=1.65u w=0.42u l=0.13u
X1629 VPWR VGND VPWR VPWR sg13_lv_pmos ad=0.19p pd=1.38u as=0 ps=0 w=1u l=1u
X1630 a_14651_10996# _131_.A2 VPWR VPWR sg13_lv_pmos ad=0.3808p pd=2.92u as=0.2128p ps=1.5u w=1.12u l=0.13u
X1631 VPWR _122_.A0 _165_.Y VPWR sg13_lv_pmos ad=0.3808p pd=2.92u as=0.2128p ps=1.5u w=1.12u l=0.13u
X1632 VGND VPWR VGND VGND sg13_lv_nmos ad=79.8f pd=0.8u as=0 ps=0 w=0.42u l=1u
X1633 VPWR fanout6.A a_4512_17547# VPWR sg13_lv_pmos ad=0.2891p pd=1.695u as=0.1596p ps=1.22u w=0.84u l=0.13u
X1634 VGND VPWR VGND VGND sg13_lv_nmos ad=0.1428p pd=1.52u as=0 ps=0 w=0.42u l=1u
X1635 _168_.A a_11946_9484# VGND VGND sg13_lv_nmos ad=0.2516p pd=2.16u as=0.1406p ps=1.12u w=0.74u l=0.13u
X1636 VPWR _190_.A _196_.Y VPWR sg13_lv_pmos ad=0.3808p pd=2.92u as=0.2128p ps=1.5u w=1.12u l=0.13u
X1637 VGND VPWR VGND VGND sg13_lv_nmos ad=0.1428p pd=1.52u as=0 ps=0 w=0.42u l=1u
X1638 VPWR VGND VPWR VPWR sg13_lv_pmos ad=0.34p pd=2.68u as=0 ps=0 w=1u l=1u
X1639 VPWR VGND VPWR VPWR sg13_lv_pmos ad=0.19p pd=1.38u as=0 ps=0 w=1u l=1u
X1640 VGND _250_.RESET_B a_1956_16434# VGND sg13_lv_nmos ad=0.1626p pd=1.415u as=60.89999f ps=0.71u w=0.42u l=0.13u
X1641 VPWR _193_.Y a_7616_15437# VPWR sg13_lv_pmos ad=0.2856p pd=2.36u as=0.1596p ps=1.22u w=0.84u l=0.13u
X1642 VPWR VGND VPWR VPWR sg13_lv_pmos ad=0.34p pd=2.68u as=0 ps=0 w=1u l=1u
X1643 a_3695_8797# a_2853_8447# a_3601_8797# VGND sg13_lv_nmos ad=0.12665p pd=1.145u as=0.1428p ps=1.52u w=0.42u l=0.13u
X1644 VGND clkbuf_1_0__f_sclk.A a_3380_13690# VGND sg13_lv_nmos ad=0.2516p pd=2.16u as=0.1406p ps=1.12u w=0.74u l=0.13u
X1645 VGND VPWR VGND VGND sg13_lv_nmos ad=0.1428p pd=1.52u as=0 ps=0 w=0.42u l=1u
X1646 VGND VPWR VGND VGND sg13_lv_nmos ad=79.8f pd=0.8u as=0 ps=0 w=0.42u l=1u
X1647 _224_.Y _215_.A VPWR VPWR sg13_lv_pmos ad=0.3808p pd=2.92u as=0.3808p ps=2.92u w=1.12u l=0.13u
X1648 VGND VPWR VGND VGND sg13_lv_nmos ad=0.1428p pd=1.52u as=0 ps=0 w=0.42u l=1u
X1649 VGND VPWR VGND VGND sg13_lv_nmos ad=0.1428p pd=1.52u as=0 ps=0 w=0.42u l=1u
X1650 _178_.B1 _176_.B a_6579_11460# VPWR sg13_lv_pmos ad=0.2408p pd=1.55u as=0.1428p ps=1.375u w=1.12u l=0.13u
X1651 VGND VPWR VGND VGND sg13_lv_nmos ad=79.8f pd=0.8u as=0 ps=0 w=0.42u l=1u
X1652 VPWR VGND VPWR VPWR sg13_lv_pmos ad=0.34p pd=2.68u as=0 ps=0 w=1u l=1u
X1653 a_14794_8404# a_15237_8447# a_15177_8483# VPWR sg13_lv_pmos ad=79.8f pd=0.8u as=63f ps=0.72u w=0.42u l=0.13u
X1654 _222_.Y _222_.A VPWR VPWR sg13_lv_pmos ad=0.3808p pd=2.92u as=0.3808p ps=2.92u w=1.12u l=0.13u
X1655 a_2602_3868# a_3045_3911# a_2342_4338# VGND sg13_lv_nmos ad=79.8f pd=0.8u as=0.1296p ps=1.52u w=0.42u l=0.13u
X1656 a_13820_4948# _151_.B VPWR VPWR sg13_lv_pmos ad=0.2128p pd=1.5u as=0.2128p ps=1.5u w=1.12u l=0.13u
X1657 a_3760_12430# a_3503_12287# a_3922_12210# VGND sg13_lv_nmos ad=0.1428p pd=1.52u as=37.8f ps=0.6u w=0.42u l=0.13u
X1658 a_14820_11464# a_15339_11471# a_16079_11821# VGND sg13_lv_nmos ad=0.3473p pd=2.71u as=0.12665p ps=1.145u w=0.74u l=0.13u
X1659 a_13413_11460# _126_.B1 VPWR VPWR sg13_lv_pmos ad=0.2464p pd=1.56u as=0.3808p ps=2.92u w=1.12u l=0.13u
X1660 VPWR VGND VPWR VPWR sg13_lv_pmos ad=0.34p pd=2.68u as=0 ps=0 w=1u l=1u
X1661 fanout8.A a_1192_17508# VGND VGND sg13_lv_nmos ad=0.2886p pd=2.26u as=0.14875p ps=1.16u w=0.74u l=0.13u
X1662 VGND _193_.Y a_7985_13776# VGND sg13_lv_nmos ad=0.15245p pd=1.17u as=0.17462p ps=1.185u w=0.55u l=0.13u
X1663 VGND _260_.CLK _131_.B1 VGND sg13_lv_nmos ad=0.2516p pd=2.16u as=0.1406p ps=1.12u w=0.74u l=0.13u
X1664 VGND VPWR VGND VGND sg13_lv_nmos ad=0.1428p pd=1.52u as=0 ps=0 w=0.42u l=1u
X1665 VPWR VGND VPWR VPWR sg13_lv_pmos ad=0.19p pd=1.38u as=0 ps=0 w=1u l=1u
X1666 VGND _230_.Y a_8964_13722# VGND sg13_lv_nmos ad=0.1626p pd=1.415u as=60.89999f ps=0.71u w=0.42u l=0.13u
X1667 a_9120_9501# _171_.Y a_9083_9232# VGND sg13_lv_nmos ad=0.2176p pd=1.96u as=78.39999f ps=0.885u w=0.64u l=0.13u
X1668 VGND clkbuf_1_0__f_sclk.A a_3380_13690# VGND sg13_lv_nmos ad=0.1406p pd=1.12u as=0.1406p ps=1.12u w=0.74u l=0.13u
X1669 a_2628_3904# a_2602_3868# VPWR VPWR sg13_lv_pmos ad=0.34p pd=2.68u as=0.36237p ps=2.605u w=1u l=0.13u
X1670 a_9444_12223# a_9156_12528# a_9382_12223# VGND sg13_lv_nmos ad=0.1428p pd=1.52u as=37.8f ps=0.6u w=0.42u l=0.13u
X1671 VGND VPWR VGND VGND sg13_lv_nmos ad=79.8f pd=0.8u as=0 ps=0 w=0.42u l=1u
X1672 VPWR VGND VPWR VPWR sg13_lv_pmos ad=0.34p pd=2.68u as=0 ps=0 w=1u l=1u
X1673 VPWR VGND VPWR VPWR sg13_lv_pmos ad=0.19p pd=1.38u as=0 ps=0 w=1u l=1u
X1674 _184_.Y _173_.Y VPWR VPWR sg13_lv_pmos ad=0.3808p pd=2.92u as=0.2128p ps=1.5u w=1.12u l=0.13u
X1675 VGND _148_.B a_5050_15238# VGND sg13_lv_nmos ad=0.2516p pd=2.16u as=0.1406p ps=1.12u w=0.74u l=0.13u
X1676 VGND VPWR VGND VGND sg13_lv_nmos ad=79.8f pd=0.8u as=0 ps=0 w=0.42u l=1u
X1677 VGND VPWR VGND VGND sg13_lv_nmos ad=0.1428p pd=1.52u as=0 ps=0 w=0.42u l=1u
X1678 VGND VPWR VGND VGND sg13_lv_nmos ad=0.1428p pd=1.52u as=0 ps=0 w=0.42u l=1u
X1679 VPWR _145_.A2 a_7872_5451# VPWR sg13_lv_pmos ad=0.2891p pd=1.695u as=0.1596p ps=1.22u w=0.84u l=0.13u
X1680 VGND _151_.B a_13649_4704# VGND sg13_lv_nmos ad=0.15245p pd=1.17u as=0.17462p ps=1.185u w=0.55u l=0.13u
X1681 a_3952_8678# a_3695_8797# a_4114_8874# VGND sg13_lv_nmos ad=0.1428p pd=1.52u as=37.8f ps=0.6u w=0.42u l=0.13u
X1682 VPWR VGND VPWR VPWR sg13_lv_pmos ad=0.34p pd=2.68u as=0 ps=0 w=1u l=1u
X1683 a_6836_3900# a_6810_3863# _210_.B VPWR sg13_lv_pmos ad=0.2128p pd=1.5u as=0.3808p ps=2.92u w=1.12u l=0.13u
X1684 VPWR _149_.A a_13914_5412# VPWR sg13_lv_pmos ad=0.2891p pd=1.695u as=0.1428p ps=1.375u w=1.12u l=0.13u
X1685 a_2620_7678# _148_.A a_2126_7864# VGND sg13_lv_nmos ad=0.13135p pd=1.095u as=0.1628p ps=1.18u w=0.74u l=0.13u
X1686 _236_.Y _236_.A VPWR VPWR sg13_lv_pmos ad=0.3808p pd=2.92u as=0.3808p ps=2.92u w=1.12u l=0.13u
X1687 VGND VPWR VGND VGND sg13_lv_nmos ad=79.8f pd=0.8u as=0 ps=0 w=0.42u l=1u
X1688 a_15767_17137# _211_.Y a_16514_16746# VGND sg13_lv_nmos ad=0.1428p pd=1.52u as=60.89999f ps=0.71u w=0.42u l=0.13u
X1689 VPWR a_3956_6888# _243_.CLK VPWR sg13_lv_pmos ad=0.2128p pd=1.5u as=0.2128p ps=1.5u w=1.12u l=0.13u
X1690 VPWR _243_.RESET_B a_2602_3868# VPWR sg13_lv_pmos ad=0.1563p pd=1.22u as=0.147p ps=1.54u w=0.42u l=0.13u
X1691 _164_.Y _164_.B1 a_10895_8436# VPWR sg13_lv_pmos ad=0.2128p pd=1.5u as=0.2128p ps=1.5u w=1.12u l=0.13u
X1692 VGND _171_.Y a_8705_9212# VGND sg13_lv_nmos ad=0.2516p pd=2.16u as=0.1406p ps=1.12u w=0.74u l=0.13u
X1693 a_15697_11813# a_15237_11471# a_15339_11471# VGND sg13_lv_nmos ad=0.31732p pd=1.805u as=0.2516p ps=2.16u w=0.74u l=0.13u
X1694 a_10752_7989# _154_.X a_10715_7720# VGND sg13_lv_nmos ad=0.2176p pd=1.96u as=78.39999f ps=0.885u w=0.64u l=0.13u
X1695 VPWR VGND VPWR VPWR sg13_lv_pmos ad=0.34p pd=2.68u as=0 ps=0 w=1u l=1u
X1696 a_6584_12218# _192_.B a_6482_12218# VGND sg13_lv_nmos ad=0.1406p pd=1.12u as=0.1406p ps=1.12u w=0.74u l=0.13u
X1697 VPWR _208_.X a_6720_17061# VPWR sg13_lv_pmos ad=0.2891p pd=1.695u as=0.1596p ps=1.22u w=0.84u l=0.13u
X1698 VPWR VGND VPWR VPWR sg13_lv_pmos ad=0.19p pd=1.38u as=0 ps=0 w=1u l=1u
X1699 _243_.CLK a_3956_6888# VPWR VPWR sg13_lv_pmos ad=0.2128p pd=1.5u as=0.2128p ps=1.5u w=1.12u l=0.13u
X1700 VGND VPWR VGND VGND sg13_lv_nmos ad=0.1428p pd=1.52u as=0 ps=0 w=0.42u l=1u
X1701 a_10895_8436# _145_.X VPWR VPWR sg13_lv_pmos ad=0.2128p pd=1.5u as=0.2128p ps=1.5u w=1.12u l=0.13u
X1702 a_3313_8438# a_2853_8447# a_2955_8447# VPWR sg13_lv_pmos ad=0.41165p pd=2.12u as=0.3864p ps=2.93u w=1.12u l=0.13u
X1703 a_2126_13912# _120_.A0 a_2298_14020# VPWR sg13_lv_pmos ad=0.2225p pd=1.445u as=0.2975p ps=1.595u w=1u l=0.13u
X1704 _162_.B a_10752_7989# a_10901_7678# VGND sg13_lv_nmos ad=0.2516p pd=2.16u as=0.1406p ps=1.12u w=0.74u l=0.13u
X1705 _126_.B1 a_14058_12508# VGND VGND sg13_lv_nmos ad=0.2516p pd=2.16u as=0.1406p ps=1.12u w=0.74u l=0.13u
X1706 VGND VPWR VGND VGND sg13_lv_nmos ad=0.1428p pd=1.52u as=0 ps=0 w=0.42u l=1u
X1707 VPWR VGND VPWR VPWR sg13_lv_pmos ad=0.19p pd=1.38u as=0 ps=0 w=1u l=1u
X1708 VGND VPWR VGND VGND sg13_lv_nmos ad=79.8f pd=0.8u as=0 ps=0 w=0.42u l=1u
X1709 a_1862_13410# a_2667_12983# a_2122_12940# VPWR sg13_lv_pmos ad=0.1428p pd=1.52u as=79.8f ps=0.8u w=0.42u l=0.13u
X1710 a_4089_4023# a_3147_3911# a_3887_4261# VPWR sg13_lv_pmos ad=93.45f pd=0.865u as=0.2048p ps=1.63u w=0.42u l=0.13u
X1711 VPWR VGND VPWR VPWR sg13_lv_pmos ad=0.34p pd=2.68u as=0 ps=0 w=1u l=1u
X1712 a_11172_16746# _212_.Y a_11078_16746# VGND sg13_lv_nmos ad=60.89999f pd=0.71u as=0.1428p ps=1.52u w=0.42u l=0.13u
X1713 a_10415_13799# a_9573_13701# a_9156_14040# VPWR sg13_lv_pmos ad=0.2048p pd=1.63u as=0.34p ps=2.68u w=1u l=0.13u
X1714 VPWR a_2126_11726# _120_.X VPWR sg13_lv_pmos ad=0.2198p pd=1.52u as=0.6048p ps=3.32u w=1.12u l=0.13u
X1715 VGND VPWR VGND VGND sg13_lv_nmos ad=0.1428p pd=1.52u as=0 ps=0 w=0.42u l=1u
X1716 VGND _148_.B a_4858_12214# VGND sg13_lv_nmos ad=0.2516p pd=2.16u as=0.1406p ps=1.12u w=0.74u l=0.13u
X1717 a_10617_12525# a_9675_12332# a_10415_12287# VPWR sg13_lv_pmos ad=93.45f pd=0.865u as=0.2048p ps=1.63u w=0.42u l=0.13u
X1718 VPWR _232_.Y a_8006_16746# VPWR sg13_lv_pmos ad=0.36237p pd=2.605u as=79.8f ps=0.8u w=0.42u l=0.13u
X1719 VPWR VGND VPWR VPWR sg13_lv_pmos ad=0.34p pd=2.68u as=0 ps=0 w=1u l=1u
X1720 VGND VPWR VGND VGND sg13_lv_nmos ad=79.8f pd=0.8u as=0 ps=0 w=0.42u l=1u
X1721 VPWR VGND VPWR VPWR sg13_lv_pmos ad=0.34p pd=2.68u as=0 ps=0 w=1u l=1u
X1722 a_2724_8861# a_2436_8440# a_2662_8861# VGND sg13_lv_nmos ad=0.1428p pd=1.52u as=37.8f ps=0.6u w=0.42u l=0.13u
X1723 VPWR VGND VPWR VPWR sg13_lv_pmos ad=0.34p pd=2.68u as=0 ps=0 w=1u l=1u
X1724 a_2218_12433# a_2661_12189# a_1958_12210# VGND sg13_lv_nmos ad=79.8f pd=0.8u as=0.1296p ps=1.52u w=0.42u l=0.13u
X1725 a_9322_4873# a_9765_4629# a_9705_5041# VPWR sg13_lv_pmos ad=79.8f pd=0.8u as=63f ps=0.72u w=0.42u l=0.13u
X1726 VGND VPWR VGND VGND sg13_lv_nmos ad=0.1428p pd=1.52u as=0 ps=0 w=0.42u l=1u
X1727 VGND VPWR VGND VGND sg13_lv_nmos ad=79.8f pd=0.8u as=0 ps=0 w=0.42u l=1u
X1728 a_14265_16119# a_13323_16007# a_14063_16357# VPWR sg13_lv_pmos ad=93.45f pd=0.865u as=0.2048p ps=1.63u w=0.42u l=0.13u
X1729 VPWR VGND VPWR VPWR sg13_lv_pmos ad=0.19p pd=1.38u as=0 ps=0 w=1u l=1u
X1730 a_2398_5782# _125_.A1 a_2301_5782# VGND sg13_lv_nmos ad=0.1628p pd=1.18u as=0.13135p ps=1.095u w=0.74u l=0.13u
X1731 _210_.Y a_6060_4166# VPWR VPWR sg13_lv_pmos ad=0.2408p pd=1.55u as=0.3808p ps=2.92u w=1.12u l=0.13u
X1732 a_3956_6888# clkbuf_1_0__f_sclk.A VGND VGND sg13_lv_nmos ad=0.1406p pd=1.12u as=0.1406p ps=1.12u w=0.74u l=0.13u
X1733 _230_.Y _236_.A VGND VGND sg13_lv_nmos ad=0.2516p pd=2.16u as=0.2516p ps=2.16u w=0.74u l=0.13u
X1734 a_5297_12264# _120_.A0 VGND VGND sg13_lv_nmos ad=0.17462p pd=1.185u as=0.374p ps=2.46u w=0.55u l=0.13u
X1735 a_10308_9199# a_10539_9308# a_9994_9409# VGND sg13_lv_nmos ad=0.2373p pd=1.97u as=79.8f ps=0.8u w=0.42u l=0.13u
X1736 VPWR VGND VPWR VPWR sg13_lv_pmos ad=0.34p pd=2.68u as=0 ps=0 w=1u l=1u
X1737 VGND VPWR VGND VGND sg13_lv_nmos ad=0.1428p pd=1.52u as=0 ps=0 w=0.42u l=1u
X1738 VGND VPWR VGND VGND sg13_lv_nmos ad=79.8f pd=0.8u as=0 ps=0 w=0.42u l=1u
X1739 a_8557_4248# _144_.Y a_8386_3900# VPWR sg13_lv_pmos ad=0.35p pd=2.7u as=0.2125p ps=1.425u w=1u l=0.13u
X1740 _143_.A a_6747_5468# a_6949_5782# VGND sg13_lv_nmos ad=0.333p pd=2.38u as=0.1406p ps=1.12u w=0.74u l=0.13u
X1741 VGND VPWR VGND VGND sg13_lv_nmos ad=79.8f pd=0.8u as=0 ps=0 w=0.42u l=1u
X1742 a_2608_6166# _148_.A a_2494_6166# VGND sg13_lv_nmos ad=0.3367p pd=1.65u as=0.1628p ps=1.18u w=0.74u l=0.13u
X1743 VGND VPWR VGND VGND sg13_lv_nmos ad=79.8f pd=0.8u as=0 ps=0 w=0.42u l=1u
X1744 VPWR VGND VPWR VPWR sg13_lv_pmos ad=0.34p pd=2.68u as=0 ps=0 w=1u l=1u
X1745 VGND _164_.Y a_9269_9190# VGND sg13_lv_nmos ad=0.1898p pd=1.36u as=0.2516p ps=2.16u w=0.74u l=0.13u
X1746 VGND VPWR VGND VGND sg13_lv_nmos ad=0.1428p pd=1.52u as=0 ps=0 w=0.42u l=1u
X1747 a_8870_13722# _194_.X VPWR VPWR sg13_lv_pmos ad=79.8f pd=0.8u as=0.1428p ps=1.52u w=0.42u l=0.13u
X1748 a_7929_4965# a_6987_4772# a_7727_4727# VPWR sg13_lv_pmos ad=93.45f pd=0.865u as=0.2048p ps=1.63u w=0.42u l=0.13u
X1749 a_8156_14020# _193_.Y VPWR VPWR sg13_lv_pmos ad=0.2128p pd=1.5u as=0.2128p ps=1.5u w=1.12u l=0.13u
X1750 VGND a_3956_6888# _243_.CLK VGND sg13_lv_nmos ad=0.1406p pd=1.12u as=0.1406p ps=1.12u w=0.74u l=0.13u
X1751 VGND a_4625_16800# _208_.X VGND sg13_lv_nmos ad=0.3108p pd=2.32u as=0.1628p ps=1.18u w=0.74u l=0.13u
X1752 VPWR _214_.A _214_.Y VPWR sg13_lv_pmos ad=0.3808p pd=2.92u as=0.3808p ps=2.92u w=1.12u l=0.13u
X1753 VPWR VGND VPWR VPWR sg13_lv_pmos ad=0.19p pd=1.38u as=0 ps=0 w=1u l=1u
X1754 a_2298_15532# a_2232_15428# VPWR VPWR sg13_lv_pmos ad=0.2975p pd=1.595u as=0.2198p ps=1.52u w=1u l=0.13u
X1755 VPWR a_2075_5468# a_2575_5436# VPWR sg13_lv_pmos ad=0.2198p pd=1.52u as=0.2975p ps=1.595u w=1u l=0.13u
X1756 _157_.Y _157_.B a_13130_4948# VPWR sg13_lv_pmos ad=0.3808p pd=2.92u as=0.1176p ps=1.33u w=1.12u l=0.13u
X1757 a_15601_5765# a_15141_5423# a_15243_5423# VGND sg13_lv_nmos ad=0.31732p pd=1.805u as=0.2516p ps=2.16u w=0.74u l=0.13u
X1758 VGND _138_.Y a_8694_5770# VGND sg13_lv_nmos ad=0.15245p pd=1.17u as=88.8f ps=0.98u w=0.74u l=0.13u
X1759 VPWR VGND VPWR VPWR sg13_lv_pmos ad=0.19p pd=1.38u as=0 ps=0 w=1u l=1u
X1760 a_12778_15964# a_13221_16007# a_13161_16043# VPWR sg13_lv_pmos ad=79.8f pd=0.8u as=63f ps=0.72u w=0.42u l=0.13u
X1761 _243_.CLK a_3956_6888# VPWR VPWR sg13_lv_pmos ad=0.2128p pd=1.5u as=0.2128p ps=1.5u w=1.12u l=0.13u
X1762 VGND VPWR VGND VGND sg13_lv_nmos ad=0.1428p pd=1.52u as=0 ps=0 w=0.42u l=1u
X1763 VGND _178_.B1 _178_.Y VGND sg13_lv_nmos ad=0.2516p pd=2.16u as=0.1406p ps=1.12u w=0.74u l=0.13u
X1764 VPWR VGND VPWR VPWR sg13_lv_pmos ad=0.34p pd=2.68u as=0 ps=0 w=1u l=1u
X1765 a_9573_12189# _251_.CLK a_10033_12231# VGND sg13_lv_nmos ad=0.2516p pd=2.16u as=0.31732p ps=1.805u w=0.74u l=0.13u
X1766 VGND a_10672_12430# a_10321_12287# VGND sg13_lv_nmos ad=79.8f pd=0.8u as=0.1428p ps=1.52u w=0.42u l=0.13u
X1767 _122_.A0 a_4362_8436# VPWR VPWR sg13_lv_pmos ad=0.3808p pd=2.92u as=0.2128p ps=1.5u w=1.12u l=0.13u
X1768 a_7168_15260# _204_.X _205_.Y VGND sg13_lv_nmos ad=0.1406p pd=1.12u as=0.2516p ps=2.16u w=0.74u l=0.13u
X1769 VPWR VGND VPWR VPWR sg13_lv_pmos ad=0.19p pd=1.38u as=0 ps=0 w=1u l=1u
X1770 VGND _239_.Y a_14148_15234# VGND sg13_lv_nmos ad=0.1626p pd=1.415u as=60.89999f ps=0.71u w=0.42u l=0.13u
X1771 a_10672_12430# a_10415_12287# a_10834_12210# VGND sg13_lv_nmos ad=0.1428p pd=1.52u as=37.8f ps=0.6u w=0.42u l=0.13u
X1772 VGND VPWR VGND VGND sg13_lv_nmos ad=79.8f pd=0.8u as=0 ps=0 w=0.42u l=1u
X1773 _244_.D a_2494_6166# VPWR VPWR sg13_lv_pmos ad=0.6048p pd=3.32u as=0.2198p ps=1.52u w=1.12u l=0.13u
X1774 VPWR VGND VPWR VPWR sg13_lv_pmos ad=0.19p pd=1.38u as=0 ps=0 w=1u l=1u
X1775 VPWR VGND VPWR VPWR sg13_lv_pmos ad=0.34p pd=2.68u as=0 ps=0 w=1u l=1u
X1776 a_15237_9165# _260_.CLK a_15697_9207# VGND sg13_lv_nmos ad=0.2516p pd=2.16u as=0.31732p ps=1.805u w=0.74u l=0.13u
X1777 a_7064_9194# _174_.Y a_6962_9194# VGND sg13_lv_nmos ad=0.1406p pd=1.12u as=0.1406p ps=1.12u w=0.74u l=0.13u
X1778 _199_.B1 _207_.A2 a_5619_17044# VPWR sg13_lv_pmos ad=0.2408p pd=1.55u as=0.1428p ps=1.375u w=1.12u l=0.13u
X1779 VPWR VGND VPWR VPWR sg13_lv_pmos ad=0.19p pd=1.38u as=0 ps=0 w=1u l=1u
X1780 VPWR VGND VPWR VPWR sg13_lv_pmos ad=0.19p pd=1.38u as=0 ps=0 w=1u l=1u
X1781 _234_.Y _236_.A VGND VGND sg13_lv_nmos ad=0.2516p pd=2.16u as=0.2516p ps=2.16u w=0.74u l=0.13u
X1782 a_6095_4270# _210_.A VGND VGND sg13_lv_nmos ad=0.2516p pd=2.16u as=0.1898p ps=1.36u w=0.74u l=0.13u
X1783 VGND VPWR VGND VGND sg13_lv_nmos ad=0.1428p pd=1.52u as=0 ps=0 w=0.42u l=1u
X1784 a_3588_4663# a_3300_4968# a_3526_4663# VGND sg13_lv_nmos ad=0.1428p pd=1.52u as=37.8f ps=0.6u w=0.42u l=0.13u
X1785 VGND _251_.CLK a_16840_4688# VGND sg13_lv_nmos ad=0.14875p pd=1.16u as=0.187p ps=1.78u w=0.55u l=0.13u
X1786 VPWR VGND VPWR VPWR sg13_lv_pmos ad=0.34p pd=2.68u as=0 ps=0 w=1u l=1u
X1787 a_13403_8436# _151_.B VPWR VPWR sg13_lv_pmos ad=0.3808p pd=2.92u as=0.2128p ps=1.5u w=1.12u l=0.13u
X1788 freq_out a_16840_4688# VGND VGND sg13_lv_nmos ad=0.2886p pd=2.26u as=0.14875p ps=1.16u w=0.74u l=0.13u
X1789 a_6683_16792# _205_.Y VGND VGND sg13_lv_nmos ad=78.39999f pd=0.885u as=0.2272p ps=1.99u w=0.64u l=0.13u
X1790 VGND VPWR VGND VGND sg13_lv_nmos ad=0.1428p pd=1.52u as=0 ps=0 w=0.42u l=1u
X1791 VGND _234_.Y a_11940_12210# VGND sg13_lv_nmos ad=0.1626p pd=1.415u as=60.89999f ps=0.71u w=0.42u l=0.13u
X1792 a_3045_3911# _243_.CLK a_3505_4253# VGND sg13_lv_nmos ad=0.2516p pd=2.16u as=0.31732p ps=1.805u w=0.74u l=0.13u
X1793 VGND VPWR VGND VGND sg13_lv_nmos ad=79.8f pd=0.8u as=0 ps=0 w=0.42u l=1u
X1794 VPWR VGND VPWR VPWR sg13_lv_pmos ad=0.34p pd=2.68u as=0 ps=0 w=1u l=1u
X1795 a_4593_17068# _250_.Q VPWR VPWR sg13_lv_pmos ad=0.1225p pd=1.245u as=0.36p ps=2.72u w=1u l=0.13u
X1796 a_3826_13410# _221_.Y VGND VGND sg13_lv_nmos ad=37.8f pd=0.6u as=79.8f ps=0.8u w=0.42u l=0.13u
X1797 a_12132_12528# a_12106_12433# VPWR VPWR sg13_lv_pmos ad=0.34p pd=2.68u as=0.36237p ps=2.605u w=1u l=0.13u
X1798 VGND VPWR VGND VGND sg13_lv_nmos ad=0.1428p pd=1.52u as=0 ps=0 w=0.42u l=1u
X1799 VPWR VGND VPWR VPWR sg13_lv_pmos ad=0.19p pd=1.38u as=0 ps=0 w=1u l=1u
X1800 VGND _232_.Y a_8100_16746# VGND sg13_lv_nmos ad=0.1626p pd=1.415u as=60.89999f ps=0.71u w=0.42u l=0.13u
X1801 a_14357_12972# _131_.A2 VPWR VPWR sg13_lv_pmos ad=0.2128p pd=1.5u as=0.2128p ps=1.5u w=1.12u l=0.13u
X1802 a_4512_17547# fanout6.A a_4475_17856# VGND sg13_lv_nmos ad=0.2176p pd=1.96u as=78.39999f ps=0.885u w=0.64u l=0.13u
X1803 a_7074_15532# _186_.Y a_6862_15532# VPWR sg13_lv_pmos ad=0.2128p pd=1.5u as=0.2128p ps=1.5u w=1.12u l=0.13u
X1804 VGND VPWR VGND VGND sg13_lv_nmos ad=79.8f pd=0.8u as=0 ps=0 w=0.42u l=1u
X1805 VPWR VGND VPWR VPWR sg13_lv_pmos ad=0.19p pd=1.38u as=0 ps=0 w=1u l=1u
X1806 VPWR VGND VPWR VPWR sg13_lv_pmos ad=0.19p pd=1.38u as=0 ps=0 w=1u l=1u
X1807 VPWR _149_.A a_13019_6460# VPWR sg13_lv_pmos ad=0.2128p pd=1.5u as=0.2128p ps=1.5u w=1.12u l=0.13u
X1808 a_7984_4870# _224_.Y a_8044_4965# VPWR sg13_lv_pmos ad=79.8f pd=0.8u as=0.204p ps=1.835u w=0.42u l=0.13u
X1809 a_13121_6188# _149_.A _153_.Y VGND sg13_lv_nmos ad=0.1406p pd=1.12u as=0.1406p ps=1.12u w=0.74u l=0.13u
X1810 _199_.B1 a_5376_17061# a_5525_16750# VGND sg13_lv_nmos ad=0.2516p pd=2.16u as=0.1406p ps=1.12u w=0.74u l=0.13u
X1811 VGND _149_.A a_14196_5760# VGND sg13_lv_nmos ad=0.2272p pd=1.99u as=78.39999f ps=0.885u w=0.64u l=0.13u
X1812 VGND _131_.A2 a_14753_10724# VGND sg13_lv_nmos ad=0.2516p pd=2.16u as=0.1406p ps=1.12u w=0.74u l=0.13u
X1813 a_16185_5535# a_15243_5423# a_15983_5773# VPWR sg13_lv_pmos ad=93.45f pd=0.865u as=0.2048p ps=1.63u w=0.42u l=0.13u
X1814 VGND a_7984_4870# a_7633_4727# VGND sg13_lv_nmos ad=79.8f pd=0.8u as=0.1428p ps=1.52u w=0.42u l=0.13u
X1815 VGND VPWR VGND VGND sg13_lv_nmos ad=0.1428p pd=1.52u as=0 ps=0 w=0.42u l=1u
X1816 VPWR a_15980_7638# _251_.CLK VPWR sg13_lv_pmos ad=0.2114p pd=1.54u as=0.42p ps=2.99u w=1.12u l=0.13u
X1817 VGND VPWR VGND VGND sg13_lv_nmos ad=0.1428p pd=1.52u as=0 ps=0 w=0.42u l=1u
X1818 a_3717_4629# _243_.CLK a_4177_4671# VGND sg13_lv_nmos ad=0.2516p pd=2.16u as=0.31732p ps=1.805u w=0.74u l=0.13u
X1819 VPWR a_2126_17774# _250_.D VPWR sg13_lv_pmos ad=0.2198p pd=1.52u as=0.6048p ps=3.32u w=1.12u l=0.13u
X1820 VPWR _225_.A _225_.Y VPWR sg13_lv_pmos ad=0.3808p pd=2.92u as=0.3808p ps=2.92u w=1.12u l=0.13u
X1821 VPWR VGND VPWR VPWR sg13_lv_pmos ad=0.19p pd=1.38u as=0 ps=0 w=1u l=1u
X1822 VGND VPWR VGND VGND sg13_lv_nmos ad=0.1428p pd=1.52u as=0 ps=0 w=0.42u l=1u
X1823 a_14820_8440# a_14794_8404# VPWR VPWR sg13_lv_pmos ad=0.34p pd=2.68u as=0.36237p ps=2.605u w=1u l=0.13u
X1824 a_16240_12430# _235_.Y a_16300_12525# VPWR sg13_lv_pmos ad=79.8f pd=0.8u as=0.204p ps=1.835u w=0.42u l=0.13u
X1825 a_15108_9199# a_15339_9308# a_14794_9409# VGND sg13_lv_nmos ad=0.2373p pd=1.97u as=79.8f ps=0.8u w=0.42u l=0.13u
X1826 VPWR a_8557_4248# _145_.X VPWR sg13_lv_pmos ad=0.3808p pd=2.92u as=0.2128p ps=1.5u w=1.12u l=0.13u
X1827 _225_.A a_9352_17508# VPWR VPWR sg13_lv_pmos ad=0.42p pd=2.99u as=0.2114p ps=1.54u w=1.12u l=0.13u
X1828 VPWR VGND VPWR VPWR sg13_lv_pmos ad=0.34p pd=2.68u as=0 ps=0 w=1u l=1u
X1829 _244_.RESET_B _215_.A VGND VGND sg13_lv_nmos ad=0.2516p pd=2.16u as=0.2516p ps=2.16u w=0.74u l=0.13u
X1830 VGND VPWR VGND VGND sg13_lv_nmos ad=0.1428p pd=1.52u as=0 ps=0 w=0.42u l=1u
X1831 VPWR VGND VPWR VPWR sg13_lv_pmos ad=0.19p pd=1.38u as=0 ps=0 w=1u l=1u
X1832 a_14359_16710# a_14919_16964# a_14940_16710# VGND sg13_lv_nmos ad=0.12665p pd=1.145u as=0.3473p ps=2.71u w=0.74u l=0.13u
X1833 VPWR _236_.A _240_.Y VPWR sg13_lv_pmos ad=0.3808p pd=2.92u as=0.3808p ps=2.92u w=1.12u l=0.13u
X1834 _239_.Y _225_.A VGND VGND sg13_lv_nmos ad=0.2516p pd=2.16u as=0.2516p ps=2.16u w=0.74u l=0.13u
X1835 VPWR VGND VPWR VPWR sg13_lv_pmos ad=0.19p pd=1.38u as=0 ps=0 w=1u l=1u
X1836 VGND a_3886_10702# clkbuf_1_0__f_sclk.A VGND sg13_lv_nmos ad=0.1406p pd=1.12u as=0.1406p ps=1.12u w=0.74u l=0.13u
X1837 VPWR VGND VPWR VPWR sg13_lv_pmos ad=0.34p pd=2.68u as=0 ps=0 w=1u l=1u
X1838 VGND VPWR VGND VGND sg13_lv_nmos ad=0.1428p pd=1.52u as=0 ps=0 w=0.42u l=1u
X1839 a_6971_16344# _201_.Y VGND VGND sg13_lv_nmos ad=78.39999f pd=0.885u as=0.2272p ps=1.99u w=0.64u l=0.13u
X1840 VGND VPWR VGND VGND sg13_lv_nmos ad=79.8f pd=0.8u as=0 ps=0 w=0.42u l=1u
X1841 a_4816_4870# _215_.Y a_4876_4965# VPWR sg13_lv_pmos ad=79.8f pd=0.8u as=0.204p ps=1.835u w=0.42u l=0.13u
X1842 VPWR _173_.Y a_6124_9945# VPWR sg13_lv_pmos ad=0.1596p pd=1.22u as=0.2856p ps=2.36u w=0.84u l=0.13u
X1843 VPWR VGND VPWR VPWR sg13_lv_pmos ad=0.19p pd=1.38u as=0 ps=0 w=1u l=1u
X1844 VGND VPWR VGND VGND sg13_lv_nmos ad=79.8f pd=0.8u as=0 ps=0 w=0.42u l=1u
X1845 a_16514_16746# _238_.Y VGND VGND sg13_lv_nmos ad=60.89999f pd=0.71u as=0.1626p ps=1.415u w=0.42u l=0.13u
X1846 VGND VPWR VGND VGND sg13_lv_nmos ad=0.1428p pd=1.52u as=0 ps=0 w=0.42u l=1u
X1847 a_6810_3863# _136_.B VGND VGND sg13_lv_nmos ad=0.17462p pd=1.185u as=0.15245p ps=1.17u w=0.55u l=0.13u
X1848 VGND VPWR VGND VGND sg13_lv_nmos ad=0.1428p pd=1.52u as=0 ps=0 w=0.42u l=1u
X1849 VPWR _164_.Y a_8156_9928# VPWR sg13_lv_pmos ad=0.3808p pd=2.92u as=0.2128p ps=1.5u w=1.12u l=0.15u
X1850 VPWR VGND VPWR VPWR sg13_lv_pmos ad=0.34p pd=2.68u as=0 ps=0 w=1u l=1u
X1851 VPWR a_6336_11499# _178_.B1 VPWR sg13_lv_pmos ad=0.3808p pd=2.92u as=0.2408p ps=1.55u w=1.12u l=0.13u
X1852 a_3695_9263# a_2853_9165# a_3601_9263# VGND sg13_lv_nmos ad=0.12665p pd=1.145u as=0.1428p ps=1.52u w=0.42u l=0.13u
X1853 a_10940_3900# _136_.A VPWR VPWR sg13_lv_pmos ad=0.2128p pd=1.5u as=0.2128p ps=1.5u w=1.12u l=0.13u
X1854 VPWR a_3886_10702# clkbuf_1_0__f_sclk.A VPWR sg13_lv_pmos ad=0.2128p pd=1.5u as=0.2128p ps=1.5u w=1.12u l=0.13u
X1855 VGND VPWR VGND VGND sg13_lv_nmos ad=0.1428p pd=1.52u as=0 ps=0 w=0.42u l=1u
X1856 a_2397_6166# _124_.S VGND VGND sg13_lv_nmos ad=0.13135p pd=1.095u as=0.18945p ps=1.27u w=0.74u l=0.13u
X1857 VGND a_11536_17750# a_11185_17869# VGND sg13_lv_nmos ad=79.8f pd=0.8u as=0.1428p ps=1.52u w=0.42u l=0.13u
X1858 VPWR VGND VPWR VPWR sg13_lv_pmos ad=0.34p pd=2.68u as=0 ps=0 w=1u l=1u
X1859 VGND a_3886_10702# clkbuf_1_0__f_sclk.A VGND sg13_lv_nmos ad=0.1406p pd=1.12u as=0.1406p ps=1.12u w=0.74u l=0.13u
X1860 VGND sclk a_3886_10702# VGND sg13_lv_nmos ad=0.1406p pd=1.12u as=0.1406p ps=1.12u w=0.74u l=0.13u
X1861 _237_.Y _236_.A VPWR VPWR sg13_lv_pmos ad=0.3808p pd=2.92u as=0.3808p ps=2.92u w=1.12u l=0.13u
X1862 a_10769_4258# _136_.A a_10737_3900# VPWR sg13_lv_pmos ad=0.34p pd=2.68u as=0.1225p ps=1.245u w=1u l=0.13u
X1863 VPWR VGND VPWR VPWR sg13_lv_pmos ad=0.34p pd=2.68u as=0 ps=0 w=1u l=1u
X1864 a_12549_7996# _162_.Y a_12215_7664# VPWR sg13_lv_pmos ad=0.2125p pd=1.425u as=0.35p ps=2.7u w=1u l=0.13u
X1865 _177_.X a_6124_9945# VGND VGND sg13_lv_nmos ad=0.2516p pd=2.16u as=0.1371p ps=1.12u w=0.74u l=0.13u
X1866 VGND VPWR VGND VGND sg13_lv_nmos ad=79.8f pd=0.8u as=0 ps=0 w=0.42u l=1u
X1867 a_11661_4696# _243_.Q VPWR VPWR sg13_lv_pmos ad=0.1596p pd=1.22u as=0.2856p ps=2.36u w=0.84u l=0.13u
X1868 VPWR VGND VPWR VPWR sg13_lv_pmos ad=0.34p pd=2.68u as=0 ps=0 w=1u l=1u
X1869 VGND VPWR VGND VGND sg13_lv_nmos ad=0.1428p pd=1.52u as=0 ps=0 w=0.42u l=1u
X1870 VPWR _148_.B _195_.Y VPWR sg13_lv_pmos ad=0.3808p pd=2.92u as=0.2128p ps=1.5u w=1.12u l=0.13u
X1871 a_2565_16725# _247_.CLK a_3025_16767# VGND sg13_lv_nmos ad=0.2516p pd=2.16u as=0.31732p ps=1.805u w=0.74u l=0.13u
X1872 VPWR _184_.Y a_7157_9948# VPWR sg13_lv_pmos ad=0.2128p pd=1.5u as=0.3808p ps=2.92u w=1.12u l=0.13u
X1873 VPWR _222_.A _250_.RESET_B VPWR sg13_lv_pmos ad=0.3808p pd=2.92u as=0.3808p ps=2.92u w=1.12u l=0.13u
X1874 _192_.Y _187_.Y a_6584_12218# VGND sg13_lv_nmos ad=0.2516p pd=2.16u as=0.1406p ps=1.12u w=0.74u l=0.13u
X1875 VGND VPWR VGND VGND sg13_lv_nmos ad=0.1428p pd=1.52u as=0 ps=0 w=0.42u l=1u
X1876 VGND a_10220_18222# _236_.A VGND sg13_lv_nmos ad=0.14875p pd=1.16u as=0.2886p ps=2.26u w=0.74u l=0.13u
X1877 a_10377_17555# a_10020_17512# VPWR VPWR sg13_lv_pmos ad=63f pd=0.72u as=0.1563p ps=1.22u w=0.42u l=0.13u
X1878 VPWR _124_.S a_2558_11484# VPWR sg13_lv_pmos ad=0.253p pd=1.53u as=0.3325p ps=1.665u w=1u l=0.13u
X1879 VPWR a_3886_10702# clkbuf_1_0__f_sclk.A VPWR sg13_lv_pmos ad=0.2128p pd=1.5u as=0.2128p ps=1.5u w=1.12u l=0.13u
X1880 VPWR sclk a_3886_10702# VPWR sg13_lv_pmos ad=0.2128p pd=1.5u as=0.2128p ps=1.5u w=1.12u l=0.13u
X1881 a_3956_6888# clkbuf_1_0__f_sclk.A VPWR VPWR sg13_lv_pmos ad=0.2128p pd=1.5u as=0.2128p ps=1.5u w=1.12u l=0.13u
X1882 VPWR VGND VPWR VPWR sg13_lv_pmos ad=0.34p pd=2.68u as=0 ps=0 w=1u l=1u
X1883 a_3664_16966# a_3407_16823# a_3826_16746# VGND sg13_lv_nmos ad=0.1428p pd=1.52u as=37.8f ps=0.6u w=0.42u l=0.13u
X1884 a_15767_17137# a_15071_17016# a_15861_16904# VGND sg13_lv_nmos ad=0.1296p pd=1.52u as=79.8f ps=0.8u w=0.42u l=0.13u
X1885 VPWR a_3695_8797# a_3952_8678# VPWR sg13_lv_pmos ad=0.4659p pd=3.65u as=79.8f ps=0.8u w=0.42u l=0.13u
X1886 VPWR _210_.B a_6747_5468# VPWR sg13_lv_pmos ad=0.2198p pd=1.53u as=0.2856p ps=2.36u w=0.84u l=0.13u
X1887 VGND a_15856_15454# a_15505_15311# VGND sg13_lv_nmos ad=79.8f pd=0.8u as=0.1428p ps=1.52u w=0.42u l=0.13u
X1888 _194_.X _193_.Y a_8250_13738# VGND sg13_lv_nmos ad=0.1628p pd=1.18u as=88.8f ps=0.98u w=0.74u l=0.13u
X1889 _136_.A a_8488_8436# VGND VGND sg13_lv_nmos ad=0.2886p pd=2.26u as=0.14875p ps=1.16u w=0.74u l=0.13u
X1890 clkbuf_1_0__f_sclk.A a_3886_10702# VGND VGND sg13_lv_nmos ad=0.1406p pd=1.12u as=0.1406p ps=1.12u w=0.74u l=0.13u
X1891 a_5427_15260# _196_.Y VGND VGND sg13_lv_nmos ad=0.1406p pd=1.12u as=0.2516p ps=2.16u w=0.74u l=0.13u
X1892 VPWR a_15599_15311# a_15856_15454# VPWR sg13_lv_pmos ad=0.4659p pd=3.65u as=79.8f ps=0.8u w=0.42u l=0.13u
X1893 VPWR _149_.A a_13740_5678# VPWR sg13_lv_pmos ad=0.4536p pd=2.76u as=0.1596p ps=1.22u w=0.84u l=0.13u
X1894 VGND VPWR VGND VGND sg13_lv_nmos ad=0.1428p pd=1.52u as=0 ps=0 w=0.42u l=1u
X1895 VPWR a_3956_6888# _243_.CLK VPWR sg13_lv_pmos ad=0.2128p pd=1.5u as=0.2128p ps=1.5u w=1.12u l=0.13u
X1896 VGND VPWR VGND VGND sg13_lv_nmos ad=0.1428p pd=1.52u as=0 ps=0 w=0.42u l=1u
X1897 VPWR VGND VPWR VPWR sg13_lv_pmos ad=0.34p pd=2.68u as=0 ps=0 w=1u l=1u
X1898 VGND VPWR VGND VGND sg13_lv_nmos ad=0.1428p pd=1.52u as=0 ps=0 w=0.42u l=1u
X1899 VGND VPWR VGND VGND sg13_lv_nmos ad=0.1428p pd=1.52u as=0 ps=0 w=0.42u l=1u
X1900 VGND VPWR VGND VGND sg13_lv_nmos ad=0.1428p pd=1.52u as=0 ps=0 w=0.42u l=1u
X1901 VPWR VGND VPWR VPWR sg13_lv_pmos ad=0.19p pd=1.38u as=0 ps=0 w=1u l=1u
X1902 a_12623_16823# a_11781_16725# a_11364_17064# VPWR sg13_lv_pmos ad=0.2048p pd=1.63u as=0.34p ps=2.68u w=1u l=0.13u
X1903 VGND VPWR VGND VGND sg13_lv_nmos ad=79.8f pd=0.8u as=0 ps=0 w=0.42u l=1u
X1904 _260_.RESET_B _225_.A VPWR VPWR sg13_lv_pmos ad=0.3808p pd=2.92u as=0.3808p ps=2.92u w=1.12u l=0.13u
X1905 a_15081_12601# a_14724_12528# VPWR VPWR sg13_lv_pmos ad=63f pd=0.72u as=0.1563p ps=1.22u w=0.42u l=0.13u
X1906 _243_.RESET_B _215_.A VGND VGND sg13_lv_nmos ad=0.2516p pd=2.16u as=0.2516p ps=2.16u w=0.74u l=0.13u
X1907 VGND VPWR VGND VGND sg13_lv_nmos ad=79.8f pd=0.8u as=0 ps=0 w=0.42u l=1u
X1908 a_2148_16000# a_2122_15964# VPWR VPWR sg13_lv_pmos ad=0.34p pd=2.68u as=0.36237p ps=2.605u w=1u l=0.13u
X1909 a_2374_16421# _250_.RESET_B VGND VGND sg13_lv_nmos ad=37.8f pd=0.6u as=0.1701p ps=1.65u w=0.42u l=0.13u
X1910 _143_.Y _143_.A VGND VGND sg13_lv_nmos ad=0.2516p pd=2.16u as=0.2516p ps=2.16u w=0.74u l=0.13u
X1911 VPWR VGND VPWR VPWR sg13_lv_pmos ad=0.19p pd=1.38u as=0 ps=0 w=1u l=1u
X1912 clkbuf_1_0__f_sclk.A a_3886_10702# VPWR VPWR sg13_lv_pmos ad=0.2128p pd=1.5u as=0.2128p ps=1.5u w=1.12u l=0.13u
X1913 _170_.Y _168_.Y VPWR VPWR sg13_lv_pmos ad=0.2128p pd=1.5u as=0.3808p ps=2.92u w=1.12u l=0.13u
X1914 a_2232_17770# _124_.S VPWR VPWR sg13_lv_pmos ad=0.2856p pd=2.36u as=0.253p ps=1.53u w=0.84u l=0.13u
X1915 VPWR VGND VPWR VPWR sg13_lv_pmos ad=0.19p pd=1.38u as=0 ps=0 w=1u l=1u
X1916 VPWR VGND VPWR VPWR sg13_lv_pmos ad=0.19p pd=1.38u as=0 ps=0 w=1u l=1u
X1917 VPWR VGND VPWR VPWR sg13_lv_pmos ad=0.34p pd=2.68u as=0 ps=0 w=1u l=1u
X1918 _260_.CLK a_16746_11460# VPWR VPWR sg13_lv_pmos ad=0.3808p pd=2.92u as=0.2128p ps=1.5u w=1.12u l=0.13u
X1919 VGND _164_.B1 _164_.Y VGND sg13_lv_nmos ad=0.2516p pd=2.16u as=0.1406p ps=1.12u w=0.74u l=0.13u
X1920 VGND VPWR VGND VGND sg13_lv_nmos ad=0.1428p pd=1.52u as=0 ps=0 w=0.42u l=1u
X1921 VPWR VGND VPWR VPWR sg13_lv_pmos ad=0.34p pd=2.68u as=0 ps=0 w=1u l=1u
X1922 _247_.CLK a_3380_13690# VPWR VPWR sg13_lv_pmos ad=0.2128p pd=1.5u as=0.2128p ps=1.5u w=1.12u l=0.13u
X1923 VGND VPWR VGND VGND sg13_lv_nmos ad=0.1428p pd=1.52u as=0 ps=0 w=0.42u l=1u
X1924 a_2628_3904# a_3147_3911# a_3887_4261# VGND sg13_lv_nmos ad=0.3473p pd=2.71u as=0.12665p ps=1.145u w=0.74u l=0.13u
X1925 _174_.Y _168_.B VPWR VPWR sg13_lv_pmos ad=0.2128p pd=1.5u as=0.3808p ps=2.92u w=1.12u l=0.13u
X1926 a_2620_10318# _122_.A0 a_2126_10214# VGND sg13_lv_nmos ad=0.13135p pd=1.095u as=0.1628p ps=1.18u w=0.74u l=0.13u
X1927 a_5333_15532# _195_.Y VPWR VPWR sg13_lv_pmos ad=0.2128p pd=1.5u as=0.2128p ps=1.5u w=1.12u l=0.13u
X1928 VGND _157_.B _157_.Y VGND sg13_lv_nmos ad=0.2516p pd=2.16u as=0.1406p ps=1.12u w=0.74u l=0.13u
X1929 VGND VPWR VGND VGND sg13_lv_nmos ad=79.8f pd=0.8u as=0 ps=0 w=0.42u l=1u
X1930 VGND VPWR VGND VGND sg13_lv_nmos ad=79.8f pd=0.8u as=0 ps=0 w=0.42u l=1u
X1931 VPWR _210_.A a_6234_3900# VPWR sg13_lv_pmos ad=0.2891p pd=1.695u as=0.1428p ps=1.375u w=1.12u l=0.13u
X1932 a_10989_8784# _145_.X _164_.Y VGND sg13_lv_nmos ad=0.1406p pd=1.12u as=0.1406p ps=1.12u w=0.74u l=0.13u
X1933 VGND VPWR VGND VGND sg13_lv_nmos ad=79.8f pd=0.8u as=0 ps=0 w=0.42u l=1u
X1934 VPWR _226_.Y a_14698_5380# VPWR sg13_lv_pmos ad=0.1563p pd=1.22u as=0.147p ps=1.54u w=0.42u l=0.13u
X1935 a_2122_15964# a_2565_16007# a_1862_16434# VGND sg13_lv_nmos ad=79.8f pd=0.8u as=0.1296p ps=1.52u w=0.42u l=0.13u
X1936 VGND _247_.CLK clkload0.Y VGND sg13_lv_nmos ad=0.2516p pd=2.16u as=0.2516p ps=2.16u w=0.74u l=0.13u
X1937 VGND a_8557_4248# _145_.X VGND sg13_lv_nmos ad=0.2516p pd=2.16u as=0.1406p ps=1.12u w=0.74u l=0.13u
X1938 VPWR VGND VPWR VPWR sg13_lv_pmos ad=0.19p pd=1.38u as=0 ps=0 w=1u l=1u
X1939 VPWR VGND VPWR VPWR sg13_lv_pmos ad=0.19p pd=1.38u as=0 ps=0 w=1u l=1u
X1940 VGND VPWR VGND VGND sg13_lv_nmos ad=79.8f pd=0.8u as=0 ps=0 w=0.42u l=1u
X1941 VGND VPWR VGND VGND sg13_lv_nmos ad=79.8f pd=0.8u as=0 ps=0 w=0.42u l=1u
X1942 VGND VPWR VGND VGND sg13_lv_nmos ad=0.1428p pd=1.52u as=0 ps=0 w=0.42u l=1u
X1943 VGND VPWR VGND VGND sg13_lv_nmos ad=0.1428p pd=1.52u as=0 ps=0 w=0.42u l=1u
X1944 a_2244_8874# _122_.X a_2150_8874# VGND sg13_lv_nmos ad=60.89999f pd=0.71u as=0.1428p ps=1.52u w=0.42u l=0.13u
X1945 VPWR VGND VPWR VPWR sg13_lv_pmos ad=0.19p pd=1.38u as=0 ps=0 w=1u l=1u
X1946 a_10033_12231# a_9573_12189# a_9675_12332# VGND sg13_lv_nmos ad=0.31732p pd=1.805u as=0.2516p ps=2.16u w=0.74u l=0.13u
X1947 a_2494_6166# _148_.A a_2397_6460# VPWR sg13_lv_pmos ad=0.2225p pd=1.445u as=0.3325p ps=1.665u w=1u l=0.13u
X1948 VGND clkbuf_1_0__f_sclk.A a_3956_6888# VGND sg13_lv_nmos ad=0.2516p pd=2.16u as=0.1406p ps=1.12u w=0.74u l=0.13u
X1949 VGND VPWR VGND VGND sg13_lv_nmos ad=79.8f pd=0.8u as=0 ps=0 w=0.42u l=1u
X1950 _250_.Q a_4074_15996# VPWR VPWR sg13_lv_pmos ad=0.3808p pd=2.92u as=0.2128p ps=1.5u w=1.12u l=0.13u
X1951 _247_.CLK a_3380_13690# VPWR VPWR sg13_lv_pmos ad=0.2128p pd=1.5u as=0.2128p ps=1.5u w=1.12u l=0.13u
X1952 VPWR VGND VPWR VPWR sg13_lv_pmos ad=0.34p pd=2.68u as=0 ps=0 w=1u l=1u
X1953 VPWR VGND VPWR VPWR sg13_lv_pmos ad=0.19p pd=1.38u as=0 ps=0 w=1u l=1u
X1954 VPWR VGND VPWR VPWR sg13_lv_pmos ad=0.19p pd=1.38u as=0 ps=0 w=1u l=1u
X1955 a_13914_4666# _145_.X VGND VGND sg13_lv_nmos ad=88.8f pd=0.98u as=0.15245p ps=1.17u w=0.74u l=0.13u
X1956 VGND VPWR VGND VGND sg13_lv_nmos ad=0.1428p pd=1.52u as=0 ps=0 w=0.42u l=1u
X1957 a_14240_16921# a_14359_16710# VPWR VPWR sg13_lv_pmos ad=0.3864p pd=2.93u as=0.2128p ps=1.5u w=1.12u l=0.13u
X1958 VPWR VGND VPWR VPWR sg13_lv_pmos ad=0.19p pd=1.38u as=0 ps=0 w=1u l=1u
X1959 VPWR VGND VPWR VPWR sg13_lv_pmos ad=0.19p pd=1.38u as=0 ps=0 w=1u l=1u
X1960 VPWR VGND VPWR VPWR sg13_lv_pmos ad=0.34p pd=2.68u as=0 ps=0 w=1u l=1u
X1961 VGND a_2126_15424# _118_.X VGND sg13_lv_nmos ad=0.148p pd=1.14u as=0.4033p ps=2.57u w=0.74u l=0.13u
X1962 VPWR VGND VPWR VPWR sg13_lv_pmos ad=0.34p pd=2.68u as=0 ps=0 w=1u l=1u
X1963 VPWR VGND VPWR VPWR sg13_lv_pmos ad=0.19p pd=1.38u as=0 ps=0 w=1u l=1u
X1964 a_13221_16007# _266_.CLK a_13681_15998# VPWR sg13_lv_pmos ad=0.4088p pd=2.97u as=0.41165p ps=2.12u w=1.12u l=0.13u
X1965 a_7180_14020# a_6958_13764# VPWR VPWR sg13_lv_pmos ad=0.1176p pd=1.33u as=0.2618p ps=1.63u w=1.12u l=0.13u
X1966 VGND a_13100_13686# _148_.B VGND sg13_lv_nmos ad=0.14875p pd=1.16u as=0.2886p ps=2.26u w=0.74u l=0.13u
X1967 VGND VPWR VGND VGND sg13_lv_nmos ad=0.1428p pd=1.52u as=0 ps=0 w=0.42u l=1u
X1968 a_9808_16966# a_9551_16823# a_9970_16746# VGND sg13_lv_nmos ad=0.1428p pd=1.52u as=37.8f ps=0.6u w=0.42u l=0.13u
X1969 a_6095_4270# a_6060_4166# _210_.Y VGND sg13_lv_nmos ad=0.1406p pd=1.12u as=0.2516p ps=2.16u w=0.74u l=0.13u
X1970 VGND _226_.Y a_14532_5850# VGND sg13_lv_nmos ad=0.1626p pd=1.415u as=60.89999f ps=0.71u w=0.42u l=0.13u
X1971 a_14572_16746# a_14359_16710# VPWR VPWR sg13_lv_pmos ad=79.8f pd=0.8u as=0.4659p ps=3.65u w=0.42u l=0.13u
X1972 VGND VPWR VGND VGND sg13_lv_nmos ad=79.8f pd=0.8u as=0 ps=0 w=0.42u l=1u
X1973 a_8134_16421# _258_.RESET_B VGND VGND sg13_lv_nmos ad=37.8f pd=0.6u as=0.1701p ps=1.65u w=0.42u l=0.13u
X1974 VGND a_3695_8797# a_4362_8436# VGND sg13_lv_nmos ad=0.1406p pd=1.12u as=0.2516p ps=2.16u w=0.74u l=0.13u
X1975 _260_.CLK a_16746_11460# VGND VGND sg13_lv_nmos ad=0.2516p pd=2.16u as=0.1406p ps=1.12u w=0.74u l=0.13u
X1976 VPWR a_10415_13799# a_11082_14020# VPWR sg13_lv_pmos ad=0.2128p pd=1.5u as=0.3864p ps=2.93u w=1.12u l=0.13u
X1977 VPWR VGND VPWR VPWR sg13_lv_pmos ad=0.19p pd=1.38u as=0 ps=0 w=1u l=1u
X1978 VPWR VGND VPWR VPWR sg13_lv_pmos ad=0.19p pd=1.38u as=0 ps=0 w=1u l=1u
X1979 VPWR a_5376_17061# _199_.B1 VPWR sg13_lv_pmos ad=0.3808p pd=2.92u as=0.2408p ps=1.55u w=1.12u l=0.13u
X1980 a_6197_13342# _189_.X VGND VGND sg13_lv_nmos ad=0.1406p pd=1.12u as=0.1898p ps=1.36u w=0.74u l=0.13u
X1981 VGND a_11536_9406# a_11185_9263# VGND sg13_lv_nmos ad=79.8f pd=0.8u as=0.1428p ps=1.52u w=0.42u l=0.13u
X1982 _132_.Y _131_.A2 VGND VGND sg13_lv_nmos ad=0.1406p pd=1.12u as=0.2516p ps=2.16u w=0.74u l=0.13u
X1983 _136_.B a_8394_4948# VGND VGND sg13_lv_nmos ad=0.2516p pd=2.16u as=0.1406p ps=1.12u w=0.74u l=0.13u
X1984 fanout7.A a_16746_9484# VPWR VPWR sg13_lv_pmos ad=0.3808p pd=2.92u as=0.2128p ps=1.5u w=1.12u l=0.13u
X1985 a_6182_4650# _210_.Y VPWR VPWR sg13_lv_pmos ad=79.8f pd=0.8u as=0.1428p ps=1.52u w=0.42u l=0.13u
X1986 VPWR clkbuf_1_0__f_sclk.A a_3380_13690# VPWR sg13_lv_pmos ad=0.3808p pd=2.92u as=0.2128p ps=1.5u w=1.12u l=0.13u
X1987 VPWR VGND VPWR VPWR sg13_lv_pmos ad=0.19p pd=1.38u as=0 ps=0 w=1u l=1u
X1988 VGND VPWR VGND VGND sg13_lv_nmos ad=0.1428p pd=1.52u as=0 ps=0 w=0.42u l=1u
X1989 a_14340_15552# a_14314_15457# VPWR VPWR sg13_lv_pmos ad=0.34p pd=2.68u as=0.36237p ps=2.605u w=1u l=0.13u
X1990 VPWR VGND VPWR VPWR sg13_lv_pmos ad=0.34p pd=2.68u as=0 ps=0 w=1u l=1u
X1991 VPWR a_16079_8797# a_16746_8436# VPWR sg13_lv_pmos ad=0.2128p pd=1.5u as=0.3864p ps=2.93u w=1.12u l=0.13u
X1992 VPWR VGND VPWR VPWR sg13_lv_pmos ad=0.19p pd=1.38u as=0 ps=0 w=1u l=1u
X1993 a_9130_12433# a_9573_12189# a_8870_12210# VGND sg13_lv_nmos ad=79.8f pd=0.8u as=0.1296p ps=1.52u w=0.42u l=0.13u
X1994 VGND _207_.A2 a_5249_16344# VGND sg13_lv_nmos ad=0.2516p pd=2.16u as=0.1406p ps=1.12u w=0.74u l=0.13u
X1995 a_7882_15964# a_8325_16007# a_7622_16434# VGND sg13_lv_nmos ad=79.8f pd=0.8u as=0.1296p ps=1.52u w=0.42u l=0.13u
X1996 a_13648_12430# _234_.Y a_13708_12525# VPWR sg13_lv_pmos ad=79.8f pd=0.8u as=0.204p ps=1.835u w=0.42u l=0.13u
X1997 VPWR VGND VPWR VPWR sg13_lv_pmos ad=0.34p pd=2.68u as=0 ps=0 w=1u l=1u
X1998 a_16498_11898# _236_.Y VGND VGND sg13_lv_nmos ad=37.8f pd=0.6u as=79.8f ps=0.8u w=0.42u l=0.13u
X1999 VGND _220_.Y a_2052_12210# VGND sg13_lv_nmos ad=0.1626p pd=1.415u as=60.89999f ps=0.71u w=0.42u l=0.13u
X2000 VPWR VGND VPWR VPWR sg13_lv_pmos ad=0.19p pd=1.38u as=0 ps=0 w=1u l=1u
X2001 VGND _143_.A a_8021_5782# VGND sg13_lv_nmos ad=0.1898p pd=1.36u as=0.2516p ps=2.16u w=0.74u l=0.13u
X2002 VGND VPWR VGND VGND sg13_lv_nmos ad=0.1428p pd=1.52u as=0 ps=0 w=0.42u l=1u
X2003 a_2436_16421# a_2148_16000# a_2374_16421# VGND sg13_lv_nmos ad=0.1428p pd=1.52u as=37.8f ps=0.6u w=0.42u l=0.13u
X2004 VPWR VGND VPWR VPWR sg13_lv_pmos ad=0.34p pd=2.68u as=0 ps=0 w=1u l=1u
X2005 a_7739_9484# _170_.B VPWR VPWR sg13_lv_pmos ad=0.3808p pd=2.92u as=0.2128p ps=1.5u w=1.12u l=0.13u
X2006 VGND _136_.A a_6966_4258# VGND sg13_lv_nmos ad=0.15245p pd=1.17u as=88.8f ps=0.98u w=0.74u l=0.13u
X2007 VPWR VGND VPWR VPWR sg13_lv_pmos ad=0.34p pd=2.68u as=0 ps=0 w=1u l=1u
X2008 VPWR VGND VPWR VPWR sg13_lv_pmos ad=0.19p pd=1.38u as=0 ps=0 w=1u l=1u
X2009 VGND VPWR VGND VGND sg13_lv_nmos ad=79.8f pd=0.8u as=0 ps=0 w=0.42u l=1u
X2010 VGND a_3695_9263# a_4362_9484# VGND sg13_lv_nmos ad=0.1406p pd=1.12u as=0.2516p ps=2.16u w=0.74u l=0.13u
X2011 a_3407_13333# a_2565_12983# a_2148_12976# VPWR sg13_lv_pmos ad=0.2048p pd=1.63u as=0.34p ps=2.68u w=1u l=0.13u
X2012 VPWR clkbuf_1_0__f_sclk.A a_3380_13690# VPWR sg13_lv_pmos ad=0.2128p pd=1.5u as=0.2128p ps=1.5u w=1.12u l=0.13u
X2013 VPWR VGND VPWR VPWR sg13_lv_pmos ad=0.19p pd=1.38u as=0 ps=0 w=1u l=1u
X2014 VPWR VGND VPWR VPWR sg13_lv_pmos ad=0.34p pd=2.68u as=0 ps=0 w=1u l=1u
X2015 VPWR VGND VPWR VPWR sg13_lv_pmos ad=0.19p pd=1.38u as=0 ps=0 w=1u l=1u
X2016 a_2298_13726# a_2232_13916# VGND VGND sg13_lv_nmos ad=0.3367p pd=1.65u as=0.148p ps=1.14u w=0.74u l=0.13u
X2017 VGND VPWR VGND VGND sg13_lv_nmos ad=0.1428p pd=1.52u as=0 ps=0 w=0.42u l=1u
X2018 VGND VPWR VGND VGND sg13_lv_nmos ad=79.8f pd=0.8u as=0 ps=0 w=0.42u l=1u
X2019 a_3300_5416# a_3274_5380# VPWR VPWR sg13_lv_pmos ad=0.34p pd=2.68u as=0.36237p ps=2.605u w=1u l=0.13u
X2020 VPWR a_12623_16823# a_13290_17044# VPWR sg13_lv_pmos ad=0.2128p pd=1.5u as=0.3864p ps=2.93u w=1.12u l=0.13u
X2021 VGND _139_.X a_10799_5782# VGND sg13_lv_nmos ad=0.1898p pd=1.36u as=0.1406p ps=1.12u w=0.74u l=0.13u
X2022 VPWR VGND VPWR VPWR sg13_lv_pmos ad=0.19p pd=1.38u as=0 ps=0 w=1u l=1u
X2023 VPWR VGND VPWR VPWR sg13_lv_pmos ad=0.34p pd=2.68u as=0 ps=0 w=1u l=1u
X2024 a_3887_4261# a_3045_3911# a_3793_4261# VGND sg13_lv_nmos ad=0.12665p pd=1.145u as=0.1428p ps=1.52u w=0.42u l=0.13u
X2025 _227_.Y _225_.A VPWR VPWR sg13_lv_pmos ad=0.3808p pd=2.92u as=0.3808p ps=2.92u w=1.12u l=0.13u
X2026 VGND a_3380_13690# _247_.CLK VGND sg13_lv_nmos ad=0.1406p pd=1.12u as=0.1406p ps=1.12u w=0.74u l=0.13u
X2027 _234_.Y _236_.A VPWR VPWR sg13_lv_pmos ad=0.3808p pd=2.92u as=0.3808p ps=2.92u w=1.12u l=0.13u
X2028 _243_.D a_2398_4654# VPWR VPWR sg13_lv_pmos ad=0.6048p pd=3.32u as=0.2198p ps=1.52u w=1.12u l=0.13u
X2029 VPWR VGND VPWR VPWR sg13_lv_pmos ad=0.19p pd=1.38u as=0 ps=0 w=1u l=1u
X2030 a_9156_14040# a_9130_13945# VPWR VPWR sg13_lv_pmos ad=0.34p pd=2.68u as=0.36237p ps=2.605u w=1u l=0.13u
X2031 a_14532_12210# _129_.Y a_14438_12210# VGND sg13_lv_nmos ad=60.89999f pd=0.71u as=0.1428p ps=1.52u w=0.42u l=0.13u
X2032 _158_.Y _157_.Y VGND VGND sg13_lv_nmos ad=0.1406p pd=1.12u as=0.2516p ps=2.16u w=0.74u l=0.13u
X2033 a_9994_17476# a_10437_17519# a_9734_17946# VGND sg13_lv_nmos ad=79.8f pd=0.8u as=0.1296p ps=1.52u w=0.42u l=0.13u
X2034 VPWR a_6747_5468# _143_.A VPWR sg13_lv_pmos ad=0.3808p pd=2.92u as=0.2128p ps=1.5u w=1.12u l=0.13u
X2035 VPWR sdata a_1192_7712# VPWR sg13_lv_pmos ad=0.2114p pd=1.54u as=0.2856p ps=2.36u w=0.84u l=0.13u
X2036 _213_.Y _251_.CLK VGND VGND sg13_lv_nmos ad=0.2516p pd=2.16u as=0.2516p ps=2.16u w=0.74u l=0.13u
X2037 a_14340_15552# a_14314_15457# VGND VGND sg13_lv_nmos ad=0.2516p pd=2.16u as=0.1626p ps=1.415u w=0.74u l=0.13u
X2038 VGND a_2075_4692# a_2512_4654# VGND sg13_lv_nmos ad=0.148p pd=1.14u as=0.3367p ps=1.65u w=0.74u l=0.13u
X2039 VPWR VGND VPWR VPWR sg13_lv_pmos ad=0.34p pd=2.68u as=0 ps=0 w=1u l=1u
X2040 VGND VPWR VGND VGND sg13_lv_nmos ad=0.1428p pd=1.52u as=0 ps=0 w=0.42u l=1u
X2041 _211_.Y _264_.Q VPWR VPWR sg13_lv_pmos ad=0.3808p pd=2.92u as=0.3808p ps=2.92u w=1.12u l=0.13u
X2042 VGND VPWR VGND VGND sg13_lv_nmos ad=0.1428p pd=1.52u as=0 ps=0 w=0.42u l=1u
X2043 VPWR _244_.RESET_B a_3274_5380# VPWR sg13_lv_pmos ad=0.1563p pd=1.22u as=0.147p ps=1.54u w=0.42u l=0.13u
X2044 VGND VPWR VGND VGND sg13_lv_nmos ad=0.1428p pd=1.52u as=0 ps=0 w=0.42u l=1u
X2045 VGND VPWR VGND VGND sg13_lv_nmos ad=0.1428p pd=1.52u as=0 ps=0 w=0.42u l=1u
X2046 VPWR _258_.RESET_B a_7882_15964# VPWR sg13_lv_pmos ad=0.1563p pd=1.22u as=0.147p ps=1.54u w=0.42u l=0.13u
X2047 VGND VPWR VGND VGND sg13_lv_nmos ad=79.8f pd=0.8u as=0 ps=0 w=0.42u l=1u
X2048 VPWR VGND VPWR VPWR sg13_lv_pmos ad=0.19p pd=1.38u as=0 ps=0 w=1u l=1u
X2049 a_2397_6460# _124_.S VPWR VPWR sg13_lv_pmos ad=0.3325p pd=1.665u as=0.253p ps=1.53u w=1u l=0.13u
X2050 a_3826_16746# _222_.Y VGND VGND sg13_lv_nmos ad=37.8f pd=0.6u as=79.8f ps=0.8u w=0.42u l=0.13u
X2051 VPWR VGND VPWR VPWR sg13_lv_pmos ad=0.19p pd=1.38u as=0 ps=0 w=1u l=1u
X2052 VPWR VGND VPWR VPWR sg13_lv_pmos ad=0.19p pd=1.38u as=0 ps=0 w=1u l=1u
X2053 VPWR VGND VPWR VPWR sg13_lv_pmos ad=0.34p pd=2.68u as=0 ps=0 w=1u l=1u
X2054 VGND VPWR VGND VGND sg13_lv_nmos ad=79.8f pd=0.8u as=0 ps=0 w=0.42u l=1u
X2055 a_13649_4704# _151_.B a_13617_4972# VPWR sg13_lv_pmos ad=0.34p pd=2.68u as=0.1225p ps=1.245u w=1u l=0.13u
X2056 VGND VPWR VGND VGND sg13_lv_nmos ad=79.8f pd=0.8u as=0 ps=0 w=0.42u l=1u
X2057 VPWR _196_.Y _200_.Y VPWR sg13_lv_pmos ad=0.2128p pd=1.5u as=0.2128p ps=1.5u w=1.12u l=0.13u
X2058 a_5562_12226# _120_.A0 VGND VGND sg13_lv_nmos ad=88.8f pd=0.98u as=0.15245p ps=1.17u w=0.74u l=0.13u
X2059 a_9466_7678# _154_.X VGND VGND sg13_lv_nmos ad=0.1406p pd=1.12u as=0.2516p ps=2.16u w=0.74u l=0.13u
X2060 VGND VPWR VGND VGND sg13_lv_nmos ad=0.1428p pd=1.52u as=0 ps=0 w=0.42u l=1u
X2061 _202_.Y _191_.Y VGND VGND sg13_lv_nmos ad=0.1406p pd=1.12u as=0.2516p ps=2.16u w=0.74u l=0.13u
X2062 _159_.Y _158_.Y a_14067_7972# VPWR sg13_lv_pmos ad=0.2408p pd=1.55u as=0.1428p ps=1.375u w=1.12u l=0.13u
X2063 a_10246_9199# _228_.Y VGND VGND sg13_lv_nmos ad=37.8f pd=0.6u as=0.1701p ps=1.65u w=0.42u l=0.13u
X2064 a_3025_12974# a_2565_12983# a_2667_12983# VPWR sg13_lv_pmos ad=0.41165p pd=2.12u as=0.3864p ps=2.93u w=1.12u l=0.13u
X2065 VPWR _139_.X a_11381_3900# VPWR sg13_lv_pmos ad=0.2128p pd=1.5u as=0.3808p ps=2.92u w=1.12u l=0.13u
X2066 a_11721_17137# a_11364_17064# VPWR VPWR sg13_lv_pmos ad=63f pd=0.72u as=0.1563p ps=1.22u w=0.42u l=0.13u
X2067 _220_.Y _215_.A VGND VGND sg13_lv_nmos ad=0.2516p pd=2.16u as=0.2516p ps=2.16u w=0.74u l=0.13u
X2068 VPWR VGND VPWR VPWR sg13_lv_pmos ad=0.34p pd=2.68u as=0 ps=0 w=1u l=1u
X2069 a_4306_4338# _243_.RESET_B VGND VGND sg13_lv_nmos ad=37.8f pd=0.6u as=79.8f ps=0.8u w=0.42u l=0.13u
X2070 a_6218_10296# _173_.Y a_6124_9945# VGND sg13_lv_nmos ad=0.1216p pd=1.02u as=0.2176p ps=1.96u w=0.64u l=0.13u
X2071 a_2126_15424# _118_.A0 a_2298_15238# VGND sg13_lv_nmos ad=0.1628p pd=1.18u as=0.3367p ps=1.65u w=0.74u l=0.13u
X2072 _151_.B _157_.B a_13338_5770# VGND sg13_lv_nmos ad=0.1628p pd=1.18u as=88.8f ps=0.98u w=0.74u l=0.13u
X2073 _185_.Y _171_.A a_7251_10296# VGND sg13_lv_nmos ad=0.1406p pd=1.12u as=0.1406p ps=1.12u w=0.74u l=0.13u
X2074 a_10834_13722# _230_.Y VGND VGND sg13_lv_nmos ad=37.8f pd=0.6u as=79.8f ps=0.8u w=0.42u l=0.13u
X2075 VGND a_16336_9406# a_15985_9263# VGND sg13_lv_nmos ad=79.8f pd=0.8u as=0.1428p ps=1.52u w=0.42u l=0.13u
X2076 VGND VPWR VGND VGND sg13_lv_nmos ad=79.8f pd=0.8u as=0 ps=0 w=0.42u l=1u
X2077 a_2565_16725# _247_.CLK a_3025_17042# VPWR sg13_lv_pmos ad=0.4088p pd=2.97u as=0.41165p ps=2.12u w=1.12u l=0.13u
X2078 a_8694_5770# _144_.B _145_.A2 VGND sg13_lv_nmos ad=88.8f pd=0.98u as=0.1628p ps=1.18u w=0.74u l=0.13u
X2079 VPWR VGND VPWR VPWR sg13_lv_pmos ad=0.34p pd=2.68u as=0 ps=0 w=1u l=1u
X2080 _244_.RESET_B _215_.A VPWR VPWR sg13_lv_pmos ad=0.3808p pd=2.92u as=0.3808p ps=2.92u w=1.12u l=0.13u
X2081 _218_.Y _215_.A VGND VGND sg13_lv_nmos ad=0.2516p pd=2.16u as=0.2516p ps=2.16u w=0.74u l=0.13u
X2082 a_15217_15255# a_14757_15213# a_14859_15356# VGND sg13_lv_nmos ad=0.31732p pd=1.805u as=0.2516p ps=2.16u w=0.74u l=0.13u
X2083 _126_.B1 a_14058_12508# VPWR VPWR sg13_lv_pmos ad=0.3808p pd=2.92u as=0.2128p ps=1.5u w=1.12u l=0.13u
X2084 a_14820_8440# a_15339_8447# a_16079_8797# VGND sg13_lv_nmos ad=0.3473p pd=2.71u as=0.12665p ps=1.145u w=0.74u l=0.13u
X2085 VGND VPWR VGND VGND sg13_lv_nmos ad=79.8f pd=0.8u as=0 ps=0 w=0.42u l=1u
X2086 VPWR VGND VPWR VPWR sg13_lv_pmos ad=0.19p pd=1.38u as=0 ps=0 w=1u l=1u
X2087 _239_.Y _225_.A VPWR VPWR sg13_lv_pmos ad=0.3808p pd=2.92u as=0.3808p ps=2.92u w=1.12u l=0.13u
X2088 VGND VPWR VGND VGND sg13_lv_nmos ad=79.8f pd=0.8u as=0 ps=0 w=0.42u l=1u
X2089 a_12489_12601# a_12132_12528# VPWR VPWR sg13_lv_pmos ad=63f pd=0.72u as=0.1563p ps=1.22u w=0.42u l=0.13u
X2090 VGND VPWR VGND VGND sg13_lv_nmos ad=0.1428p pd=1.52u as=0 ps=0 w=0.42u l=1u
X2091 VPWR VGND VPWR VPWR sg13_lv_pmos ad=0.34p pd=2.68u as=0 ps=0 w=1u l=1u
X2092 VPWR VGND VPWR VPWR sg13_lv_pmos ad=0.19p pd=1.38u as=0 ps=0 w=1u l=1u
X2093 VGND VPWR VGND VGND sg13_lv_nmos ad=79.8f pd=0.8u as=0 ps=0 w=0.42u l=1u
X2094 a_2244_12528# a_2218_12433# VPWR VPWR sg13_lv_pmos ad=0.34p pd=2.68u as=0.36237p ps=2.605u w=1u l=0.13u
X2095 _178_.B1 a_6336_11499# a_6485_11830# VGND sg13_lv_nmos ad=0.2516p pd=2.16u as=0.1406p ps=1.12u w=0.74u l=0.13u
X2096 a_11755_4696# _243_.Q a_11661_4696# VGND sg13_lv_nmos ad=0.1216p pd=1.02u as=0.2176p ps=1.96u w=0.64u l=0.13u
X2097 a_3045_3911# _243_.CLK a_3505_3902# VPWR sg13_lv_pmos ad=0.4088p pd=2.97u as=0.41165p ps=2.12u w=1.12u l=0.13u
X2098 VGND a_12215_7664# _164_.B1 VGND sg13_lv_nmos ad=0.2516p pd=2.16u as=0.1406p ps=1.12u w=0.74u l=0.13u
X2099 VGND VPWR VGND VGND sg13_lv_nmos ad=0.1428p pd=1.52u as=0 ps=0 w=0.42u l=1u
X2100 VGND VPWR VGND VGND sg13_lv_nmos ad=0.1428p pd=1.52u as=0 ps=0 w=0.42u l=1u
X2101 a_6966_4258# _136_.B _210_.B VGND sg13_lv_nmos ad=88.8f pd=0.98u as=0.1628p ps=1.18u w=0.74u l=0.13u
X2102 VPWR _258_.RESET_B a_7622_16434# VPWR sg13_lv_pmos ad=0.36237p pd=2.605u as=79.8f ps=0.8u w=0.42u l=0.13u
X2103 VPWR _228_.Y a_9734_9186# VPWR sg13_lv_pmos ad=0.36237p pd=2.605u as=79.8f ps=0.8u w=0.42u l=0.13u
X2104 a_14820_8440# a_14794_8404# VGND VGND sg13_lv_nmos ad=0.2516p pd=2.16u as=0.1626p ps=1.415u w=0.74u l=0.13u
X2105 a_15601_12506# a_15141_12189# a_15243_12332# VPWR sg13_lv_pmos ad=0.41165p pd=2.12u as=0.3864p ps=2.93u w=1.12u l=0.13u
X2106 VGND VPWR VGND VGND sg13_lv_nmos ad=0.1428p pd=1.52u as=0 ps=0 w=0.42u l=1u
X2107 VPWR _227_.Y a_14794_8404# VPWR sg13_lv_pmos ad=0.1563p pd=1.22u as=0.147p ps=1.54u w=0.42u l=0.13u
X2108 VPWR a_11279_9263# a_11536_9406# VPWR sg13_lv_pmos ad=0.4659p pd=3.65u as=79.8f ps=0.8u w=0.42u l=0.13u
X2109 a_2410_9409# a_2853_9165# a_2150_9186# VGND sg13_lv_nmos ad=79.8f pd=0.8u as=0.1296p ps=1.52u w=0.42u l=0.13u
X2110 _176_.A a_11082_12508# VGND VGND sg13_lv_nmos ad=0.2516p pd=2.16u as=0.1406p ps=1.12u w=0.74u l=0.13u
X2111 VPWR clkbuf_1_0__f_sclk.A a_3956_6888# VPWR sg13_lv_pmos ad=0.3808p pd=2.92u as=0.2128p ps=1.5u w=1.12u l=0.13u
X2112 a_3313_9207# a_2853_9165# a_2955_9308# VGND sg13_lv_nmos ad=0.31732p pd=1.805u as=0.2516p ps=2.16u w=0.74u l=0.13u
X2113 VGND VPWR VGND VGND sg13_lv_nmos ad=0.1428p pd=1.52u as=0 ps=0 w=0.42u l=1u
X2114 VPWR a_3407_13333# a_4074_12972# VPWR sg13_lv_pmos ad=0.2128p pd=1.5u as=0.3864p ps=2.93u w=1.12u l=0.13u
X2115 a_9348_4968# a_9322_4873# VGND VGND sg13_lv_nmos ad=0.2516p pd=2.16u as=0.1626p ps=1.415u w=0.74u l=0.13u
X2116 VGND _124_.S a_2075_5468# VGND sg13_lv_nmos ad=0.18945p pd=1.27u as=0.187p ps=1.78u w=0.55u l=0.13u
X2117 VPWR a_9551_16823# a_10218_17044# VPWR sg13_lv_pmos ad=0.2128p pd=1.5u as=0.3864p ps=2.93u w=1.12u l=0.13u
X2118 a_10607_4727# a_9765_4629# a_10513_4727# VGND sg13_lv_nmos ad=0.12665p pd=1.145u as=0.1428p ps=1.52u w=0.42u l=0.13u
X2119 VGND VPWR VGND VGND sg13_lv_nmos ad=79.8f pd=0.8u as=0 ps=0 w=0.42u l=1u
X2120 VGND VPWR VGND VGND sg13_lv_nmos ad=0.1428p pd=1.52u as=0 ps=0 w=0.42u l=1u
X2121 VGND a_3407_16357# a_4074_15996# VGND sg13_lv_nmos ad=0.1406p pd=1.12u as=0.2516p ps=2.16u w=0.74u l=0.13u
X2122 a_16336_8678# _227_.Y a_16396_8559# VPWR sg13_lv_pmos ad=79.8f pd=0.8u as=0.204p ps=1.835u w=0.42u l=0.13u
X2123 a_3724_13095# a_3664_13214# a_3609_13095# VPWR sg13_lv_pmos ad=0.204p pd=1.835u as=93.45f ps=0.865u w=0.42u l=0.13u
X2124 _168_.Y a_6528_8475# a_6677_8806# VGND sg13_lv_nmos ad=0.2516p pd=2.16u as=0.1406p ps=1.12u w=0.74u l=0.13u
X2125 a_6528_8475# _168_.B a_6491_8784# VGND sg13_lv_nmos ad=0.2176p pd=1.96u as=78.39999f ps=0.885u w=0.64u l=0.13u
X2126 a_1862_16434# _250_.D VPWR VPWR sg13_lv_pmos ad=79.8f pd=0.8u as=0.1428p ps=1.52u w=0.42u l=0.13u
X2127 a_13129_15280# _134_.Y VGND VGND sg13_lv_nmos ad=0.1216p pd=1.02u as=0.1331p ps=1.12u w=0.64u l=0.13u
X2128 VPWR VGND VPWR VPWR sg13_lv_pmos ad=0.19p pd=1.38u as=0 ps=0 w=1u l=1u
X2129 VGND VPWR VGND VGND sg13_lv_nmos ad=0.1428p pd=1.52u as=0 ps=0 w=0.42u l=1u
X2130 VGND VPWR VGND VGND sg13_lv_nmos ad=0.1428p pd=1.52u as=0 ps=0 w=0.42u l=1u
X2131 a_4475_17856# _118_.A0 VGND VGND sg13_lv_nmos ad=78.39999f pd=0.885u as=0.2272p ps=1.99u w=0.64u l=0.13u
X2132 _230_.Y _236_.A VPWR VPWR sg13_lv_pmos ad=0.3808p pd=2.92u as=0.3808p ps=2.92u w=1.12u l=0.13u
X2133 VGND VPWR VGND VGND sg13_lv_nmos ad=79.8f pd=0.8u as=0 ps=0 w=0.42u l=1u
X2134 VGND VPWR VGND VGND sg13_lv_nmos ad=0.1428p pd=1.52u as=0 ps=0 w=0.42u l=1u
X2135 a_15217_15530# a_14757_15213# a_14859_15356# VPWR sg13_lv_pmos ad=0.41165p pd=2.12u as=0.3864p ps=2.93u w=1.12u l=0.13u
X2136 a_15983_5773# a_15141_5423# a_15889_5773# VGND sg13_lv_nmos ad=0.12665p pd=1.145u as=0.1428p ps=1.52u w=0.42u l=0.13u
X2137 VGND VPWR VGND VGND sg13_lv_nmos ad=79.8f pd=0.8u as=0 ps=0 w=0.42u l=1u
X2138 a_14919_16964# a_15071_17016# a_15389_16767# VGND sg13_lv_nmos ad=0.2516p pd=2.16u as=0.31732p ps=1.805u w=0.74u l=0.13u
X2139 a_3887_4261# a_3045_3911# a_2628_3904# VPWR sg13_lv_pmos ad=0.2048p pd=1.63u as=0.34p ps=2.68u w=1u l=0.13u
X2140 VGND _237_.Y a_12612_16434# VGND sg13_lv_nmos ad=0.1626p pd=1.415u as=60.89999f ps=0.71u w=0.42u l=0.13u
X2141 VGND _148_.B a_5297_12264# VGND sg13_lv_nmos ad=0.15245p pd=1.17u as=0.17462p ps=1.185u w=0.55u l=0.13u
X2142 VGND VPWR VGND VGND sg13_lv_nmos ad=0.1428p pd=1.52u as=0 ps=0 w=0.42u l=1u
X2143 VPWR _207_.A1 a_5147_15996# VPWR sg13_lv_pmos ad=0.2128p pd=1.5u as=0.2128p ps=1.5u w=1.12u l=0.13u
X2144 VPWR a_12992_15437# _135_.X VPWR sg13_lv_pmos ad=0.1918p pd=1.5u as=0.3808p ps=2.92u w=1.12u l=0.13u
X2145 VPWR VGND VPWR VPWR sg13_lv_pmos ad=0.34p pd=2.68u as=0 ps=0 w=1u l=1u
X2146 _243_.Q a_4554_3900# VGND VGND sg13_lv_nmos ad=0.2516p pd=2.16u as=0.1406p ps=1.12u w=0.74u l=0.13u
X2147 a_15980_7638# fanout7.A VPWR VPWR sg13_lv_pmos ad=0.2856p pd=2.36u as=0.2114p ps=1.54u w=0.84u l=0.13u
X2148 a_5242_8806# _173_.A _173_.Y VGND sg13_lv_nmos ad=0.1406p pd=1.12u as=0.2516p ps=2.16u w=0.74u l=0.13u
X2149 a_2150_9186# _246_.D VPWR VPWR sg13_lv_pmos ad=79.8f pd=0.8u as=0.1428p ps=1.52u w=0.42u l=0.13u
X2150 a_7451_14484# _193_.Y VPWR VPWR sg13_lv_pmos ad=0.3808p pd=2.92u as=0.2128p ps=1.5u w=1.12u l=0.13u
X2151 VGND VPWR VGND VGND sg13_lv_nmos ad=0.1428p pd=1.52u as=0 ps=0 w=0.42u l=1u
X2152 a_8480_4248# _145_.A2 VGND VGND sg13_lv_nmos ad=94.35f pd=0.995u as=0.2516p ps=2.16u w=0.74u l=0.13u
X2153 a_6885_4629# _251_.CLK a_7345_4946# VPWR sg13_lv_pmos ad=0.4088p pd=2.97u as=0.41165p ps=2.12u w=1.12u l=0.13u
X2154 VPWR VGND VPWR VPWR sg13_lv_pmos ad=0.34p pd=2.68u as=0 ps=0 w=1u l=1u
X2155 VGND VPWR VGND VGND sg13_lv_nmos ad=79.8f pd=0.8u as=0 ps=0 w=0.42u l=1u
X2156 a_9322_4873# a_9765_4629# a_9062_4650# VGND sg13_lv_nmos ad=79.8f pd=0.8u as=0.1296p ps=1.52u w=0.42u l=0.13u
X2157 a_13681_15998# a_13221_16007# a_13323_16007# VPWR sg13_lv_pmos ad=0.41165p pd=2.12u as=0.3864p ps=2.93u w=1.12u l=0.13u
X2158 VGND VPWR VGND VGND sg13_lv_nmos ad=0.1428p pd=1.52u as=0 ps=0 w=0.42u l=1u
X2159 a_9156_4650# _252_.D a_9062_4650# VGND sg13_lv_nmos ad=60.89999f pd=0.71u as=0.1428p ps=1.52u w=0.42u l=0.13u
X2160 VGND VPWR VGND VGND sg13_lv_nmos ad=0.1428p pd=1.52u as=0 ps=0 w=0.42u l=1u
X2161 VPWR VGND VPWR VPWR sg13_lv_pmos ad=0.34p pd=2.68u as=0 ps=0 w=1u l=1u
X2162 a_14063_16357# a_13221_16007# a_12804_16000# VPWR sg13_lv_pmos ad=0.2048p pd=1.63u as=0.34p ps=2.68u w=1u l=0.13u
X2163 VPWR a_2126_15424# _118_.X VPWR sg13_lv_pmos ad=0.2198p pd=1.52u as=0.6048p ps=3.32u w=1.12u l=0.13u
X2164 _243_.RESET_B _215_.A VPWR VPWR sg13_lv_pmos ad=0.3808p pd=2.92u as=0.3808p ps=2.92u w=1.12u l=0.13u
X2165 a_5376_17061# _207_.A1 VPWR VPWR sg13_lv_pmos ad=0.1596p pd=1.22u as=0.4536p ps=2.76u w=0.84u l=0.13u
X2166 _241_.Y _236_.A VGND VGND sg13_lv_nmos ad=0.2516p pd=2.16u as=0.2516p ps=2.16u w=0.74u l=0.13u
X2167 a_15046_9199# _260_.RESET_B VGND VGND sg13_lv_nmos ad=37.8f pd=0.6u as=0.1701p ps=1.65u w=0.42u l=0.13u
X2168 _192_.C a_6048_13011# a_6197_13342# VGND sg13_lv_nmos ad=0.2516p pd=2.16u as=0.1406p ps=1.12u w=0.74u l=0.13u
X2169 a_3300_5416# a_3819_5423# a_4559_5773# VGND sg13_lv_nmos ad=0.3473p pd=2.71u as=0.12665p ps=1.145u w=0.74u l=0.13u
X2170 VPWR VGND VPWR VPWR sg13_lv_pmos ad=0.19p pd=1.38u as=0 ps=0 w=1u l=1u
X2171 a_8964_13722# _194_.X a_8870_13722# VGND sg13_lv_nmos ad=60.89999f pd=0.71u as=0.1428p ps=1.52u w=0.42u l=0.13u
X2172 VPWR VGND VPWR VPWR sg13_lv_pmos ad=0.34p pd=2.68u as=0 ps=0 w=1u l=1u
X2173 a_2052_12210# _120_.X a_1958_12210# VGND sg13_lv_nmos ad=60.89999f pd=0.71u as=0.1428p ps=1.52u w=0.42u l=0.13u
X2174 a_6862_15532# _200_.Y VPWR VPWR sg13_lv_pmos ad=0.2128p pd=1.5u as=0.3808p ps=2.92u w=1.12u l=0.13u
X2175 VGND a_7616_15437# _204_.X VGND sg13_lv_nmos ad=0.1331p pd=1.12u as=0.2516p ps=2.16u w=0.74u l=0.13u
X2176 freq_out a_16840_4688# VPWR VPWR sg13_lv_pmos ad=0.42p pd=2.99u as=0.2114p ps=1.54u w=1.12u l=0.13u
X2177 VPWR VGND VPWR VPWR sg13_lv_pmos ad=0.34p pd=2.68u as=0 ps=0 w=1u l=1u
X2178 VPWR _227_.Y a_14534_8874# VPWR sg13_lv_pmos ad=0.36237p pd=2.605u as=79.8f ps=0.8u w=0.42u l=0.13u
X2179 a_14794_11428# a_15237_11471# a_15177_11507# VPWR sg13_lv_pmos ad=79.8f pd=0.8u as=63f ps=0.72u w=0.42u l=0.13u
X2180 a_8292_17064# a_8266_16969# VPWR VPWR sg13_lv_pmos ad=0.34p pd=2.68u as=0.36237p ps=2.605u w=1u l=0.13u
X2181 VPWR a_11279_9263# a_11946_9484# VPWR sg13_lv_pmos ad=0.2128p pd=1.5u as=0.3864p ps=2.93u w=1.12u l=0.13u
X2182 VPWR VGND VPWR VPWR sg13_lv_pmos ad=0.34p pd=2.68u as=0 ps=0 w=1u l=1u
X2183 VGND VPWR VGND VGND sg13_lv_nmos ad=0.1428p pd=1.52u as=0 ps=0 w=0.42u l=1u
X2184 VGND VPWR VGND VGND sg13_lv_nmos ad=0.1428p pd=1.52u as=0 ps=0 w=0.42u l=1u
X2185 VPWR VGND VPWR VPWR sg13_lv_pmos ad=0.19p pd=1.38u as=0 ps=0 w=1u l=1u
X2186 VPWR _225_.Y a_9322_4873# VPWR sg13_lv_pmos ad=0.1563p pd=1.22u as=0.147p ps=1.54u w=0.42u l=0.13u
X2187 a_6516_4248# _210_.B a_6060_4166# VGND sg13_lv_nmos ad=78.39999f pd=0.885u as=0.2176p ps=1.96u w=0.64u l=0.13u
X2188 VGND a_3380_13690# _247_.CLK VGND sg13_lv_nmos ad=0.1406p pd=1.12u as=0.1406p ps=1.12u w=0.74u l=0.13u
X2189 a_10415_12287# a_9573_12189# a_9156_12528# VPWR sg13_lv_pmos ad=0.2048p pd=1.63u as=0.34p ps=2.68u w=1u l=0.13u
X2190 a_9513_14113# a_9156_14040# VPWR VPWR sg13_lv_pmos ad=63f pd=0.72u as=0.1563p ps=1.22u w=0.42u l=0.13u
X2191 VGND _170_.B a_7841_9212# VGND sg13_lv_nmos ad=0.2516p pd=2.16u as=0.1406p ps=1.12u w=0.74u l=0.13u
X2192 VPWR VGND VPWR VPWR sg13_lv_pmos ad=0.34p pd=2.68u as=0 ps=0 w=1u l=1u
X2193 VGND VPWR VGND VGND sg13_lv_nmos ad=79.8f pd=0.8u as=0 ps=0 w=0.42u l=1u
X2194 a_14628_9186# _213_.Y a_14534_9186# VGND sg13_lv_nmos ad=60.89999f pd=0.71u as=0.1428p ps=1.52u w=0.42u l=0.13u
X2195 VPWR _118_.A0 a_4462_16052# VPWR sg13_lv_pmos ad=0.2618p pd=1.63u as=0.2856p ps=2.36u w=0.84u l=0.13u
X2196 a_12106_12433# a_12549_12189# a_11846_12210# VGND sg13_lv_nmos ad=79.8f pd=0.8u as=0.1296p ps=1.52u w=0.42u l=0.13u
X2197 a_2398_4654# _243_.Q a_2301_4948# VPWR sg13_lv_pmos ad=0.2225p pd=1.445u as=0.3325p ps=1.665u w=1u l=0.13u
X2198 a_2853_8447# _243_.CLK a_3313_8789# VGND sg13_lv_nmos ad=0.2516p pd=2.16u as=0.31732p ps=1.805u w=0.74u l=0.13u
X2199 a_15012_12223# a_15243_12332# a_14698_12433# VGND sg13_lv_nmos ad=0.2373p pd=1.97u as=79.8f ps=0.8u w=0.42u l=0.13u
X2200 a_7616_15437# _193_.Y a_7753_15280# VGND sg13_lv_nmos ad=0.2176p pd=1.96u as=0.1216p ps=1.02u w=0.64u l=0.13u
X2201 a_12825_17061# a_11883_16868# a_12623_16823# VPWR sg13_lv_pmos ad=93.45f pd=0.865u as=0.2048p ps=1.63u w=0.42u l=0.13u
X2202 VPWR VGND VPWR VPWR sg13_lv_pmos ad=0.19p pd=1.38u as=0 ps=0 w=1u l=1u
X2203 a_15177_8483# a_14820_8440# VPWR VPWR sg13_lv_pmos ad=63f pd=0.72u as=0.1563p ps=1.22u w=0.42u l=0.13u
X2204 _161_.Y _153_.Y a_12730_8806# VGND sg13_lv_nmos ad=0.2516p pd=2.16u as=0.1406p ps=1.12u w=0.74u l=0.13u
X2205 a_15601_5414# a_15141_5423# a_15243_5423# VPWR sg13_lv_pmos ad=0.41165p pd=2.12u as=0.3864p ps=2.93u w=1.12u l=0.13u
X2206 VPWR VGND VPWR VPWR sg13_lv_pmos ad=0.19p pd=1.38u as=0 ps=0 w=1u l=1u
X2207 a_4816_5654# _244_.RESET_B a_4876_5535# VPWR sg13_lv_pmos ad=79.8f pd=0.8u as=0.204p ps=1.835u w=0.42u l=0.13u
X2208 VGND a_4913_13330# _189_.X VGND sg13_lv_nmos ad=0.3108p pd=2.32u as=0.1628p ps=1.18u w=0.74u l=0.13u
X2209 VPWR VGND VPWR VPWR sg13_lv_pmos ad=0.19p pd=1.38u as=0 ps=0 w=1u l=1u
X2210 VPWR VGND VPWR VPWR sg13_lv_pmos ad=0.34p pd=2.68u as=0 ps=0 w=1u l=1u
X2211 VPWR a_16079_9263# a_16336_9406# VPWR sg13_lv_pmos ad=0.4659p pd=3.65u as=79.8f ps=0.8u w=0.42u l=0.13u
X2212 VPWR VGND VPWR VPWR sg13_lv_pmos ad=0.34p pd=2.68u as=0 ps=0 w=1u l=1u
X2213 a_13978_13342# _260_.CLK _128_.B1 VGND sg13_lv_nmos ad=0.1406p pd=1.12u as=0.2516p ps=2.16u w=0.74u l=0.13u
X2214 a_2620_11830# _173_.A a_2126_11726# VGND sg13_lv_nmos ad=0.13135p pd=1.095u as=0.1628p ps=1.18u w=0.74u l=0.13u
X2215 _266_.CLK a_13290_17044# VPWR VPWR sg13_lv_pmos ad=0.3808p pd=2.92u as=0.2128p ps=1.5u w=1.12u l=0.13u
X2216 VPWR VGND VPWR VPWR sg13_lv_pmos ad=0.34p pd=2.68u as=0 ps=0 w=1u l=1u
X2217 VPWR VGND VPWR VPWR sg13_lv_pmos ad=0.19p pd=1.38u as=0 ps=0 w=1u l=1u
X2218 VGND a_2075_5468# a_2512_5782# VGND sg13_lv_nmos ad=0.148p pd=1.14u as=0.3367p ps=1.65u w=0.74u l=0.13u
X2219 VPWR _119_.A0 a_5084_12972# VPWR sg13_lv_pmos ad=0.2128p pd=1.5u as=0.3808p ps=2.92u w=1.12u l=0.13u
X2220 _138_.Y _136_.A VGND VGND sg13_lv_nmos ad=0.1406p pd=1.12u as=0.2516p ps=2.16u w=0.74u l=0.13u
X2221 VPWR VGND VPWR VPWR sg13_lv_pmos ad=0.34p pd=2.68u as=0 ps=0 w=1u l=1u
X2222 a_2232_17770# _124_.S VGND VGND sg13_lv_nmos ad=0.187p pd=1.78u as=0.18945p ps=1.27u w=0.55u l=0.13u
X2223 VGND a_11279_17869# a_11946_17508# VGND sg13_lv_nmos ad=0.1406p pd=1.12u as=0.2516p ps=2.16u w=0.74u l=0.13u
X2224 VGND _219_.Y a_2244_9186# VGND sg13_lv_nmos ad=0.1626p pd=1.415u as=60.89999f ps=0.71u w=0.42u l=0.13u
X2225 VGND VPWR VGND VGND sg13_lv_nmos ad=0.1428p pd=1.52u as=0 ps=0 w=0.42u l=1u
X2226 a_11940_12210# _126_.Y a_11846_12210# VGND sg13_lv_nmos ad=60.89999f pd=0.71u as=0.1428p ps=1.52u w=0.42u l=0.13u
X2227 a_12331_5760# _148_.A a_12237_5760# VGND sg13_lv_nmos ad=0.1216p pd=1.02u as=0.2176p ps=1.96u w=0.64u l=0.13u
X2228 _118_.A0 a_4074_17044# VGND VGND sg13_lv_nmos ad=0.2516p pd=2.16u as=0.1406p ps=1.12u w=0.74u l=0.13u
X2229 VPWR VGND VPWR VPWR sg13_lv_pmos ad=0.19p pd=1.38u as=0 ps=0 w=1u l=1u
X2230 VPWR VGND VPWR VPWR sg13_lv_pmos ad=0.19p pd=1.38u as=0 ps=0 w=1u l=1u
X2231 VPWR VGND VPWR VPWR sg13_lv_pmos ad=0.34p pd=2.68u as=0 ps=0 w=1u l=1u
X2232 VPWR _241_.Y a_11078_16746# VPWR sg13_lv_pmos ad=0.36237p pd=2.605u as=79.8f ps=0.8u w=0.42u l=0.13u
X2233 _170_.Y _165_.Y a_7736_8802# VGND sg13_lv_nmos ad=0.2516p pd=2.16u as=0.1406p ps=1.12u w=0.74u l=0.13u
X2234 VGND _124_.S a_2075_4692# VGND sg13_lv_nmos ad=0.18945p pd=1.27u as=0.187p ps=1.78u w=0.55u l=0.13u
X2235 VPWR VGND VPWR VPWR sg13_lv_pmos ad=0.34p pd=2.68u as=0 ps=0 w=1u l=1u
X2236 VGND a_3886_10702# clkbuf_1_0__f_sclk.A VGND sg13_lv_nmos ad=0.1406p pd=1.12u as=0.1406p ps=1.12u w=0.74u l=0.13u
X2237 VPWR VGND VPWR VPWR sg13_lv_pmos ad=0.19p pd=1.38u as=0 ps=0 w=1u l=1u
X2238 a_13804_10996# _131_.A2 _132_.Y VPWR sg13_lv_pmos ad=0.1176p pd=1.33u as=0.3808p ps=2.92u w=1.12u l=0.13u
X2239 a_3121_12506# a_2661_12189# a_2763_12332# VPWR sg13_lv_pmos ad=0.41165p pd=2.12u as=0.3864p ps=2.93u w=1.12u l=0.13u
X2240 VPWR a_11731_8698# _180_.X VPWR sg13_lv_pmos ad=0.3808p pd=2.92u as=0.3808p ps=2.92u w=1.12u l=0.13u
X2241 VGND VPWR VGND VGND sg13_lv_nmos ad=0.1428p pd=1.52u as=0 ps=0 w=0.42u l=1u
X2242 a_14950_5837# _226_.Y VGND VGND sg13_lv_nmos ad=37.8f pd=0.6u as=0.1701p ps=1.65u w=0.42u l=0.13u
X2243 _247_.CLK a_3380_13690# VGND VGND sg13_lv_nmos ad=0.1406p pd=1.12u as=0.1406p ps=1.12u w=0.74u l=0.13u
X2244 VPWR VGND VPWR VPWR sg13_lv_pmos ad=0.19p pd=1.38u as=0 ps=0 w=1u l=1u
X2245 VPWR VGND VPWR VPWR sg13_lv_pmos ad=0.34p pd=2.68u as=0 ps=0 w=1u l=1u
X2246 VPWR VGND VPWR VPWR sg13_lv_pmos ad=0.34p pd=2.68u as=0 ps=0 w=1u l=1u
X2247 VPWR VGND VPWR VPWR sg13_lv_pmos ad=0.19p pd=1.38u as=0 ps=0 w=1u l=1u
X2248 VGND VPWR VGND VGND sg13_lv_nmos ad=0.1428p pd=1.52u as=0 ps=0 w=0.42u l=1u
X2249 VPWR a_3886_10702# clkbuf_1_0__f_sclk.A VPWR sg13_lv_pmos ad=0.2128p pd=1.5u as=0.2128p ps=1.5u w=1.12u l=0.13u
X2250 a_4204_4023# a_4144_4142# a_4089_4023# VPWR sg13_lv_pmos ad=0.204p pd=1.835u as=93.45f ps=0.865u w=0.42u l=0.13u
X2251 VPWR VGND VPWR VPWR sg13_lv_pmos ad=0.19p pd=1.38u as=0 ps=0 w=1u l=1u
X2252 a_14830_16746# a_15071_17016# a_14359_16710# VGND sg13_lv_nmos ad=0.1428p pd=1.52u as=0.12665p ps=1.145u w=0.42u l=0.13u
X2253 a_2602_3868# a_3045_3911# a_2985_3947# VPWR sg13_lv_pmos ad=79.8f pd=0.8u as=63f ps=0.72u w=0.42u l=0.13u
X2254 _149_.A a_16650_5412# VPWR VPWR sg13_lv_pmos ad=0.3808p pd=2.92u as=0.2128p ps=1.5u w=1.12u l=0.13u
X2255 _170_.B _154_.X VPWR VPWR sg13_lv_pmos ad=0.2128p pd=1.5u as=0.3808p ps=2.92u w=1.12u l=0.13u
X2256 VGND VPWR VGND VGND sg13_lv_nmos ad=0.1428p pd=1.52u as=0 ps=0 w=0.42u l=1u
X2257 VGND VPWR VGND VGND sg13_lv_nmos ad=0.1428p pd=1.52u as=0 ps=0 w=0.42u l=1u
X2258 VPWR _145_.X a_11974_8436# VPWR sg13_lv_pmos ad=0.19p pd=1.38u as=0.2125p ps=1.425u w=1u l=0.13u
X2259 VGND VPWR VGND VGND sg13_lv_nmos ad=0.1428p pd=1.52u as=0 ps=0 w=0.42u l=1u
X2260 VGND _133_.B _133_.Y VGND sg13_lv_nmos ad=0.1463p pd=1.15u as=0.1694p ps=1.21u w=0.77u l=0.13u
X2261 VPWR _176_.B a_6336_11499# VPWR sg13_lv_pmos ad=0.2891p pd=1.695u as=0.1596p ps=1.22u w=0.84u l=0.13u
X2262 a_8603_9484# _171_.A _181_.Y VPWR sg13_lv_pmos ad=0.2128p pd=1.5u as=0.3808p ps=2.92u w=1.12u l=0.13u
X2263 VPWR VGND VPWR VPWR sg13_lv_pmos ad=0.19p pd=1.38u as=0 ps=0 w=1u l=1u
X2264 VGND VPWR VGND VGND sg13_lv_nmos ad=0.1428p pd=1.52u as=0 ps=0 w=0.42u l=1u
X2265 VPWR a_14063_16357# a_14730_15996# VPWR sg13_lv_pmos ad=0.2128p pd=1.5u as=0.3864p ps=2.93u w=1.12u l=0.13u
X2266 VPWR VGND VPWR VPWR sg13_lv_pmos ad=0.19p pd=1.38u as=0 ps=0 w=1u l=1u
X2267 _243_.CLK a_3956_6888# VGND VGND sg13_lv_nmos ad=0.1406p pd=1.12u as=0.1406p ps=1.12u w=0.74u l=0.13u
X2268 VGND VPWR VGND VGND sg13_lv_nmos ad=0.1428p pd=1.52u as=0 ps=0 w=0.42u l=1u
X2269 VPWR VGND VPWR VPWR sg13_lv_pmos ad=0.34p pd=2.68u as=0 ps=0 w=1u l=1u
X2270 a_1580_16710# fanout8.A VPWR VPWR sg13_lv_pmos ad=0.2856p pd=2.36u as=0.2114p ps=1.54u w=0.84u l=0.13u
X2271 a_9130_13945# a_9573_13701# a_8870_13722# VGND sg13_lv_nmos ad=79.8f pd=0.8u as=0.1296p ps=1.52u w=0.42u l=0.13u
X2272 VPWR VGND VPWR VPWR sg13_lv_pmos ad=0.19p pd=1.38u as=0 ps=0 w=1u l=1u
X2273 VGND a_13073_7728# _160_.B VGND sg13_lv_nmos ad=0.3108p pd=2.32u as=0.1628p ps=1.18u w=0.74u l=0.13u
X2274 _133_.B a_16266_15532# VPWR VPWR sg13_lv_pmos ad=0.3808p pd=2.92u as=0.2128p ps=1.5u w=1.12u l=0.13u
X2275 a_10020_17512# a_10539_17519# a_11279_17869# VGND sg13_lv_nmos ad=0.3473p pd=2.71u as=0.12665p ps=1.145u w=0.74u l=0.13u
X2276 VGND VPWR VGND VGND sg13_lv_nmos ad=0.1428p pd=1.52u as=0 ps=0 w=0.42u l=1u
X2277 VGND _160_.B a_13973_7678# VGND sg13_lv_nmos ad=0.1898p pd=1.36u as=0.2516p ps=2.16u w=0.74u l=0.13u
X2278 VPWR VGND VPWR VPWR sg13_lv_pmos ad=0.34p pd=2.68u as=0 ps=0 w=1u l=1u
X2279 a_13009_12506# a_12549_12189# a_12651_12332# VPWR sg13_lv_pmos ad=0.41165p pd=2.12u as=0.3864p ps=2.93u w=1.12u l=0.13u
X2280 VPWR VGND VPWR VPWR sg13_lv_pmos ad=0.34p pd=2.68u as=0 ps=0 w=1u l=1u
X2281 VGND _229_.Y a_8964_12210# VGND sg13_lv_nmos ad=0.1626p pd=1.415u as=60.89999f ps=0.71u w=0.42u l=0.13u
X2282 _147_.B1 a_11661_4696# VPWR VPWR sg13_lv_pmos ad=0.3808p pd=2.92u as=0.1918p ps=1.5u w=1.12u l=0.13u
X2283 a_2301_4948# _124_.S VPWR VPWR sg13_lv_pmos ad=0.3325p pd=1.665u as=0.253p ps=1.53u w=1u l=0.13u
X2284 a_6468_4968# a_6987_4772# a_7727_4727# VGND sg13_lv_nmos ad=0.3473p pd=2.71u as=0.12665p ps=1.145u w=0.74u l=0.13u
X2285 a_3760_12430# _220_.Y a_3820_12525# VPWR sg13_lv_pmos ad=79.8f pd=0.8u as=0.204p ps=1.835u w=0.42u l=0.13u
X2286 VPWR VGND VPWR VPWR sg13_lv_pmos ad=0.19p pd=1.38u as=0 ps=0 w=1u l=1u
X2287 VPWR a_10752_7989# _162_.B VPWR sg13_lv_pmos ad=0.3808p pd=2.92u as=0.2408p ps=1.55u w=1.12u l=0.13u
X2288 a_14794_8404# a_15237_8447# a_14534_8874# VGND sg13_lv_nmos ad=79.8f pd=0.8u as=0.1296p ps=1.52u w=0.42u l=0.13u
X2289 a_12612_16434# _135_.X a_12518_16434# VGND sg13_lv_nmos ad=60.89999f pd=0.71u as=0.1428p ps=1.52u w=0.42u l=0.13u
X2290 VGND a_4559_4727# a_5226_4948# VGND sg13_lv_nmos ad=0.1406p pd=1.12u as=0.2516p ps=2.16u w=0.74u l=0.13u
X2291 a_4177_4946# a_3717_4629# a_3819_4772# VPWR sg13_lv_pmos ad=0.41165p pd=2.12u as=0.3864p ps=2.93u w=1.12u l=0.13u
X2292 VPWR VGND VPWR VPWR sg13_lv_pmos ad=0.19p pd=1.38u as=0 ps=0 w=1u l=1u
X2293 a_14340_15552# a_14859_15356# a_15599_15311# VGND sg13_lv_nmos ad=0.3473p pd=2.71u as=0.12665p ps=1.145u w=0.74u l=0.13u
X2294 VPWR VGND VPWR VPWR sg13_lv_pmos ad=0.19p pd=1.38u as=0 ps=0 w=1u l=1u
X2295 VPWR VGND VPWR VPWR sg13_lv_pmos ad=0.34p pd=2.68u as=0 ps=0 w=1u l=1u
X2296 VGND _168_.A a_6677_8806# VGND sg13_lv_nmos ad=0.1898p pd=1.36u as=0.2516p ps=2.16u w=0.74u l=0.13u
X2297 a_1862_16746# _118_.X VPWR VPWR sg13_lv_pmos ad=79.8f pd=0.8u as=0.1428p ps=1.52u w=0.42u l=0.13u
X2298 VGND VPWR VGND VGND sg13_lv_nmos ad=0.1428p pd=1.52u as=0 ps=0 w=0.42u l=1u
X2299 VGND VPWR VGND VGND sg13_lv_nmos ad=79.8f pd=0.8u as=0 ps=0 w=0.42u l=1u
X2300 VGND _131_.A2 a_13025_11808# VGND sg13_lv_nmos ad=0.2516p pd=2.16u as=0.1406p ps=1.12u w=0.74u l=0.13u
X2301 VPWR VGND VPWR VPWR sg13_lv_pmos ad=0.34p pd=2.68u as=0 ps=0 w=1u l=1u
X2302 a_14820_9504# a_14794_9409# VGND VGND sg13_lv_nmos ad=0.2516p pd=2.16u as=0.1626p ps=1.415u w=0.74u l=0.13u
X2303 VGND a_3407_13333# a_4074_12972# VGND sg13_lv_nmos ad=0.1406p pd=1.12u as=0.2516p ps=2.16u w=0.74u l=0.13u
X2304 a_8115_5412# _143_.A VPWR VPWR sg13_lv_pmos ad=0.1428p pd=1.375u as=0.2891p ps=1.695u w=1.12u l=0.13u
X2305 VGND a_3952_9406# a_3601_9263# VGND sg13_lv_nmos ad=79.8f pd=0.8u as=0.1428p ps=1.52u w=0.42u l=0.13u
X2306 VGND VPWR VGND VGND sg13_lv_nmos ad=79.8f pd=0.8u as=0 ps=0 w=0.42u l=1u
X2307 _151_.B a_13073_5770# a_13244_5412# VPWR sg13_lv_pmos ad=0.3808p pd=2.92u as=0.2128p ps=1.5u w=1.12u l=0.13u
X2308 _220_.Y _215_.A VPWR VPWR sg13_lv_pmos ad=0.3808p pd=2.92u as=0.3808p ps=2.92u w=1.12u l=0.13u
X2309 VPWR VGND VPWR VPWR sg13_lv_pmos ad=0.19p pd=1.38u as=0 ps=0 w=1u l=1u
X2310 a_2436_8440# a_2955_8447# a_3695_8797# VGND sg13_lv_nmos ad=0.3473p pd=2.71u as=0.12665p ps=1.145u w=0.74u l=0.13u
X2311 a_11481_9501# a_10539_9308# a_11279_9263# VPWR sg13_lv_pmos ad=93.45f pd=0.865u as=0.2048p ps=1.63u w=0.42u l=0.13u
X2312 VPWR VGND VPWR VPWR sg13_lv_pmos ad=0.19p pd=1.38u as=0 ps=0 w=1u l=1u
X2313 _209_.Y a_6720_17061# a_6869_16750# VGND sg13_lv_nmos ad=0.2516p pd=2.16u as=0.1406p ps=1.12u w=0.74u l=0.13u
X2314 VPWR VGND VPWR VPWR sg13_lv_pmos ad=0.34p pd=2.68u as=0 ps=0 w=1u l=1u
X2315 a_14534_11898# _131_.Y VPWR VPWR sg13_lv_pmos ad=79.8f pd=0.8u as=0.1428p ps=1.52u w=0.42u l=0.13u
X2316 VGND _236_.A _240_.Y VGND sg13_lv_nmos ad=0.2516p pd=2.16u as=0.2516p ps=2.16u w=0.74u l=0.13u
X2317 _192_.C _189_.X a_6291_12972# VPWR sg13_lv_pmos ad=0.2408p pd=1.55u as=0.1428p ps=1.375u w=1.12u l=0.13u
X2318 VGND _179_.Y a_8501_10702# VGND sg13_lv_nmos ad=0.1898p pd=1.36u as=0.2516p ps=2.16u w=0.74u l=0.13u
X2319 a_6048_13011# _190_.A VPWR VPWR sg13_lv_pmos ad=0.1596p pd=1.22u as=0.4536p ps=2.76u w=0.84u l=0.13u
X2320 VGND a_16240_5654# a_15889_5773# VGND sg13_lv_nmos ad=79.8f pd=0.8u as=0.1428p ps=1.52u w=0.42u l=0.13u
X2321 VGND VPWR VGND VGND sg13_lv_nmos ad=0.1428p pd=1.52u as=0 ps=0 w=0.42u l=1u
X2322 VPWR _179_.Y _183_.Y VPWR sg13_lv_pmos ad=0.3808p pd=2.92u as=0.2128p ps=1.5u w=1.12u l=0.13u
X2323 a_15599_15311# a_14757_15213# a_15505_15311# VGND sg13_lv_nmos ad=0.12665p pd=1.145u as=0.1428p ps=1.52u w=0.42u l=0.13u
X2324 VPWR VGND VPWR VPWR sg13_lv_pmos ad=0.34p pd=2.68u as=0 ps=0 w=1u l=1u
X2325 VPWR _174_.Y a_6389_9484# VPWR sg13_lv_pmos ad=0.2128p pd=1.5u as=0.3808p ps=2.92u w=1.12u l=0.13u
X2326 VPWR VGND VPWR VPWR sg13_lv_pmos ad=0.34p pd=2.68u as=0 ps=0 w=1u l=1u
X2327 VGND _201_.Y a_7157_16366# VGND sg13_lv_nmos ad=0.1898p pd=1.36u as=0.2516p ps=2.16u w=0.74u l=0.13u
X2328 VGND VPWR VGND VGND sg13_lv_nmos ad=0.1428p pd=1.52u as=0 ps=0 w=0.42u l=1u
X2329 _147_.Y _147_.A1 a_11475_4248# VGND sg13_lv_nmos ad=0.1406p pd=1.12u as=0.1406p ps=1.12u w=0.74u l=0.13u
X2330 VGND VPWR VGND VGND sg13_lv_nmos ad=79.8f pd=0.8u as=0 ps=0 w=0.42u l=1u
X2331 VGND VPWR VGND VGND sg13_lv_nmos ad=0.1428p pd=1.52u as=0 ps=0 w=0.42u l=1u
X2332 VGND a_3956_6888# _243_.CLK VGND sg13_lv_nmos ad=0.1406p pd=1.12u as=0.1406p ps=1.12u w=0.74u l=0.13u
X2333 a_14919_16964# a_15071_17016# a_15389_17042# VPWR sg13_lv_pmos ad=0.3864p pd=2.93u as=0.41165p ps=2.12u w=1.12u l=0.13u
X2334 VGND VPWR VGND VGND sg13_lv_nmos ad=0.1428p pd=1.52u as=0 ps=0 w=0.42u l=1u
X2335 VPWR _247_.CLK clkload0.Y VPWR sg13_lv_pmos ad=0.3808p pd=2.92u as=0.3808p ps=2.92u w=1.12u l=0.13u
X2336 a_7985_13776# _186_.Y VGND VGND sg13_lv_nmos ad=0.17462p pd=1.185u as=0.374p ps=2.46u w=0.55u l=0.13u
X2337 _229_.Y _236_.A VGND VGND sg13_lv_nmos ad=0.2516p pd=2.16u as=0.2516p ps=2.16u w=0.74u l=0.13u
X2338 _148_.A a_5226_5412# VGND VGND sg13_lv_nmos ad=0.2516p pd=2.16u as=0.1406p ps=1.12u w=0.74u l=0.13u
X2339 VPWR VGND VPWR VPWR sg13_lv_pmos ad=0.34p pd=2.68u as=0 ps=0 w=1u l=1u
X2340 VPWR VGND VPWR VPWR sg13_lv_pmos ad=0.19p pd=1.38u as=0 ps=0 w=1u l=1u
X2341 a_8595_10996# _179_.Y VPWR VPWR sg13_lv_pmos ad=0.1428p pd=1.375u as=0.2891p ps=1.695u w=1.12u l=0.13u
X2342 VPWR VGND VPWR VPWR sg13_lv_pmos ad=0.34p pd=2.68u as=0 ps=0 w=1u l=1u
X2343 a_15108_11885# a_15339_11471# a_14794_11428# VGND sg13_lv_nmos ad=0.2373p pd=1.97u as=79.8f ps=0.8u w=0.42u l=0.13u
X2344 _136_.B a_8394_4948# VPWR VPWR sg13_lv_pmos ad=0.3808p pd=2.92u as=0.2128p ps=1.5u w=1.12u l=0.13u
X2345 VPWR VGND VPWR VPWR sg13_lv_pmos ad=0.19p pd=1.38u as=0 ps=0 w=1u l=1u
X2346 a_10225_4946# a_9765_4629# a_9867_4772# VPWR sg13_lv_pmos ad=0.41165p pd=2.12u as=0.3864p ps=2.93u w=1.12u l=0.13u
X2347 a_2298_14020# a_2232_13916# VPWR VPWR sg13_lv_pmos ad=0.2975p pd=1.595u as=0.2198p ps=1.52u w=1u l=0.13u
X2348 a_12420_12223# a_12651_12332# a_12106_12433# VGND sg13_lv_nmos ad=0.2373p pd=1.97u as=79.8f ps=0.8u w=0.42u l=0.13u
X2349 a_8042_3900# _136_.A VPWR VPWR sg13_lv_pmos ad=0.1176p pd=1.33u as=0.4032p ps=2.96u w=1.12u l=0.13u
X2350 VGND _222_.A _250_.RESET_B VGND sg13_lv_nmos ad=0.2516p pd=2.16u as=0.2516p ps=2.16u w=0.74u l=0.13u
X2351 a_11652_16759# a_11883_16868# a_11338_16969# VGND sg13_lv_nmos ad=0.2373p pd=1.97u as=79.8f ps=0.8u w=0.42u l=0.13u
X2352 VPWR VGND VPWR VPWR sg13_lv_pmos ad=0.19p pd=1.38u as=0 ps=0 w=1u l=1u
X2353 a_4796_17044# _207_.Y VPWR VPWR sg13_lv_pmos ad=0.2128p pd=1.5u as=0.2128p ps=1.5u w=1.12u l=0.13u
X2354 a_2601_12601# a_2244_12528# VPWR VPWR sg13_lv_pmos ad=63f pd=0.72u as=0.1563p ps=1.22u w=0.42u l=0.13u
X2355 VPWR VGND VPWR VPWR sg13_lv_pmos ad=0.34p pd=2.68u as=0 ps=0 w=1u l=1u
X2356 VPWR VGND VPWR VPWR sg13_lv_pmos ad=0.34p pd=2.68u as=0 ps=0 w=1u l=1u
X2357 VPWR VGND VPWR VPWR sg13_lv_pmos ad=0.34p pd=2.68u as=0 ps=0 w=1u l=1u
X2358 a_14314_15457# a_14757_15213# a_14054_15234# VGND sg13_lv_nmos ad=79.8f pd=0.8u as=0.1296p ps=1.52u w=0.42u l=0.13u
X2359 VPWR a_3380_13690# _247_.CLK VPWR sg13_lv_pmos ad=0.2128p pd=1.5u as=0.2128p ps=1.5u w=1.12u l=0.13u
X2360 VGND VPWR VGND VGND sg13_lv_nmos ad=0.1428p pd=1.52u as=0 ps=0 w=0.42u l=1u
X2361 a_7262_3900# _136_.B a_6810_3863# VPWR sg13_lv_pmos ad=0.1225p pd=1.245u as=0.34p ps=2.68u w=1u l=0.13u
X2362 VGND VPWR VGND VGND sg13_lv_nmos ad=0.1428p pd=1.52u as=0 ps=0 w=0.42u l=1u
X2363 VGND VPWR VGND VGND sg13_lv_nmos ad=0.1428p pd=1.52u as=0 ps=0 w=0.42u l=1u
X2364 VGND a_10607_4727# a_11274_4948# VGND sg13_lv_nmos ad=0.1406p pd=1.12u as=0.2516p ps=2.16u w=0.74u l=0.13u
X2365 VGND a_13184_7183# _160_.X VGND sg13_lv_nmos ad=0.1331p pd=1.12u as=0.2516p ps=2.16u w=0.74u l=0.13u
X2366 a_14534_8874# a_15339_8447# a_14794_8404# VPWR sg13_lv_pmos ad=0.1428p pd=1.52u as=79.8f ps=0.8u w=0.42u l=0.13u
X2367 a_2916_4325# a_3147_3911# a_2602_3868# VGND sg13_lv_nmos ad=0.2373p pd=1.97u as=79.8f ps=0.8u w=0.42u l=0.13u
X2368 VGND sdata a_1192_7712# VGND sg13_lv_nmos ad=0.14875p pd=1.16u as=0.187p ps=1.78u w=0.55u l=0.13u
X2369 VPWR VGND VPWR VPWR sg13_lv_pmos ad=0.19p pd=1.38u as=0 ps=0 w=1u l=1u
X2370 VPWR VGND VPWR VPWR sg13_lv_pmos ad=0.19p pd=1.38u as=0 ps=0 w=1u l=1u
X2371 VPWR VGND VPWR VPWR sg13_lv_pmos ad=0.19p pd=1.38u as=0 ps=0 w=1u l=1u
X2372 a_2662_9199# _219_.Y VGND VGND sg13_lv_nmos ad=37.8f pd=0.6u as=0.1701p ps=1.65u w=0.42u l=0.13u
X2373 a_15046_8861# _227_.Y VGND VGND sg13_lv_nmos ad=37.8f pd=0.6u as=0.1701p ps=1.65u w=0.42u l=0.13u
X2374 a_5201_9240# _136_.A a_5169_9508# VPWR sg13_lv_pmos ad=0.34p pd=2.68u as=0.1225p ps=1.245u w=1u l=0.13u
X2375 clkbuf_1_0__f_sclk.A a_3886_10702# VGND VGND sg13_lv_nmos ad=0.1406p pd=1.12u as=0.1406p ps=1.12u w=0.74u l=0.13u
X2376 VPWR VGND VPWR VPWR sg13_lv_pmos ad=0.34p pd=2.68u as=0 ps=0 w=1u l=1u
X2377 VGND VPWR VGND VGND sg13_lv_nmos ad=0.1428p pd=1.52u as=0 ps=0 w=0.42u l=1u
X2378 a_7984_4870# a_7727_4727# a_8146_4650# VGND sg13_lv_nmos ad=0.1428p pd=1.52u as=37.8f ps=0.6u w=0.42u l=0.13u
X2379 VPWR VGND VPWR VPWR sg13_lv_pmos ad=0.19p pd=1.38u as=0 ps=0 w=1u l=1u
X2380 VPWR VGND VPWR VPWR sg13_lv_pmos ad=0.34p pd=2.68u as=0 ps=0 w=1u l=1u
X2381 VPWR VGND VPWR VPWR sg13_lv_pmos ad=0.19p pd=1.38u as=0 ps=0 w=1u l=1u
X2382 VPWR a_11279_17869# a_11536_17750# VPWR sg13_lv_pmos ad=0.4659p pd=3.65u as=79.8f ps=0.8u w=0.42u l=0.13u
X2383 VPWR VGND VPWR VPWR sg13_lv_pmos ad=0.19p pd=1.38u as=0 ps=0 w=1u l=1u
X2384 a_6048_13011# _189_.X a_6011_13320# VGND sg13_lv_nmos ad=0.2176p pd=1.96u as=78.39999f ps=0.885u w=0.64u l=0.13u
X2385 _219_.Y _215_.A VPWR VPWR sg13_lv_pmos ad=0.3808p pd=2.92u as=0.3808p ps=2.92u w=1.12u l=0.13u
X2386 a_14063_16357# a_13221_16007# a_13969_16357# VGND sg13_lv_nmos ad=0.12665p pd=1.145u as=0.1428p ps=1.52u w=0.42u l=0.13u
X2387 VGND a_16240_12430# a_15889_12287# VGND sg13_lv_nmos ad=79.8f pd=0.8u as=0.1428p ps=1.52u w=0.42u l=0.13u
X2388 a_16281_9501# a_15339_9308# a_16079_9263# VPWR sg13_lv_pmos ad=93.45f pd=0.865u as=0.2048p ps=1.63u w=0.42u l=0.13u
X2389 VGND VPWR VGND VGND sg13_lv_nmos ad=79.8f pd=0.8u as=0 ps=0 w=0.42u l=1u
X2390 a_14320_16238# _237_.Y a_14380_16119# VPWR sg13_lv_pmos ad=79.8f pd=0.8u as=0.204p ps=1.835u w=0.42u l=0.13u
X2391 VPWR _136_.B a_6836_3900# VPWR sg13_lv_pmos ad=0.2128p pd=1.5u as=0.2128p ps=1.5u w=1.12u l=0.13u
X2392 VPWR VGND VPWR VPWR sg13_lv_pmos ad=0.19p pd=1.38u as=0 ps=0 w=1u l=1u
X2393 VGND VPWR VGND VGND sg13_lv_nmos ad=0.1428p pd=1.52u as=0 ps=0 w=0.42u l=1u
X2394 VGND VPWR VGND VGND sg13_lv_nmos ad=79.8f pd=0.8u as=0 ps=0 w=0.42u l=1u
X2395 VPWR VGND VPWR VPWR sg13_lv_pmos ad=0.19p pd=1.38u as=0 ps=0 w=1u l=1u
X2396 _243_.CLK a_3956_6888# VPWR VPWR sg13_lv_pmos ad=0.2128p pd=1.5u as=0.2128p ps=1.5u w=1.12u l=0.13u
X2397 VPWR VGND VPWR VPWR sg13_lv_pmos ad=0.34p pd=2.68u as=0 ps=0 w=1u l=1u
X2398 clkbuf_1_0__f_sclk.A a_3886_10702# VPWR VPWR sg13_lv_pmos ad=0.2128p pd=1.5u as=0.2128p ps=1.5u w=1.12u l=0.13u
X2399 VPWR VGND VPWR VPWR sg13_lv_pmos ad=0.34p pd=2.68u as=0 ps=0 w=1u l=1u
X2400 a_10895_8436# _164_.B1 _164_.Y VPWR sg13_lv_pmos ad=0.3808p pd=2.92u as=0.2128p ps=1.5u w=1.12u l=0.13u
X2401 VPWR VGND VPWR VPWR sg13_lv_pmos ad=0.19p pd=1.38u as=0 ps=0 w=1u l=1u
X2402 a_13338_5770# _147_.Y VGND VGND sg13_lv_nmos ad=88.8f pd=0.98u as=0.15245p ps=1.17u w=0.74u l=0.13u
X2403 clkbuf_1_0__f_sclk.A a_3886_10702# VGND VGND sg13_lv_nmos ad=0.1406p pd=1.12u as=0.1406p ps=1.12u w=0.74u l=0.13u
X2404 VPWR VGND VPWR VPWR sg13_lv_pmos ad=0.19p pd=1.38u as=0 ps=0 w=1u l=1u
X2405 a_2793_8483# a_2436_8440# VPWR VPWR sg13_lv_pmos ad=63f pd=0.72u as=0.1563p ps=1.22u w=0.42u l=0.13u
X2406 VPWR VGND VPWR VPWR sg13_lv_pmos ad=0.34p pd=2.68u as=0 ps=0 w=1u l=1u
X2407 VGND a_2126_13912# _119_.X VGND sg13_lv_nmos ad=0.148p pd=1.14u as=0.4033p ps=2.57u w=0.74u l=0.13u
X2408 VPWR VGND VPWR VPWR sg13_lv_pmos ad=0.19p pd=1.38u as=0 ps=0 w=1u l=1u
X2409 VPWR _144_.B a_8564_5412# VPWR sg13_lv_pmos ad=0.2128p pd=1.5u as=0.2128p ps=1.5u w=1.12u l=0.13u
X2410 VGND VPWR VGND VGND sg13_lv_nmos ad=0.1428p pd=1.52u as=0 ps=0 w=0.42u l=1u
X2411 VPWR VGND VPWR VPWR sg13_lv_pmos ad=0.34p pd=2.68u as=0 ps=0 w=1u l=1u
X2412 VPWR a_3407_16357# a_3664_16238# VPWR sg13_lv_pmos ad=0.4659p pd=3.65u as=79.8f ps=0.8u w=0.42u l=0.13u
X2413 a_14532_5850# _151_.X a_14438_5850# VGND sg13_lv_nmos ad=60.89999f pd=0.71u as=0.1428p ps=1.52u w=0.42u l=0.13u
X2414 VPWR _145_.X a_10895_8436# VPWR sg13_lv_pmos ad=0.2128p pd=1.5u as=0.2128p ps=1.5u w=1.12u l=0.13u
X2415 _181_.Y _171_.A VGND VGND sg13_lv_nmos ad=0.1406p pd=1.12u as=0.2516p ps=2.16u w=0.74u l=0.13u
X2416 VPWR VGND VPWR VPWR sg13_lv_pmos ad=0.19p pd=1.38u as=0 ps=0 w=1u l=1u
X2417 _134_.Y _128_.B1 a_12984_12952# VPWR sg13_lv_pmos ad=0.2128p pd=1.5u as=0.2128p ps=1.5u w=1.12u l=0.15u
X2418 a_9636_4663# a_9348_4968# a_9574_4663# VGND sg13_lv_nmos ad=0.1428p pd=1.52u as=37.8f ps=0.6u w=0.42u l=0.13u
X2419 VGND _227_.Y a_14628_8874# VGND sg13_lv_nmos ad=0.1626p pd=1.415u as=60.89999f ps=0.71u w=0.42u l=0.13u
X2420 VPWR VGND VPWR VPWR sg13_lv_pmos ad=0.34p pd=2.68u as=0 ps=0 w=1u l=1u
X2421 VPWR VGND VPWR VPWR sg13_lv_pmos ad=0.34p pd=2.68u as=0 ps=0 w=1u l=1u
X2422 VPWR VGND VPWR VPWR sg13_lv_pmos ad=0.34p pd=2.68u as=0 ps=0 w=1u l=1u
X2423 VGND VPWR VGND VGND sg13_lv_nmos ad=79.8f pd=0.8u as=0 ps=0 w=0.42u l=1u
X2424 clkbuf_1_0__f_sclk.A a_3886_10702# VPWR VPWR sg13_lv_pmos ad=0.2128p pd=1.5u as=0.2128p ps=1.5u w=1.12u l=0.13u
X2425 a_10989_8784# _160_.X VGND VGND sg13_lv_nmos ad=0.1406p pd=1.12u as=0.2516p ps=2.16u w=0.74u l=0.13u
X2426 VGND _124_.S a_2620_17878# VGND sg13_lv_nmos ad=0.18945p pd=1.27u as=0.13135p ps=1.095u w=0.74u l=0.13u
X2427 a_1580_16710# fanout8.A VGND VGND sg13_lv_nmos ad=0.187p pd=1.78u as=0.14875p ps=1.16u w=0.55u l=0.13u
X2428 _162_.B _154_.X a_10995_7972# VPWR sg13_lv_pmos ad=0.2408p pd=1.55u as=0.1428p ps=1.375u w=1.12u l=0.13u
X2429 VGND VPWR VGND VGND sg13_lv_nmos ad=79.8f pd=0.8u as=0 ps=0 w=0.42u l=1u
X2430 a_3886_10702# sclk VGND VGND sg13_lv_nmos ad=0.1406p pd=1.12u as=0.1406p ps=1.12u w=0.74u l=0.13u
X2431 VGND VPWR VGND VGND sg13_lv_nmos ad=0.1428p pd=1.52u as=0 ps=0 w=0.42u l=1u
X2432 VPWR VGND VPWR VPWR sg13_lv_pmos ad=0.34p pd=2.68u as=0 ps=0 w=1u l=1u
X2433 a_9062_4650# a_9867_4772# a_9322_4873# VPWR sg13_lv_pmos ad=0.1428p pd=1.52u as=79.8f ps=0.8u w=0.42u l=0.13u
X2434 VPWR VGND VPWR VPWR sg13_lv_pmos ad=0.34p pd=2.68u as=0 ps=0 w=1u l=1u
X2435 a_9868_17061# a_9808_16966# a_9753_17061# VPWR sg13_lv_pmos ad=0.204p pd=1.835u as=93.45f ps=0.865u w=0.42u l=0.13u
X2436 VPWR VGND VPWR VPWR sg13_lv_pmos ad=0.34p pd=2.68u as=0 ps=0 w=1u l=1u
X2437 VPWR VGND VPWR VPWR sg13_lv_pmos ad=0.34p pd=2.68u as=0 ps=0 w=1u l=1u
X2438 VGND _207_.Y a_4625_16800# VGND sg13_lv_nmos ad=0.15245p pd=1.17u as=0.17462p ps=1.185u w=0.55u l=0.13u
X2439 VGND VPWR VGND VGND sg13_lv_nmos ad=79.8f pd=0.8u as=0 ps=0 w=0.42u l=1u
X2440 VPWR VGND VPWR VPWR sg13_lv_pmos ad=0.19p pd=1.38u as=0 ps=0 w=1u l=1u
X2441 VGND clkbuf_1_0__f_sclk.A a_3956_6888# VGND sg13_lv_nmos ad=0.1406p pd=1.12u as=0.1406p ps=1.12u w=0.74u l=0.13u
X2442 VGND VPWR VGND VGND sg13_lv_nmos ad=79.8f pd=0.8u as=0 ps=0 w=0.42u l=1u
X2443 VPWR VGND VPWR VPWR sg13_lv_pmos ad=0.19p pd=1.38u as=0 ps=0 w=1u l=1u
X2444 a_14320_16238# a_14063_16357# a_14482_16434# VGND sg13_lv_nmos ad=0.1428p pd=1.52u as=37.8f ps=0.6u w=0.42u l=0.13u
X2445 VPWR VGND VPWR VPWR sg13_lv_pmos ad=0.34p pd=2.68u as=0 ps=0 w=1u l=1u
X2446 a_6881_13320# _187_.Y _191_.Y VGND sg13_lv_nmos ad=0.1406p pd=1.12u as=0.1406p ps=1.12u w=0.74u l=0.13u
X2447 a_14067_7972# _160_.B VPWR VPWR sg13_lv_pmos ad=0.1428p pd=1.375u as=0.2891p ps=1.695u w=1.12u l=0.13u
X2448 VPWR _157_.Y a_12549_7996# VPWR sg13_lv_pmos ad=0.19p pd=1.38u as=0.2125p ps=1.425u w=1u l=0.13u
X2449 VPWR VGND VPWR VPWR sg13_lv_pmos ad=0.19p pd=1.38u as=0 ps=0 w=1u l=1u
X2450 a_1956_13410# _119_.X a_1862_13410# VGND sg13_lv_nmos ad=60.89999f pd=0.71u as=0.1428p ps=1.52u w=0.42u l=0.13u
X2451 _125_.A1 a_1192_7712# VPWR VPWR sg13_lv_pmos ad=0.42p pd=2.99u as=0.2114p ps=1.54u w=1.12u l=0.13u
X2452 a_3886_10702# sclk VPWR VPWR sg13_lv_pmos ad=0.2128p pd=1.5u as=0.2128p ps=1.5u w=1.12u l=0.13u
X2453 VPWR VGND VPWR VPWR sg13_lv_pmos ad=0.34p pd=2.68u as=0 ps=0 w=1u l=1u
X2454 a_1862_16746# a_2667_16868# a_2122_16969# VPWR sg13_lv_pmos ad=0.1428p pd=1.52u as=79.8f ps=0.8u w=0.42u l=0.13u
X2455 VGND VPWR VGND VGND sg13_lv_nmos ad=79.8f pd=0.8u as=0 ps=0 w=0.42u l=1u
X2456 VGND _118_.A0 a_4462_16052# VGND sg13_lv_nmos ad=0.17255p pd=1.25u as=0.187p ps=1.78u w=0.55u l=0.13u
X2457 a_3956_6888# clkbuf_1_0__f_sclk.A VGND VGND sg13_lv_nmos ad=0.1406p pd=1.12u as=0.1406p ps=1.12u w=0.74u l=0.13u
X2458 VGND VPWR VGND VGND sg13_lv_nmos ad=79.8f pd=0.8u as=0 ps=0 w=0.42u l=1u
X2459 _161_.Y _162_.B VPWR VPWR sg13_lv_pmos ad=0.2128p pd=1.5u as=0.3808p ps=2.92u w=1.12u l=0.13u
X2460 a_13883_11460# _129_.B1 _129_.Y VPWR sg13_lv_pmos ad=0.2128p pd=1.5u as=0.3808p ps=2.92u w=1.12u l=0.13u
X2461 _176_.A a_11082_12508# VPWR VPWR sg13_lv_pmos ad=0.3808p pd=2.92u as=0.2128p ps=1.5u w=1.12u l=0.13u
X2462 VPWR _153_.Y a_13244_7972# VPWR sg13_lv_pmos ad=0.2128p pd=1.5u as=0.3808p ps=2.92u w=1.12u l=0.13u
X2463 VGND VPWR VGND VGND sg13_lv_nmos ad=79.8f pd=0.8u as=0 ps=0 w=0.42u l=1u
X2464 VGND a_3886_10702# clkbuf_1_0__f_sclk.A VGND sg13_lv_nmos ad=0.2516p pd=2.16u as=0.1406p ps=1.12u w=0.74u l=0.13u
X2465 a_2671_6460# _243_.Q a_2494_6166# VPWR sg13_lv_pmos ad=0.2975p pd=1.595u as=0.2225p ps=1.445u w=1u l=0.13u
X2466 VPWR VGND VPWR VPWR sg13_lv_pmos ad=0.19p pd=1.38u as=0 ps=0 w=1u l=1u
X2467 a_4559_5773# a_3717_5423# a_3300_5416# VPWR sg13_lv_pmos ad=0.2048p pd=1.63u as=0.34p ps=2.68u w=1u l=0.13u
X2468 VPWR a_3956_6888# _243_.CLK VPWR sg13_lv_pmos ad=0.2128p pd=1.5u as=0.2128p ps=1.5u w=1.12u l=0.13u
X2469 VGND VPWR VGND VGND sg13_lv_nmos ad=79.8f pd=0.8u as=0 ps=0 w=0.42u l=1u
X2470 VGND VPWR VGND VGND sg13_lv_nmos ad=0.1428p pd=1.52u as=0 ps=0 w=0.42u l=1u
X2471 VGND _215_.Y a_3108_4650# VGND sg13_lv_nmos ad=0.1626p pd=1.415u as=60.89999f ps=0.71u w=0.42u l=0.13u
X2472 VPWR VGND VPWR VPWR sg13_lv_pmos ad=0.34p pd=2.68u as=0 ps=0 w=1u l=1u
X2473 a_15980_7638# fanout7.A VGND VGND sg13_lv_nmos ad=0.187p pd=1.78u as=0.14875p ps=1.16u w=0.55u l=0.13u
X2474 VGND a_7985_7728# _154_.X VGND sg13_lv_nmos ad=0.3108p pd=2.32u as=0.1628p ps=1.18u w=0.74u l=0.13u
X2475 a_6060_4166# _210_.B VPWR VPWR sg13_lv_pmos ad=0.1596p pd=1.22u as=0.2891p ps=1.695u w=0.84u l=0.13u
X2476 VGND VPWR VGND VGND sg13_lv_nmos ad=0.1428p pd=1.52u as=0 ps=0 w=0.42u l=1u
X2477 VGND VPWR VGND VGND sg13_lv_nmos ad=0.1428p pd=1.52u as=0 ps=0 w=0.42u l=1u
X2478 VPWR a_3407_16823# a_3664_16966# VPWR sg13_lv_pmos ad=0.4659p pd=3.65u as=79.8f ps=0.8u w=0.42u l=0.13u
X2479 a_6483_9212# _174_.Y VGND VGND sg13_lv_nmos ad=0.1406p pd=1.12u as=0.2516p ps=2.16u w=0.74u l=0.13u
X2480 VPWR a_3886_10702# clkbuf_1_0__f_sclk.A VPWR sg13_lv_pmos ad=0.3976p pd=2.95u as=0.2128p ps=1.5u w=1.12u l=0.13u
X2481 VPWR VGND VPWR VPWR sg13_lv_pmos ad=0.19p pd=1.38u as=0 ps=0 w=1u l=1u
X2482 VGND VPWR VGND VGND sg13_lv_nmos ad=0.1428p pd=1.52u as=0 ps=0 w=0.42u l=1u
X2483 VGND a_9167_16357# a_9834_15996# VGND sg13_lv_nmos ad=0.1406p pd=1.12u as=0.2516p ps=2.16u w=0.74u l=0.13u
X2484 VPWR _135_.A a_12992_15437# VPWR sg13_lv_pmos ad=0.2856p pd=2.36u as=0.1596p ps=1.22u w=0.84u l=0.13u
X2485 VGND a_3664_16238# a_3313_16357# VGND sg13_lv_nmos ad=79.8f pd=0.8u as=0.1428p ps=1.52u w=0.42u l=0.13u
X2486 VPWR VGND VPWR VPWR sg13_lv_pmos ad=0.34p pd=2.68u as=0 ps=0 w=1u l=1u
X2487 VPWR a_7872_5451# _252_.D VPWR sg13_lv_pmos ad=0.3808p pd=2.92u as=0.2408p ps=1.55u w=1.12u l=0.13u
X2488 VGND VPWR VGND VGND sg13_lv_nmos ad=79.8f pd=0.8u as=0 ps=0 w=0.42u l=1u
X2489 a_8557_4248# _143_.Y a_8480_4248# VGND sg13_lv_nmos ad=0.1406p pd=1.12u as=94.35f ps=0.995u w=0.74u l=0.13u
X2490 a_15237_11471# _133_.B a_15697_11813# VGND sg13_lv_nmos ad=0.2516p pd=2.16u as=0.31732p ps=1.805u w=0.74u l=0.13u
X2491 a_9994_9409# a_10437_9165# a_10377_9577# VPWR sg13_lv_pmos ad=79.8f pd=0.8u as=63f ps=0.72u w=0.42u l=0.13u
X2492 VGND VPWR VGND VGND sg13_lv_nmos ad=0.1428p pd=1.52u as=0 ps=0 w=0.42u l=1u
X2493 VPWR a_3380_13690# _247_.CLK VPWR sg13_lv_pmos ad=0.2128p pd=1.5u as=0.2128p ps=1.5u w=1.12u l=0.13u
X2494 VPWR VGND VPWR VPWR sg13_lv_pmos ad=0.34p pd=2.68u as=0 ps=0 w=1u l=1u
X2495 _232_.Y _222_.A VPWR VPWR sg13_lv_pmos ad=0.3808p pd=2.92u as=0.3808p ps=2.92u w=1.12u l=0.13u
X2496 VGND VPWR VGND VGND sg13_lv_nmos ad=0.1428p pd=1.52u as=0 ps=0 w=0.42u l=1u
X2497 a_14666_16746# a_14359_16710# a_14572_16746# VGND sg13_lv_nmos ad=37.8f pd=0.6u as=0.1428p ps=1.52u w=0.42u l=0.13u
X2498 VGND VPWR VGND VGND sg13_lv_nmos ad=0.1428p pd=1.52u as=0 ps=0 w=0.42u l=1u
X2499 VPWR a_6048_13011# _192_.C VPWR sg13_lv_pmos ad=0.3808p pd=2.92u as=0.2408p ps=1.55u w=1.12u l=0.13u
X2500 VPWR VGND VPWR VPWR sg13_lv_pmos ad=0.34p pd=2.68u as=0 ps=0 w=1u l=1u
X2501 VPWR VGND VPWR VPWR sg13_lv_pmos ad=0.19p pd=1.38u as=0 ps=0 w=1u l=1u
X2502 _129_.B1 _126_.B1 a_13464_12952# VPWR sg13_lv_pmos ad=0.2128p pd=1.5u as=0.2128p ps=1.5u w=1.12u l=0.15u
X2503 a_14698_5380# a_15141_5423# a_14438_5850# VGND sg13_lv_nmos ad=79.8f pd=0.8u as=0.1296p ps=1.52u w=0.42u l=0.13u
X2504 VGND VPWR VGND VGND sg13_lv_nmos ad=79.8f pd=0.8u as=0 ps=0 w=0.42u l=1u
X2505 _243_.CLK a_3956_6888# VGND VGND sg13_lv_nmos ad=0.1406p pd=1.12u as=0.1406p ps=1.12u w=0.74u l=0.13u
X2506 a_2505_16043# a_2148_16000# VPWR VPWR sg13_lv_pmos ad=63f pd=0.72u as=0.1563p ps=1.22u w=0.42u l=0.13u
X2507 a_13403_8436# _157_.Y _158_.Y VPWR sg13_lv_pmos ad=0.2128p pd=1.5u as=0.3808p ps=2.92u w=1.12u l=0.13u
X2508 a_2126_13912# _119_.A0 a_2298_13726# VGND sg13_lv_nmos ad=0.1628p pd=1.18u as=0.3367p ps=1.65u w=0.74u l=0.13u
X2509 a_13019_6460# _148_.X VPWR VPWR sg13_lv_pmos ad=0.3808p pd=2.92u as=0.2128p ps=1.5u w=1.12u l=0.13u
X2510 VGND a_3380_13690# _247_.CLK VGND sg13_lv_nmos ad=0.1406p pd=1.12u as=0.1406p ps=1.12u w=0.74u l=0.13u
X2511 VPWR a_7727_4727# a_7984_4870# VPWR sg13_lv_pmos ad=0.4659p pd=3.65u as=79.8f ps=0.8u w=0.42u l=0.13u
X2512 a_3108_5850# _244_.D a_3014_5850# VGND sg13_lv_nmos ad=60.89999f pd=0.71u as=0.1428p ps=1.52u w=0.42u l=0.13u
X2513 VGND _148_.X a_13121_6188# VGND sg13_lv_nmos ad=0.2516p pd=2.16u as=0.1406p ps=1.12u w=0.74u l=0.13u
X2514 a_14820_9504# a_14794_9409# VPWR VPWR sg13_lv_pmos ad=0.34p pd=2.68u as=0.36237p ps=2.605u w=1u l=0.13u
X2515 VGND VPWR VGND VGND sg13_lv_nmos ad=79.8f pd=0.8u as=0 ps=0 w=0.42u l=1u
X2516 VGND _191_.Y _193_.Y VGND sg13_lv_nmos ad=0.2516p pd=2.16u as=0.1406p ps=1.12u w=0.74u l=0.13u
X2517 a_16079_8797# a_15237_8447# a_14820_8440# VPWR sg13_lv_pmos ad=0.2048p pd=1.63u as=0.34p ps=2.68u w=1u l=0.13u
X2518 a_15237_9165# _260_.CLK a_15697_9482# VPWR sg13_lv_pmos ad=0.4088p pd=2.97u as=0.41165p ps=2.12u w=1.12u l=0.13u
X2519 VPWR VGND VPWR VPWR sg13_lv_pmos ad=0.34p pd=2.68u as=0 ps=0 w=1u l=1u
X2520 a_14566_15247# _239_.Y VGND VGND sg13_lv_nmos ad=37.8f pd=0.6u as=0.1701p ps=1.65u w=0.42u l=0.13u
X2521 VPWR VGND VPWR VPWR sg13_lv_pmos ad=0.34p pd=2.68u as=0 ps=0 w=1u l=1u
X2522 a_8050_10326# _164_.Y VGND VGND sg13_lv_nmos ad=0.2516p pd=2.16u as=0.1406p ps=1.12u w=0.74u l=0.15u
X2523 VGND VPWR VGND VGND sg13_lv_nmos ad=0.1428p pd=1.52u as=0 ps=0 w=0.42u l=1u
X2524 a_2565_12983# _247_.CLK a_3025_12974# VPWR sg13_lv_pmos ad=0.4088p pd=2.97u as=0.41165p ps=2.12u w=1.12u l=0.13u
X2525 VGND VPWR VGND VGND sg13_lv_nmos ad=0.1428p pd=1.52u as=0 ps=0 w=0.42u l=1u
X2526 VGND VPWR VGND VGND sg13_lv_nmos ad=0.1428p pd=1.52u as=0 ps=0 w=0.42u l=1u
X2527 VGND VPWR VGND VGND sg13_lv_nmos ad=0.1428p pd=1.52u as=0 ps=0 w=0.42u l=1u
X2528 VGND VPWR VGND VGND sg13_lv_nmos ad=0.1428p pd=1.52u as=0 ps=0 w=0.42u l=1u
X2529 VGND _192_.Y a_6958_13764# VGND sg13_lv_nmos ad=0.17255p pd=1.25u as=0.187p ps=1.78u w=0.55u l=0.13u
X2530 VPWR _240_.Y a_9734_17946# VPWR sg13_lv_pmos ad=0.36237p pd=2.605u as=79.8f ps=0.8u w=0.42u l=0.13u
X2531 _206_.Y a_4462_16052# VGND VGND sg13_lv_nmos ad=0.1406p pd=1.12u as=0.17255p ps=1.25u w=0.74u l=0.13u
X2532 VGND _170_.Y a_8014_8492# VGND sg13_lv_nmos ad=0.17255p pd=1.25u as=0.187p ps=1.78u w=0.55u l=0.13u
X2533 VPWR VGND VPWR VPWR sg13_lv_pmos ad=0.34p pd=2.68u as=0 ps=0 w=1u l=1u
X2534 VPWR _148_.B a_8488_8436# VPWR sg13_lv_pmos ad=0.2114p pd=1.54u as=0.2856p ps=2.36u w=0.84u l=0.13u
X2535 VGND a_9424_16238# a_9073_16357# VGND sg13_lv_nmos ad=79.8f pd=0.8u as=0.1428p ps=1.52u w=0.42u l=0.13u
X2536 VGND VPWR VGND VGND sg13_lv_nmos ad=79.8f pd=0.8u as=0 ps=0 w=0.42u l=1u
X2537 VGND VPWR VGND VGND sg13_lv_nmos ad=0.1428p pd=1.52u as=0 ps=0 w=0.42u l=1u
X2538 a_4114_8874# _218_.Y VGND VGND sg13_lv_nmos ad=37.8f pd=0.6u as=79.8f ps=0.8u w=0.42u l=0.13u
X2539 a_6124_9945# _174_.Y VPWR VPWR sg13_lv_pmos ad=0.1596p pd=1.22u as=0.1596p ps=1.22u w=0.84u l=0.13u
X2540 VGND VPWR VGND VGND sg13_lv_nmos ad=0.1428p pd=1.52u as=0 ps=0 w=0.42u l=1u
X2541 a_3407_16823# a_2565_16725# a_2148_17064# VPWR sg13_lv_pmos ad=0.2048p pd=1.63u as=0.34p ps=2.68u w=1u l=0.13u
X2542 a_8649_17137# a_8292_17064# VPWR VPWR sg13_lv_pmos ad=63f pd=0.72u as=0.1563p ps=1.22u w=0.42u l=0.13u
X2543 _247_.CLK a_3380_13690# VPWR VPWR sg13_lv_pmos ad=0.2128p pd=1.5u as=0.2128p ps=1.5u w=1.12u l=0.13u
X2544 VPWR VGND VPWR VPWR sg13_lv_pmos ad=0.34p pd=2.68u as=0 ps=0 w=1u l=1u
X2545 a_2558_9972# _173_.A a_2126_10214# VPWR sg13_lv_pmos ad=0.3325p pd=1.665u as=0.2225p ps=1.445u w=1u l=0.13u
X2546 VPWR VGND VPWR VPWR sg13_lv_pmos ad=0.34p pd=2.68u as=0 ps=0 w=1u l=1u
X2547 a_8518_16759# _232_.Y VGND VGND sg13_lv_nmos ad=37.8f pd=0.6u as=0.1701p ps=1.65u w=0.42u l=0.13u
X2548 VPWR VGND VPWR VPWR sg13_lv_pmos ad=0.19p pd=1.38u as=0 ps=0 w=1u l=1u
X2549 VGND VPWR VGND VGND sg13_lv_nmos ad=0.1428p pd=1.52u as=0 ps=0 w=0.42u l=1u
X2550 VGND _157_.B a_13073_5770# VGND sg13_lv_nmos ad=0.15245p pd=1.17u as=0.17462p ps=1.185u w=0.55u l=0.13u
X2551 _139_.X a_10769_4258# a_10940_3900# VPWR sg13_lv_pmos ad=0.3808p pd=2.92u as=0.2128p ps=1.5u w=1.12u l=0.13u
X2552 a_2398_5782# _210_.A a_2301_5436# VPWR sg13_lv_pmos ad=0.2225p pd=1.445u as=0.3325p ps=1.665u w=1u l=0.13u
X2553 VGND a_13648_12430# a_13297_12287# VGND sg13_lv_nmos ad=79.8f pd=0.8u as=0.1428p ps=1.52u w=0.42u l=0.13u
X2554 a_5376_17061# _207_.A2 a_5339_16792# VGND sg13_lv_nmos ad=0.2176p pd=1.96u as=78.39999f ps=0.885u w=0.64u l=0.13u
X2555 VGND VPWR VGND VGND sg13_lv_nmos ad=0.1428p pd=1.52u as=0 ps=0 w=0.42u l=1u
X2556 a_8265_16043# a_7908_16000# VPWR VPWR sg13_lv_pmos ad=63f pd=0.72u as=0.1563p ps=1.22u w=0.42u l=0.13u
X2557 a_10769_4258# _243_.Q VGND VGND sg13_lv_nmos ad=0.17462p pd=1.185u as=0.374p ps=2.46u w=0.55u l=0.13u
X2558 VGND _124_.S a_2171_6204# VGND sg13_lv_nmos ad=0.18945p pd=1.27u as=0.187p ps=1.78u w=0.55u l=0.13u
X2559 VGND VPWR VGND VGND sg13_lv_nmos ad=79.8f pd=0.8u as=0 ps=0 w=0.42u l=1u
X2560 _229_.Y _236_.A VPWR VPWR sg13_lv_pmos ad=0.3808p pd=2.92u as=0.3808p ps=2.92u w=1.12u l=0.13u
X2561 _207_.A1 a_9834_15996# VPWR VPWR sg13_lv_pmos ad=0.3808p pd=2.92u as=0.2128p ps=1.5u w=1.12u l=0.13u
X2562 VPWR VGND VPWR VPWR sg13_lv_pmos ad=0.34p pd=2.68u as=0 ps=0 w=1u l=1u
X2563 a_3380_13690# clkbuf_1_0__f_sclk.A VGND VGND sg13_lv_nmos ad=0.1406p pd=1.12u as=0.1406p ps=1.12u w=0.74u l=0.13u
X2564 VPWR VGND VPWR VPWR sg13_lv_pmos ad=0.34p pd=2.68u as=0 ps=0 w=1u l=1u
X2565 VPWR _148_.A a_12572_4948# VPWR sg13_lv_pmos ad=0.2128p pd=1.5u as=0.3808p ps=2.92u w=1.12u l=0.13u
X2566 VPWR VGND VPWR VPWR sg13_lv_pmos ad=0.34p pd=2.68u as=0 ps=0 w=1u l=1u
X2567 VGND a_14240_16921# _135_.A VGND sg13_lv_nmos ad=0.1406p pd=1.12u as=0.2516p ps=2.16u w=0.74u l=0.13u
X2568 VPWR _239_.Y a_14314_15457# VPWR sg13_lv_pmos ad=0.1563p pd=1.22u as=0.147p ps=1.54u w=0.42u l=0.13u
X2569 VGND VPWR VGND VGND sg13_lv_nmos ad=79.8f pd=0.8u as=0 ps=0 w=0.42u l=1u
X2570 a_6779_12972# _192_.C _191_.Y VPWR sg13_lv_pmos ad=0.2128p pd=1.5u as=0.3808p ps=2.92u w=1.12u l=0.13u
X2571 VPWR VGND VPWR VPWR sg13_lv_pmos ad=0.19p pd=1.38u as=0 ps=0 w=1u l=1u
X2572 VPWR a_2126_10214# _246_.D VPWR sg13_lv_pmos ad=0.2198p pd=1.52u as=0.6048p ps=3.32u w=1.12u l=0.13u
X2573 a_7157_9948# _171_.A VPWR VPWR sg13_lv_pmos ad=0.2128p pd=1.5u as=0.2128p ps=1.5u w=1.12u l=0.13u
X2574 VGND VPWR VGND VGND sg13_lv_nmos ad=0.1428p pd=1.52u as=0 ps=0 w=0.42u l=1u
X2575 a_12369_4972# _148_.A VPWR VPWR sg13_lv_pmos ad=0.1225p pd=1.245u as=0.36p ps=2.72u w=1u l=0.13u
X2576 a_14794_9409# a_15237_9165# a_15177_9577# VPWR sg13_lv_pmos ad=79.8f pd=0.8u as=63f ps=0.72u w=0.42u l=0.13u
X2577 VPWR VGND VPWR VPWR sg13_lv_pmos ad=0.34p pd=2.68u as=0 ps=0 w=1u l=1u
X2578 VPWR clkbuf_1_0__f_sclk.A a_3956_6888# VPWR sg13_lv_pmos ad=0.2128p pd=1.5u as=0.2128p ps=1.5u w=1.12u l=0.13u
X2579 VPWR VGND VPWR VPWR sg13_lv_pmos ad=0.19p pd=1.38u as=0 ps=0 w=1u l=1u
X2580 VGND a_4816_4870# a_4465_4727# VGND sg13_lv_nmos ad=79.8f pd=0.8u as=0.1428p ps=1.52u w=0.42u l=0.13u
X2581 VGND VPWR VGND VGND sg13_lv_nmos ad=0.1428p pd=1.52u as=0 ps=0 w=0.42u l=1u
X2582 a_8050_10326# _185_.Y _186_.Y VGND sg13_lv_nmos ad=0.1406p pd=1.12u as=0.2516p ps=2.16u w=0.74u l=0.15u
X2583 VPWR VGND VPWR VPWR sg13_lv_pmos ad=0.34p pd=2.68u as=0 ps=0 w=1u l=1u
X2584 VPWR VGND VPWR VPWR sg13_lv_pmos ad=0.19p pd=1.38u as=0 ps=0 w=1u l=1u
X2585 a_10752_7989# _166_.A VPWR VPWR sg13_lv_pmos ad=0.1596p pd=1.22u as=0.4536p ps=2.76u w=0.84u l=0.13u
X2586 a_15861_16904# a_14919_16964# a_15767_17137# VPWR sg13_lv_pmos ad=79.8f pd=0.8u as=0.1428p ps=1.52u w=0.42u l=0.13u
X2587 VPWR _192_.Y a_6958_13764# VPWR sg13_lv_pmos ad=0.2618p pd=1.63u as=0.2856p ps=2.36u w=0.84u l=0.13u
X2588 VGND VPWR VGND VGND sg13_lv_nmos ad=79.8f pd=0.8u as=0 ps=0 w=0.42u l=1u
X2589 VPWR VGND VPWR VPWR sg13_lv_pmos ad=0.19p pd=1.38u as=0 ps=0 w=1u l=1u
X2590 a_2853_8447# _243_.CLK a_3313_8438# VPWR sg13_lv_pmos ad=0.4088p pd=2.97u as=0.41165p ps=2.12u w=1.12u l=0.13u
X2591 a_6106_9190# _168_.B VGND VGND sg13_lv_nmos ad=0.1406p pd=1.12u as=0.2516p ps=2.16u w=0.74u l=0.13u
X2592 VGND VPWR VGND VGND sg13_lv_nmos ad=79.8f pd=0.8u as=0 ps=0 w=0.42u l=1u
X2593 _176_.B _148_.B a_5562_12226# VGND sg13_lv_nmos ad=0.1628p pd=1.18u as=88.8f ps=0.98u w=0.74u l=0.13u
X2594 a_2558_11484# _120_.A0 a_2126_11726# VPWR sg13_lv_pmos ad=0.3325p pd=1.665u as=0.2225p ps=1.445u w=1u l=0.13u
X2595 VGND VPWR VGND VGND sg13_lv_nmos ad=0.1428p pd=1.52u as=0 ps=0 w=0.42u l=1u
X2596 a_3956_6888# clkbuf_1_0__f_sclk.A VPWR VPWR sg13_lv_pmos ad=0.2128p pd=1.5u as=0.2128p ps=1.5u w=1.12u l=0.13u
X2597 a_12923_11460# _126_.B1 _126_.Y VPWR sg13_lv_pmos ad=0.2128p pd=1.5u as=0.3808p ps=2.92u w=1.12u l=0.13u
X2598 a_11220_5760# _139_.X a_10764_5678# VGND sg13_lv_nmos ad=78.39999f pd=0.885u as=0.2176p ps=1.96u w=0.64u l=0.13u
X2599 a_12401_4704# _148_.A VGND VGND sg13_lv_nmos ad=0.17462p pd=1.185u as=0.374p ps=2.46u w=0.55u l=0.13u
X2600 a_2662_8861# _218_.Y VGND VGND sg13_lv_nmos ad=37.8f pd=0.6u as=0.1701p ps=1.65u w=0.42u l=0.13u
X2601 VGND VPWR VGND VGND sg13_lv_nmos ad=79.8f pd=0.8u as=0 ps=0 w=0.42u l=1u
X2602 VPWR VGND VPWR VPWR sg13_lv_pmos ad=0.19p pd=1.38u as=0 ps=0 w=1u l=1u
X2603 VPWR VGND VPWR VPWR sg13_lv_pmos ad=0.19p pd=1.38u as=0 ps=0 w=1u l=1u
X2604 VPWR VGND VPWR VPWR sg13_lv_pmos ad=0.34p pd=2.68u as=0 ps=0 w=1u l=1u
X2605 a_16336_8678# a_16079_8797# a_16498_8874# VGND sg13_lv_nmos ad=0.1428p pd=1.52u as=37.8f ps=0.6u w=0.42u l=0.13u
X2606 VGND VPWR VGND VGND sg13_lv_nmos ad=79.8f pd=0.8u as=0 ps=0 w=0.42u l=1u
X2607 a_9513_12601# a_9156_12528# VPWR VPWR sg13_lv_pmos ad=63f pd=0.72u as=0.1563p ps=1.22u w=0.42u l=0.13u
X2608 a_2532_12223# a_2763_12332# a_2218_12433# VGND sg13_lv_nmos ad=0.2373p pd=1.97u as=79.8f ps=0.8u w=0.42u l=0.13u
X2609 _200_.Y _195_.Y VPWR VPWR sg13_lv_pmos ad=0.3808p pd=2.92u as=0.2128p ps=1.5u w=1.12u l=0.13u
X2610 a_2494_6166# _243_.Q a_2397_6166# VGND sg13_lv_nmos ad=0.1628p pd=1.18u as=0.13135p ps=1.095u w=0.74u l=0.13u
X2611 VPWR _230_.Y a_9130_13945# VPWR sg13_lv_pmos ad=0.1563p pd=1.22u as=0.147p ps=1.54u w=0.42u l=0.13u
X2612 VPWR VGND VPWR VPWR sg13_lv_pmos ad=0.19p pd=1.38u as=0 ps=0 w=1u l=1u
X2613 a_9828_9186# _172_.Y a_9734_9186# VGND sg13_lv_nmos ad=60.89999f pd=0.71u as=0.1428p ps=1.52u w=0.42u l=0.13u
X2614 VGND VPWR VGND VGND sg13_lv_nmos ad=79.8f pd=0.8u as=0 ps=0 w=0.42u l=1u
X2615 VPWR VGND VPWR VPWR sg13_lv_pmos ad=0.34p pd=2.68u as=0 ps=0 w=1u l=1u
X2616 VPWR VGND VPWR VPWR sg13_lv_pmos ad=0.19p pd=1.38u as=0 ps=0 w=1u l=1u
X2617 VGND rst a_1192_17508# VGND sg13_lv_nmos ad=0.14875p pd=1.16u as=0.187p ps=1.78u w=0.55u l=0.13u
X2618 VGND VPWR VGND VGND sg13_lv_nmos ad=0.1428p pd=1.52u as=0 ps=0 w=0.42u l=1u
X2619 VPWR VGND VPWR VPWR sg13_lv_pmos ad=0.34p pd=2.68u as=0 ps=0 w=1u l=1u
X2620 VPWR _168_.A _174_.Y VPWR sg13_lv_pmos ad=0.3808p pd=2.92u as=0.2128p ps=1.5u w=1.12u l=0.13u
X2621 a_2410_8404# a_2853_8447# a_2793_8483# VPWR sg13_lv_pmos ad=79.8f pd=0.8u as=63f ps=0.72u w=0.42u l=0.13u
X2622 VPWR VGND VPWR VPWR sg13_lv_pmos ad=0.34p pd=2.68u as=0 ps=0 w=1u l=1u
X2623 VPWR VGND VPWR VPWR sg13_lv_pmos ad=0.34p pd=2.68u as=0 ps=0 w=1u l=1u
X2624 VPWR a_4559_4727# a_5226_4948# VPWR sg13_lv_pmos ad=0.2128p pd=1.5u as=0.3864p ps=2.93u w=1.12u l=0.13u
X2625 VPWR VGND VPWR VPWR sg13_lv_pmos ad=0.19p pd=1.38u as=0 ps=0 w=1u l=1u
X2626 _193_.Y _191_.Y a_7180_14020# VPWR sg13_lv_pmos ad=0.3808p pd=2.92u as=0.1176p ps=1.33u w=1.12u l=0.13u
X2627 a_2148_12976# a_2122_12940# VPWR VPWR sg13_lv_pmos ad=0.34p pd=2.68u as=0.36237p ps=2.605u w=1u l=0.13u
X2628 _194_.X a_7985_13776# a_8156_14020# VPWR sg13_lv_pmos ad=0.3808p pd=2.92u as=0.2128p ps=1.5u w=1.12u l=0.13u
X2629 VGND _160_.X a_10989_8784# VGND sg13_lv_nmos ad=0.1406p pd=1.12u as=0.1406p ps=1.12u w=0.74u l=0.13u
X2630 a_11364_17064# a_11338_16969# VPWR VPWR sg13_lv_pmos ad=0.34p pd=2.68u as=0.36237p ps=2.605u w=1u l=0.13u
X2631 a_14724_5416# a_14698_5380# VPWR VPWR sg13_lv_pmos ad=0.34p pd=2.68u as=0.36237p ps=2.605u w=1u l=0.13u
X2632 a_15141_5423# _251_.CLK a_15601_5765# VGND sg13_lv_nmos ad=0.2516p pd=2.16u as=0.31732p ps=1.805u w=0.74u l=0.13u
X2633 VPWR a_13824_7989# _159_.Y VPWR sg13_lv_pmos ad=0.3808p pd=2.92u as=0.2408p ps=1.55u w=1.12u l=0.13u
X2634 _252_.D _145_.A2 a_8115_5412# VPWR sg13_lv_pmos ad=0.2408p pd=1.55u as=0.1428p ps=1.375u w=1.12u l=0.13u
X2635 VGND VPWR VGND VGND sg13_lv_nmos ad=0.1428p pd=1.52u as=0 ps=0 w=0.42u l=1u
X2636 VGND VPWR VGND VGND sg13_lv_nmos ad=79.8f pd=0.8u as=0 ps=0 w=0.42u l=1u
X2637 a_2150_8874# _122_.X VPWR VPWR sg13_lv_pmos ad=79.8f pd=0.8u as=0.1428p ps=1.52u w=0.42u l=0.13u
X2638 a_12518_16434# a_13323_16007# a_12778_15964# VPWR sg13_lv_pmos ad=0.1428p pd=1.52u as=79.8f ps=0.8u w=0.42u l=0.13u
X2639 VGND a_10864_4870# a_10513_4727# VGND sg13_lv_nmos ad=79.8f pd=0.8u as=0.1428p ps=1.52u w=0.42u l=0.13u
X2640 a_9156_14040# a_9130_13945# VGND VGND sg13_lv_nmos ad=0.2516p pd=2.16u as=0.1626p ps=1.415u w=0.74u l=0.13u
X2641 _243_.CLK a_3956_6888# VPWR VPWR sg13_lv_pmos ad=0.2128p pd=1.5u as=0.2128p ps=1.5u w=1.12u l=0.13u
X2642 VPWR VGND VPWR VPWR sg13_lv_pmos ad=0.19p pd=1.38u as=0 ps=0 w=1u l=1u
X2643 a_2301_5436# _124_.S VPWR VPWR sg13_lv_pmos ad=0.3325p pd=1.665u as=0.253p ps=1.53u w=1u l=0.13u
X2644 VPWR VGND VPWR VPWR sg13_lv_pmos ad=0.34p pd=2.68u as=0 ps=0 w=1u l=1u
X2645 a_10834_12210# _229_.Y VGND VGND sg13_lv_nmos ad=37.8f pd=0.6u as=79.8f ps=0.8u w=0.42u l=0.13u
X2646 VGND _186_.Y a_7168_15260# VGND sg13_lv_nmos ad=0.1406p pd=1.12u as=0.1406p ps=1.12u w=0.74u l=0.13u
X2647 VGND VPWR VGND VGND sg13_lv_nmos ad=0.1428p pd=1.52u as=0 ps=0 w=0.42u l=1u
X2648 VPWR VGND VPWR VPWR sg13_lv_pmos ad=0.19p pd=1.38u as=0 ps=0 w=1u l=1u
X2649 a_9753_17061# a_8811_16868# a_9551_16823# VPWR sg13_lv_pmos ad=93.45f pd=0.865u as=0.2048p ps=1.63u w=0.42u l=0.13u
X2650 a_4816_4870# a_4559_4727# a_4978_4650# VGND sg13_lv_nmos ad=0.1428p pd=1.52u as=37.8f ps=0.6u w=0.42u l=0.13u
X2651 a_10437_9165# _251_.CLK a_10897_9207# VGND sg13_lv_nmos ad=0.2516p pd=2.16u as=0.31732p ps=1.805u w=0.74u l=0.13u
X2652 a_8266_16969# a_8709_16725# a_8006_16746# VGND sg13_lv_nmos ad=79.8f pd=0.8u as=0.1296p ps=1.52u w=0.42u l=0.13u
X2653 VPWR a_3407_16823# a_4074_17044# VPWR sg13_lv_pmos ad=0.2128p pd=1.5u as=0.3864p ps=2.93u w=1.12u l=0.13u
X2654 a_3526_4663# _215_.Y VGND VGND sg13_lv_nmos ad=37.8f pd=0.6u as=0.1701p ps=1.65u w=0.42u l=0.13u
X2655 _122_.A0 a_4362_8436# VGND VGND sg13_lv_nmos ad=0.2516p pd=2.16u as=0.1406p ps=1.12u w=0.74u l=0.13u
X2656 VPWR _122_.A0 a_8156_7972# VPWR sg13_lv_pmos ad=0.2128p pd=1.5u as=0.3808p ps=2.92u w=1.12u l=0.13u
X2657 VGND VPWR VGND VGND sg13_lv_nmos ad=79.8f pd=0.8u as=0 ps=0 w=0.42u l=1u
X2658 VGND VPWR VGND VGND sg13_lv_nmos ad=0.1428p pd=1.52u as=0 ps=0 w=0.42u l=1u
X2659 VGND VPWR VGND VGND sg13_lv_nmos ad=0.1428p pd=1.52u as=0 ps=0 w=0.42u l=1u
X2660 VPWR VGND VPWR VPWR sg13_lv_pmos ad=0.34p pd=2.68u as=0 ps=0 w=1u l=1u
X2661 a_12237_5760# _148_.A VPWR VPWR sg13_lv_pmos ad=0.1596p pd=1.22u as=0.2856p ps=2.36u w=0.84u l=0.13u
X2662 VGND VPWR VGND VGND sg13_lv_nmos ad=0.1428p pd=1.52u as=0 ps=0 w=0.42u l=1u
X2663 a_3952_9406# _219_.Y a_4012_9501# VPWR sg13_lv_pmos ad=79.8f pd=0.8u as=0.204p ps=1.835u w=0.42u l=0.13u
X2664 VPWR _250_.RESET_B a_1862_16434# VPWR sg13_lv_pmos ad=0.36237p pd=2.605u as=79.8f ps=0.8u w=0.42u l=0.13u
X2665 VGND VPWR VGND VGND sg13_lv_nmos ad=0.1428p pd=1.52u as=0 ps=0 w=0.42u l=1u
X2666 a_11698_9186# _228_.Y VGND VGND sg13_lv_nmos ad=37.8f pd=0.6u as=79.8f ps=0.8u w=0.42u l=0.13u
X2667 a_8352_11013# _181_.Y a_8315_10744# VGND sg13_lv_nmos ad=0.2176p pd=1.96u as=78.39999f ps=0.885u w=0.64u l=0.13u
X2668 VPWR VGND VPWR VPWR sg13_lv_pmos ad=0.19p pd=1.38u as=0 ps=0 w=1u l=1u
X2669 VPWR _224_.Y a_6182_4650# VPWR sg13_lv_pmos ad=0.36237p pd=2.605u as=79.8f ps=0.8u w=0.42u l=0.13u
X2670 a_2575_4948# _210_.A a_2398_4654# VPWR sg13_lv_pmos ad=0.2975p pd=1.595u as=0.2225p ps=1.445u w=1u l=0.13u
X2671 VPWR VGND VPWR VPWR sg13_lv_pmos ad=0.34p pd=2.68u as=0 ps=0 w=1u l=1u
X2672 VPWR VGND VPWR VPWR sg13_lv_pmos ad=0.34p pd=2.68u as=0 ps=0 w=1u l=1u
X2673 VGND VPWR VGND VGND sg13_lv_nmos ad=79.8f pd=0.8u as=0 ps=0 w=0.42u l=1u
X2674 VPWR VGND VPWR VPWR sg13_lv_pmos ad=0.19p pd=1.38u as=0 ps=0 w=1u l=1u
X2675 a_1956_16746# _118_.X a_1862_16746# VGND sg13_lv_nmos ad=60.89999f pd=0.71u as=0.1428p ps=1.52u w=0.42u l=0.13u
X2676 VGND VPWR VGND VGND sg13_lv_nmos ad=0.1428p pd=1.52u as=0 ps=0 w=0.42u l=1u
X2677 VGND _221_.Y a_1956_13410# VGND sg13_lv_nmos ad=0.1626p pd=1.415u as=60.89999f ps=0.71u w=0.42u l=0.13u
X2678 a_2505_13019# a_2148_12976# VPWR VPWR sg13_lv_pmos ad=63f pd=0.72u as=0.1563p ps=1.22u w=0.42u l=0.13u
X2679 _166_.A a_16746_8436# VPWR VPWR sg13_lv_pmos ad=0.3808p pd=2.92u as=0.2128p ps=1.5u w=1.12u l=0.13u
X2680 VPWR VGND VPWR VPWR sg13_lv_pmos ad=0.34p pd=2.68u as=0 ps=0 w=1u l=1u
X2681 _131_.B1 _260_.CLK a_14357_12972# VPWR sg13_lv_pmos ad=0.3808p pd=2.92u as=0.2128p ps=1.5u w=1.12u l=0.13u
X2682 _243_.D a_2398_4654# VGND VGND sg13_lv_nmos ad=0.4033p pd=2.57u as=0.148p ps=1.14u w=0.74u l=0.13u
X2683 _205_.Y _199_.Y a_7074_15532# VPWR sg13_lv_pmos ad=0.3808p pd=2.92u as=0.2128p ps=1.5u w=1.12u l=0.13u
X2684 VGND VPWR VGND VGND sg13_lv_nmos ad=79.8f pd=0.8u as=0 ps=0 w=0.42u l=1u
X2685 VGND VPWR VGND VGND sg13_lv_nmos ad=79.8f pd=0.8u as=0 ps=0 w=0.42u l=1u
X2686 VPWR VGND VPWR VPWR sg13_lv_pmos ad=0.34p pd=2.68u as=0 ps=0 w=1u l=1u
X2687 VGND VPWR VGND VGND sg13_lv_nmos ad=79.8f pd=0.8u as=0 ps=0 w=0.42u l=1u
X2688 VPWR a_13184_7183# _160_.X VPWR sg13_lv_pmos ad=0.1918p pd=1.5u as=0.3808p ps=2.92u w=1.12u l=0.13u
X2689 _186_.Y _185_.Y VPWR VPWR sg13_lv_pmos ad=0.2128p pd=1.5u as=0.3808p ps=2.92u w=1.12u l=0.15u
X2690 VGND VPWR VGND VGND sg13_lv_nmos ad=79.8f pd=0.8u as=0 ps=0 w=0.42u l=1u
X2691 a_12132_12528# a_12106_12433# VGND VGND sg13_lv_nmos ad=0.2516p pd=2.16u as=0.1626p ps=1.415u w=0.74u l=0.13u
X2692 VGND VPWR VGND VGND sg13_lv_nmos ad=0.1428p pd=1.52u as=0 ps=0 w=0.42u l=1u
X2693 VGND VPWR VGND VGND sg13_lv_nmos ad=0.1428p pd=1.52u as=0 ps=0 w=0.42u l=1u
X2694 VPWR VGND VPWR VPWR sg13_lv_pmos ad=0.34p pd=2.68u as=0 ps=0 w=1u l=1u
X2695 VPWR VGND VPWR VPWR sg13_lv_pmos ad=0.19p pd=1.38u as=0 ps=0 w=1u l=1u
X2696 VGND fanout6.A _206_.Y VGND sg13_lv_nmos ad=0.2516p pd=2.16u as=0.1406p ps=1.12u w=0.74u l=0.13u
X2697 a_5906_15242# _199_.B1 VGND VGND sg13_lv_nmos ad=0.1406p pd=1.12u as=0.2886p ps=2.26u w=0.74u l=0.13u
X2698 _247_.CLK a_3380_13690# VGND VGND sg13_lv_nmos ad=0.1406p pd=1.12u as=0.2516p ps=2.16u w=0.74u l=0.13u
X2699 _173_.A a_4362_9484# VGND VGND sg13_lv_nmos ad=0.2516p pd=2.16u as=0.1406p ps=1.12u w=0.74u l=0.13u
X2700 a_7908_16000# a_7882_15964# VGND VGND sg13_lv_nmos ad=0.2516p pd=2.16u as=0.1626p ps=1.415u w=0.74u l=0.13u
X2701 VGND _176_.A a_6485_11830# VGND sg13_lv_nmos ad=0.1898p pd=1.36u as=0.2516p ps=2.16u w=0.74u l=0.13u
X2702 VPWR VGND VPWR VPWR sg13_lv_pmos ad=0.34p pd=2.68u as=0 ps=0 w=1u l=1u
X2703 a_9586_16434# _258_.RESET_B VGND VGND sg13_lv_nmos ad=37.8f pd=0.6u as=79.8f ps=0.8u w=0.42u l=0.13u
X2704 VPWR VGND VPWR VPWR sg13_lv_pmos ad=0.34p pd=2.68u as=0 ps=0 w=1u l=1u
X2705 VPWR VGND VPWR VPWR sg13_lv_pmos ad=0.34p pd=2.68u as=0 ps=0 w=1u l=1u
X2706 VGND VPWR VGND VGND sg13_lv_nmos ad=79.8f pd=0.8u as=0 ps=0 w=0.42u l=1u
X2707 VPWR VGND VPWR VPWR sg13_lv_pmos ad=0.19p pd=1.38u as=0 ps=0 w=1u l=1u
X2708 VPWR a_15983_12287# a_16240_12430# VPWR sg13_lv_pmos ad=0.4659p pd=3.65u as=79.8f ps=0.8u w=0.42u l=0.13u
X2709 VGND a_2126_7864# _122_.X VGND sg13_lv_nmos ad=0.148p pd=1.14u as=0.4033p ps=2.57u w=0.74u l=0.13u
X2710 a_16396_11583# a_16336_11702# a_16281_11583# VPWR sg13_lv_pmos ad=0.204p pd=1.835u as=93.45f ps=0.865u w=0.42u l=0.13u
X2711 VGND VPWR VGND VGND sg13_lv_nmos ad=0.1428p pd=1.52u as=0 ps=0 w=0.42u l=1u
X2712 VGND VPWR VGND VGND sg13_lv_nmos ad=79.8f pd=0.8u as=0 ps=0 w=0.42u l=1u
X2713 VPWR a_10607_4727# a_11274_4948# VPWR sg13_lv_pmos ad=0.2128p pd=1.5u as=0.3864p ps=2.93u w=1.12u l=0.13u
X2714 VPWR VGND VPWR VPWR sg13_lv_pmos ad=0.34p pd=2.68u as=0 ps=0 w=1u l=1u
X2715 a_9083_9232# _164_.Y VGND VGND sg13_lv_nmos ad=78.39999f pd=0.885u as=0.2272p ps=1.99u w=0.64u l=0.13u
X2716 clkbuf_1_0__f_sclk.A a_3886_10702# VGND VGND sg13_lv_nmos ad=0.1406p pd=1.12u as=0.1406p ps=1.12u w=0.74u l=0.13u
X2717 VPWR VGND VPWR VPWR sg13_lv_pmos ad=0.19p pd=1.38u as=0 ps=0 w=1u l=1u
X2718 a_12886_13350# _128_.B1 VGND VGND sg13_lv_nmos ad=0.1406p pd=1.12u as=0.1406p ps=1.12u w=0.74u l=0.15u
X2719 VPWR VGND VPWR VPWR sg13_lv_pmos ad=0.19p pd=1.38u as=0 ps=0 w=1u l=1u
X2720 VGND VPWR VGND VGND sg13_lv_nmos ad=79.8f pd=0.8u as=0 ps=0 w=0.42u l=1u
X2721 a_12549_12189# _133_.B a_13009_12506# VPWR sg13_lv_pmos ad=0.4088p pd=2.97u as=0.41165p ps=2.12u w=1.12u l=0.13u
X2722 VPWR VGND VPWR VPWR sg13_lv_pmos ad=0.34p pd=2.68u as=0 ps=0 w=1u l=1u
X2723 a_14651_10996# _131_.B1 _131_.Y VPWR sg13_lv_pmos ad=0.2128p pd=1.5u as=0.3808p ps=2.92u w=1.12u l=0.13u
X2724 a_10732_14037# a_10672_13942# a_10617_14037# VPWR sg13_lv_pmos ad=0.204p pd=1.835u as=93.45f ps=0.865u w=0.42u l=0.13u
X2725 VGND VPWR VGND VGND sg13_lv_nmos ad=0.1428p pd=1.52u as=0 ps=0 w=0.42u l=1u
X2726 a_13505_8784# _145_.X _158_.Y VGND sg13_lv_nmos ad=0.1406p pd=1.12u as=0.1406p ps=1.12u w=0.74u l=0.13u
X2727 VPWR VGND VPWR VPWR sg13_lv_pmos ad=0.19p pd=1.38u as=0 ps=0 w=1u l=1u
X2728 VPWR a_2126_13912# _119_.X VPWR sg13_lv_pmos ad=0.2198p pd=1.52u as=0.6048p ps=3.32u w=1.12u l=0.13u
X2729 VPWR VGND VPWR VPWR sg13_lv_pmos ad=0.34p pd=2.68u as=0 ps=0 w=1u l=1u
X2730 a_6825_5041# a_6468_4968# VPWR VPWR sg13_lv_pmos ad=63f pd=0.72u as=0.1563p ps=1.22u w=0.42u l=0.13u
X2731 VPWR VGND VPWR VPWR sg13_lv_pmos ad=0.34p pd=2.68u as=0 ps=0 w=1u l=1u
X2732 a_3717_5423# _243_.CLK a_4177_5765# VGND sg13_lv_nmos ad=0.2516p pd=2.16u as=0.31732p ps=1.805u w=0.74u l=0.13u
X2733 a_8964_12210# _182_.Y a_8870_12210# VGND sg13_lv_nmos ad=60.89999f pd=0.71u as=0.1428p ps=1.52u w=0.42u l=0.13u
X2734 VGND VPWR VGND VGND sg13_lv_nmos ad=79.8f pd=0.8u as=0 ps=0 w=0.42u l=1u
X2735 VPWR _133_.Y _134_.Y VPWR sg13_lv_pmos ad=0.3808p pd=2.92u as=0.2128p ps=1.5u w=1.12u l=0.15u
X2736 VGND VPWR VGND VGND sg13_lv_nmos ad=0.1428p pd=1.52u as=0 ps=0 w=0.42u l=1u
X2737 VPWR VGND VPWR VPWR sg13_lv_pmos ad=0.34p pd=2.68u as=0 ps=0 w=1u l=1u
X2738 VPWR VGND VPWR VPWR sg13_lv_pmos ad=0.19p pd=1.38u as=0 ps=0 w=1u l=1u
X2739 a_4761_4965# a_3819_4772# a_4559_4727# VPWR sg13_lv_pmos ad=93.45f pd=0.865u as=0.2048p ps=1.63u w=0.42u l=0.13u
X2740 clkbuf_1_0__f_sclk.A a_3886_10702# VPWR VPWR sg13_lv_pmos ad=0.2128p pd=1.5u as=0.2128p ps=1.5u w=1.12u l=0.13u
X2741 VPWR _232_.Y a_8266_16969# VPWR sg13_lv_pmos ad=0.1563p pd=1.22u as=0.147p ps=1.54u w=0.42u l=0.13u
X2742 a_3695_8797# a_2853_8447# a_2436_8440# VPWR sg13_lv_pmos ad=0.2048p pd=1.63u as=0.34p ps=2.68u w=1u l=0.13u
X2743 clkbuf_1_0__f_sclk.A a_3886_10702# VGND VGND sg13_lv_nmos ad=0.1406p pd=1.12u as=0.1406p ps=1.12u w=0.74u l=0.13u
X2744 a_11698_17946# _240_.Y VGND VGND sg13_lv_nmos ad=37.8f pd=0.6u as=79.8f ps=0.8u w=0.42u l=0.13u
X2745 a_10715_7720# _166_.A VGND VGND sg13_lv_nmos ad=78.39999f pd=0.885u as=0.2272p ps=1.99u w=0.64u l=0.13u
X2746 VGND VPWR VGND VGND sg13_lv_nmos ad=0.1428p pd=1.52u as=0 ps=0 w=0.42u l=1u
X2747 VGND _131_.A2 a_13978_13342# VGND sg13_lv_nmos ad=0.2516p pd=2.16u as=0.1406p ps=1.12u w=0.74u l=0.13u
X2748 _170_.B _166_.A a_9466_7678# VGND sg13_lv_nmos ad=0.2516p pd=2.16u as=0.1406p ps=1.12u w=0.74u l=0.13u
X2749 a_14451_13320# _126_.B1 VGND VGND sg13_lv_nmos ad=0.1406p pd=1.12u as=0.2516p ps=2.16u w=0.74u l=0.13u
X2750 a_2558_7972# _122_.A0 a_2126_7864# VPWR sg13_lv_pmos ad=0.3325p pd=1.665u as=0.2225p ps=1.445u w=1u l=0.13u
X2751 a_3609_16119# a_2667_16007# a_3407_16357# VPWR sg13_lv_pmos ad=93.45f pd=0.865u as=0.2048p ps=1.63u w=0.42u l=0.13u
X2752 VPWR VGND VPWR VPWR sg13_lv_pmos ad=0.19p pd=1.38u as=0 ps=0 w=1u l=1u
X2753 VPWR VGND VPWR VPWR sg13_lv_pmos ad=0.34p pd=2.68u as=0 ps=0 w=1u l=1u
X2754 VGND VPWR VGND VGND sg13_lv_nmos ad=79.8f pd=0.8u as=0 ps=0 w=0.42u l=1u
X2755 VGND VPWR VGND VGND sg13_lv_nmos ad=0.1428p pd=1.52u as=0 ps=0 w=0.42u l=1u
X2756 a_4625_16800# _250_.Q VGND VGND sg13_lv_nmos ad=0.17462p pd=1.185u as=0.374p ps=2.46u w=0.55u l=0.13u
X2757 a_16498_9186# _260_.RESET_B VGND VGND sg13_lv_nmos ad=37.8f pd=0.6u as=79.8f ps=0.8u w=0.42u l=0.13u
X2758 clkbuf_1_0__f_sclk.A a_3886_10702# VPWR VPWR sg13_lv_pmos ad=0.2128p pd=1.5u as=0.2128p ps=1.5u w=1.12u l=0.13u
X2759 VPWR VGND VPWR VPWR sg13_lv_pmos ad=0.34p pd=2.68u as=0 ps=0 w=1u l=1u
X2760 VGND VPWR VGND VGND sg13_lv_nmos ad=79.8f pd=0.8u as=0 ps=0 w=0.42u l=1u
X2761 VGND VPWR VGND VGND sg13_lv_nmos ad=79.8f pd=0.8u as=0 ps=0 w=0.42u l=1u
X2762 VGND VPWR VGND VGND sg13_lv_nmos ad=0.1428p pd=1.52u as=0 ps=0 w=0.42u l=1u
X2763 a_16018_15234# _239_.Y VGND VGND sg13_lv_nmos ad=37.8f pd=0.6u as=79.8f ps=0.8u w=0.42u l=0.13u
X2764 VPWR VGND VPWR VPWR sg13_lv_pmos ad=0.34p pd=2.68u as=0 ps=0 w=1u l=1u
X2765 a_14724_12528# a_15243_12332# a_15983_12287# VGND sg13_lv_nmos ad=0.3473p pd=2.71u as=0.12665p ps=1.145u w=0.74u l=0.13u
X2766 VPWR VGND VPWR VPWR sg13_lv_pmos ad=0.34p pd=2.68u as=0 ps=0 w=1u l=1u
X2767 _199_.Y _195_.Y a_5427_15260# VGND sg13_lv_nmos ad=0.1406p pd=1.12u as=0.1406p ps=1.12u w=0.74u l=0.13u
X2768 a_2374_13397# _221_.Y VGND VGND sg13_lv_nmos ad=37.8f pd=0.6u as=0.1701p ps=1.65u w=0.42u l=0.13u
X2769 VPWR fanout8.A a_9352_17508# VPWR sg13_lv_pmos ad=0.2114p pd=1.54u as=0.2856p ps=2.36u w=0.84u l=0.13u
X2770 VGND VPWR VGND VGND sg13_lv_nmos ad=0.1428p pd=1.52u as=0 ps=0 w=0.42u l=1u
X2771 VGND VPWR VGND VGND sg13_lv_nmos ad=0.1428p pd=1.52u as=0 ps=0 w=0.42u l=1u
X2772 VPWR VGND VPWR VPWR sg13_lv_pmos ad=0.34p pd=2.68u as=0 ps=0 w=1u l=1u
X2773 VPWR VGND VPWR VPWR sg13_lv_pmos ad=0.19p pd=1.38u as=0 ps=0 w=1u l=1u
X2774 a_8325_16007# fanout7.A a_8785_16349# VGND sg13_lv_nmos ad=0.2516p pd=2.16u as=0.31732p ps=1.805u w=0.74u l=0.13u
X2775 a_2724_9199# a_2955_9308# a_2410_9409# VGND sg13_lv_nmos ad=0.2373p pd=1.97u as=79.8f ps=0.8u w=0.42u l=0.13u
X2776 a_2628_3904# a_2602_3868# VGND VGND sg13_lv_nmos ad=0.2516p pd=2.16u as=0.1626p ps=1.415u w=0.74u l=0.13u
X2777 VPWR VGND VPWR VPWR sg13_lv_pmos ad=0.34p pd=2.68u as=0 ps=0 w=1u l=1u
X2778 a_16336_11702# a_16079_11821# a_16498_11898# VGND sg13_lv_nmos ad=0.1428p pd=1.52u as=37.8f ps=0.6u w=0.42u l=0.13u
X2779 VGND VPWR VGND VGND sg13_lv_nmos ad=79.8f pd=0.8u as=0 ps=0 w=0.42u l=1u
X2780 VPWR a_16079_8797# a_16336_8678# VPWR sg13_lv_pmos ad=0.4659p pd=3.65u as=79.8f ps=0.8u w=0.42u l=0.13u
X2781 a_2232_15428# _124_.S VPWR VPWR sg13_lv_pmos ad=0.2856p pd=2.36u as=0.253p ps=1.53u w=0.84u l=0.13u
X2782 VPWR VGND VPWR VPWR sg13_lv_pmos ad=0.19p pd=1.38u as=0 ps=0 w=1u l=1u
X2783 a_15697_11462# a_15237_11471# a_15339_11471# VPWR sg13_lv_pmos ad=0.41165p pd=2.12u as=0.3864p ps=2.93u w=1.12u l=0.13u
X2784 VPWR VGND VPWR VPWR sg13_lv_pmos ad=0.34p pd=2.68u as=0 ps=0 w=1u l=1u
X2785 a_9369_16119# a_8427_16007# a_9167_16357# VPWR sg13_lv_pmos ad=93.45f pd=0.865u as=0.2048p ps=1.63u w=0.42u l=0.13u
X2786 VPWR VGND VPWR VPWR sg13_lv_pmos ad=0.34p pd=2.68u as=0 ps=0 w=1u l=1u
X2787 a_13366_13350# _126_.B1 VGND VGND sg13_lv_nmos ad=0.1406p pd=1.12u as=0.1406p ps=1.12u w=0.74u l=0.15u
X2788 VPWR VGND VPWR VPWR sg13_lv_pmos ad=0.34p pd=2.68u as=0 ps=0 w=1u l=1u
X2789 a_2512_4654# _243_.Q a_2398_4654# VGND sg13_lv_nmos ad=0.3367p pd=1.65u as=0.1628p ps=1.18u w=0.74u l=0.13u
X2790 _199_.Y _199_.B1 a_5333_15532# VPWR sg13_lv_pmos ad=0.3808p pd=2.92u as=0.2128p ps=1.5u w=1.12u l=0.13u
X2791 a_13391_12287# a_12549_12189# a_13297_12287# VGND sg13_lv_nmos ad=0.12665p pd=1.145u as=0.1428p ps=1.52u w=0.42u l=0.13u
X2792 VGND VPWR VGND VGND sg13_lv_nmos ad=0.1428p pd=1.52u as=0 ps=0 w=0.42u l=1u
X2793 _168_.B _136_.A a_5466_9202# VGND sg13_lv_nmos ad=0.1628p pd=1.18u as=88.8f ps=0.98u w=0.74u l=0.13u
X2794 a_3609_17061# a_2667_16868# a_3407_16823# VPWR sg13_lv_pmos ad=93.45f pd=0.865u as=0.2048p ps=1.63u w=0.42u l=0.13u
X2795 a_12623_16823# a_11781_16725# a_12529_16823# VGND sg13_lv_nmos ad=0.12665p pd=1.145u as=0.1428p ps=1.52u w=0.42u l=0.13u
X2796 VGND VPWR VGND VGND sg13_lv_nmos ad=79.8f pd=0.8u as=0 ps=0 w=0.42u l=1u
X2797 a_2122_16969# a_2565_16725# a_1862_16746# VGND sg13_lv_nmos ad=79.8f pd=0.8u as=0.1296p ps=1.52u w=0.42u l=0.13u
X2798 VGND VPWR VGND VGND sg13_lv_nmos ad=79.8f pd=0.8u as=0 ps=0 w=0.42u l=1u
X2799 a_2126_11726# _173_.A a_2298_11484# VPWR sg13_lv_pmos ad=0.2225p pd=1.445u as=0.2975p ps=1.595u w=1u l=0.13u
X2800 a_7258_8806# _136_.A VGND VGND sg13_lv_nmos ad=0.1406p pd=1.12u as=0.2516p ps=2.16u w=0.74u l=0.13u
X2801 VPWR a_15861_16904# a_14940_16710# VPWR sg13_lv_pmos ad=0.36237p pd=2.605u as=0.34p ps=2.68u w=1u l=0.13u
X2802 a_2436_16421# a_2667_16007# a_2122_15964# VGND sg13_lv_nmos ad=0.2373p pd=1.97u as=79.8f ps=0.8u w=0.42u l=0.13u
X2803 VPWR VGND VPWR VPWR sg13_lv_pmos ad=0.34p pd=2.68u as=0 ps=0 w=1u l=1u
X2804 VPWR _128_.B1 _129_.B1 VPWR sg13_lv_pmos ad=0.3808p pd=2.92u as=0.2128p ps=1.5u w=1.12u l=0.15u
X2805 VPWR VGND VPWR VPWR sg13_lv_pmos ad=0.34p pd=2.68u as=0 ps=0 w=1u l=1u
X2806 VPWR _173_.A a_5372_9484# VPWR sg13_lv_pmos ad=0.2128p pd=1.5u as=0.3808p ps=2.92u w=1.12u l=0.13u
X2807 VGND VPWR VGND VGND sg13_lv_nmos ad=79.8f pd=0.8u as=0 ps=0 w=0.42u l=1u
X2808 VGND a_3760_12430# a_3409_12287# VGND sg13_lv_nmos ad=79.8f pd=0.8u as=0.1428p ps=1.52u w=0.42u l=0.13u
X2809 VGND VPWR VGND VGND sg13_lv_nmos ad=79.8f pd=0.8u as=0 ps=0 w=0.42u l=1u
X2810 VPWR _124_.S a_2558_17532# VPWR sg13_lv_pmos ad=0.253p pd=1.53u as=0.3325p ps=1.665u w=1u l=0.13u
X2811 VPWR VGND VPWR VPWR sg13_lv_pmos ad=0.34p pd=2.68u as=0 ps=0 w=1u l=1u
X2812 a_3313_9482# a_2853_9165# a_2955_9308# VPWR sg13_lv_pmos ad=0.41165p pd=2.12u as=0.3864p ps=2.93u w=1.12u l=0.13u
X2813 VPWR VGND VPWR VPWR sg13_lv_pmos ad=0.34p pd=2.68u as=0 ps=0 w=1u l=1u
X2814 VGND _136_.A a_5242_8806# VGND sg13_lv_nmos ad=0.2516p pd=2.16u as=0.1406p ps=1.12u w=0.74u l=0.13u
X2815 a_8580_16759# a_8811_16868# a_8266_16969# VGND sg13_lv_nmos ad=0.2373p pd=1.97u as=79.8f ps=0.8u w=0.42u l=0.13u
X2816 VPWR a_3380_13690# _247_.CLK VPWR sg13_lv_pmos ad=0.2128p pd=1.5u as=0.2128p ps=1.5u w=1.12u l=0.13u
X2817 a_9636_4663# a_9867_4772# a_9322_4873# VGND sg13_lv_nmos ad=0.2373p pd=1.97u as=79.8f ps=0.8u w=0.42u l=0.13u
X2818 _124_.S a_1192_11460# VPWR VPWR sg13_lv_pmos ad=0.42p pd=2.99u as=0.2114p ps=1.54u w=1.12u l=0.13u
X2819 a_6468_4968# a_6442_4873# VPWR VPWR sg13_lv_pmos ad=0.34p pd=2.68u as=0.36237p ps=2.605u w=1u l=0.13u
X2820 VPWR VGND VPWR VPWR sg13_lv_pmos ad=0.34p pd=2.68u as=0 ps=0 w=1u l=1u
X2821 VGND _266_.CLK _212_.Y VGND sg13_lv_nmos ad=0.2516p pd=2.16u as=0.2516p ps=2.16u w=0.74u l=0.13u
X2822 VPWR VGND VPWR VPWR sg13_lv_pmos ad=0.34p pd=2.68u as=0 ps=0 w=1u l=1u
X2823 VPWR _222_.Y a_1862_16746# VPWR sg13_lv_pmos ad=0.36237p pd=2.605u as=79.8f ps=0.8u w=0.42u l=0.13u
X2824 a_14728_17061# _238_.Y a_14572_16746# VPWR sg13_lv_pmos ad=0.204p pd=1.835u as=79.8f ps=0.8u w=0.42u l=0.13u
X2825 VGND _124_.S a_2620_15238# VGND sg13_lv_nmos ad=0.18945p pd=1.27u as=0.13135p ps=1.095u w=0.74u l=0.13u
X2826 _242_.D a_2398_5782# VGND VGND sg13_lv_nmos ad=0.4033p pd=2.57u as=0.148p ps=1.14u w=0.74u l=0.13u
X2827 a_12110_8784# _145_.X a_11731_8698# VGND sg13_lv_nmos ad=81.6f pd=0.895u as=0.1216p ps=1.02u w=0.64u l=0.13u
X2828 a_14724_12528# a_14698_12433# VGND VGND sg13_lv_nmos ad=0.2516p pd=2.16u as=0.1626p ps=1.415u w=0.74u l=0.13u
X2829 VGND a_10769_4258# _139_.X VGND sg13_lv_nmos ad=0.3108p pd=2.32u as=0.1628p ps=1.18u w=0.74u l=0.13u
X2830 VGND VPWR VGND VGND sg13_lv_nmos ad=0.1428p pd=1.52u as=0 ps=0 w=0.42u l=1u
X2831 _168_.A a_11946_9484# VPWR VPWR sg13_lv_pmos ad=0.3808p pd=2.92u as=0.2128p ps=1.5u w=1.12u l=0.13u
X2832 _190_.A a_11082_14020# VPWR VPWR sg13_lv_pmos ad=0.3808p pd=2.92u as=0.2128p ps=1.5u w=1.12u l=0.13u
X2833 VGND VPWR VGND VGND sg13_lv_nmos ad=79.8f pd=0.8u as=0 ps=0 w=0.42u l=1u
X2834 a_14757_15213# _266_.CLK a_15217_15255# VGND sg13_lv_nmos ad=0.2516p pd=2.16u as=0.31732p ps=1.805u w=0.74u l=0.13u
X2835 a_5201_9240# _173_.A VGND VGND sg13_lv_nmos ad=0.17462p pd=1.185u as=0.374p ps=2.46u w=0.55u l=0.13u
X2836 VGND VPWR VGND VGND sg13_lv_nmos ad=0.1428p pd=1.52u as=0 ps=0 w=0.42u l=1u
X2837 VPWR VGND VPWR VPWR sg13_lv_pmos ad=0.34p pd=2.68u as=0 ps=0 w=1u l=1u
X2838 VGND VPWR VGND VGND sg13_lv_nmos ad=0.1428p pd=1.52u as=0 ps=0 w=0.42u l=1u
X2839 VPWR VGND VPWR VPWR sg13_lv_pmos ad=0.19p pd=1.38u as=0 ps=0 w=1u l=1u
X2840 VGND VPWR VGND VGND sg13_lv_nmos ad=0.1428p pd=1.52u as=0 ps=0 w=0.42u l=1u
X2841 VGND _260_.CLK _132_.Y VGND sg13_lv_nmos ad=0.2516p pd=2.16u as=0.1406p ps=1.12u w=0.74u l=0.13u
X2842 a_13092_16421# a_12804_16000# a_13030_16421# VGND sg13_lv_nmos ad=0.1428p pd=1.52u as=37.8f ps=0.6u w=0.42u l=0.13u
X2843 a_2436_13397# a_2148_12976# a_2374_13397# VGND sg13_lv_nmos ad=0.1428p pd=1.52u as=37.8f ps=0.6u w=0.42u l=0.13u
X2844 VPWR VGND VPWR VPWR sg13_lv_pmos ad=0.34p pd=2.68u as=0 ps=0 w=1u l=1u
X2845 VPWR VGND VPWR VPWR sg13_lv_pmos ad=0.34p pd=2.68u as=0 ps=0 w=1u l=1u
X2846 VPWR VGND VPWR VPWR sg13_lv_pmos ad=0.34p pd=2.68u as=0 ps=0 w=1u l=1u
X2847 a_9444_12223# a_9675_12332# a_9130_12433# VGND sg13_lv_nmos ad=0.2373p pd=1.97u as=79.8f ps=0.8u w=0.42u l=0.13u
X2848 _171_.Y a_8014_8492# VGND VGND sg13_lv_nmos ad=0.1406p pd=1.12u as=0.17255p ps=1.25u w=0.74u l=0.13u
X2849 a_2148_16000# a_2667_16007# a_3407_16357# VGND sg13_lv_nmos ad=0.3473p pd=2.71u as=0.12665p ps=1.145u w=0.74u l=0.13u
X2850 a_8196_16421# a_8427_16007# a_7882_15964# VGND sg13_lv_nmos ad=0.2373p pd=1.97u as=79.8f ps=0.8u w=0.42u l=0.13u
X2851 a_15141_12189# _133_.B a_15601_12506# VPWR sg13_lv_pmos ad=0.4088p pd=2.97u as=0.41165p ps=2.12u w=1.12u l=0.13u
C0 _166_.A _227_.Y 0.02709f
C1 a_12549_12189# _133_.Y 0.02571f
C2 _136_.A a_8386_3900# 0.01167f
C3 a_17120_7010# VPWR 0.05657f
C4 _180_.X _164_.Y 0.28608f
C5 _186_.Y a_8050_10326# 0.09703f
C6 a_14359_16710# a_14919_16964# 0.26905f
C7 _166_.A _154_.X 1.85317f
C8 _225_.A a_15339_11471# 0.01343f
C9 _133_.Y _129_.B1 0.08535f
C10 _243_.Q _243_.D 0.27111f
C11 _235_.Y a_16300_12525# 0.01227f
C12 a_6836_3900# _136_.B 0.01274f
C13 a_13184_8522# VPWR 0.0664f
C14 _145_.A2 a_8386_3900# 0.08282f
C15 _186_.Y _202_.Y 0.38077f
C16 fanout6.A a_4796_17044# 0.01505f
C17 _119_.A0 VPWR 1.38589f
C18 _243_.Q a_6810_3863# 0.01938f
C19 _194_.X _230_.Y 0.17984f
C20 _212_.Y _135_.X 0.0102f
C21 _158_.Y a_13505_8784# 0.01171f
C22 _178_.B1 _177_.X 0.05936f
C23 a_14794_9409# a_14820_9504# 0.36952f
C24 _131_.B1 a_14357_12972# 0.15794f
C25 a_8709_16725# a_9169_16767# 0.02396f
C26 a_4625_16800# a_4796_17044# 0.37141f
C27 _168_.B a_5372_9484# 0.09945f
C28 _138_.Y VPWR 0.67486f
C29 _143_.A _251_.CLK 0.02735f
C30 a_15071_17016# a_14919_16964# 0.47795f
C31 _210_.B a_6468_4968# 0.04991f
C32 a_2126_13912# a_2298_13726# 0.0308f
C33 _119_.X a_1864_13644# 0.01304f
C34 a_16266_15532# _133_.B 0.11571f
C35 a_3045_3911# _243_.RESET_B 0.03688f
C36 _250_.RESET_B _118_.X 0.0486f
C37 _191_.Y _205_.Y 0.20802f
C38 _147_.Y _148_.A 0.06593f
C39 a_3014_4650# a_3588_4663# 0.31978f
C40 a_14058_12508# VPWR 0.38225f
C41 _118_.A0 _118_.X 0.04134f
C42 a_13403_8436# VPWR 0.3118f
C43 _135_.A a_13221_16007# 0.01106f
C44 a_16650_5412# VPWR 0.38747f
C45 a_10940_3900# VPWR 0.20734f
C46 _119_.A0 a_3664_13214# 0.01301f
C47 _222_.A a_3313_16823# 0.0102f
C48 _119_.A0 _124_.S 0.36572f
C49 _165_.Y _170_.B 0.84177f
C50 a_12712_5498# VPWR 0.14634f
C51 _246_.D _219_.Y 0.19637f
C52 _178_.B1 _184_.Y 0.01771f
C53 _236_.A a_9994_17476# 0.01836f
C54 a_15339_9308# a_15697_9482# 0.02138f
C55 _118_.A0 a_2298_17878# 0.01667f
C56 a_6987_4772# a_7345_4946# 0.02138f
C57 a_14919_16964# a_15767_17137# 0.097f
C58 a_13297_12287# _133_.Y 0.01877f
C59 _174_.Y _178_.Y 0.03326f
C60 _160_.B _145_.X 0.19672f
C61 a_2853_8447# VPWR 0.23892f
C62 a_2171_6204# a_2048_6294# 0.01108f
C63 a_8292_17064# a_8811_16868# 0.34114f
C64 a_3887_4261# _243_.RESET_B 0.13317f
C65 _122_.X a_2150_8874# 0.26469f
C66 _143_.Y a_8386_3900# 0.10083f
C67 a_13413_11460# _133_.Y 0.02521f
C68 _215_.A _122_.X 0.14331f
C69 _160_.X a_10895_8436# 0.35785f
C70 a_4559_4727# a_4816_4870# 0.34468f
C71 _235_.Y VPWR 1.36245f
C72 _239_.Y a_14757_15213# 0.03527f
C73 _227_.Y _251_.CLK 0.13244f
C74 _119_.A0 a_4456_13402# 0.01005f
C75 _154_.X _251_.CLK 0.03779f
C76 a_13883_11460# VPWR 0.28486f
C77 _236_.Y a_14820_11464# 0.42886f
C78 _139_.X _147_.Y 0.02446f
C79 a_13376_4782# _145_.X 0.01549f
C80 _214_.A a_11078_16746# 0.03512f
C81 a_14820_9504# a_15108_9199# 0.43707f
C82 _166_.A _251_.CLK 0.18238f
C83 _192_.C VPWR 0.61725f
C84 a_6182_4650# a_6756_4663# 0.31978f
C85 a_15767_17137# _211_.Y 0.27964f
C86 a_14724_12528# _131_.A2 0.01549f
C87 a_15339_11471# _260_.CLK 0.04788f
C88 a_2075_5468# _125_.A1 0.118f
C89 a_14534_9186# _251_.CLK 0.01384f
C90 a_4362_8436# VPWR 0.38461f
C91 a_9734_17946# a_9994_17476# 0.75507f
C92 _226_.Y a_15983_5773# 0.13297f
C93 a_2232_7868# _148_.A 0.10806f
C94 _209_.Y _232_.Y 0.1539f
C95 a_4559_4727# a_4465_4727# 0.28931f
C96 _239_.Y a_15599_15311# 0.13299f
C97 a_16746_9484# fanout7.A 0.18367f
C98 _219_.Y a_2853_9165# 0.03432f
C99 _230_.Y VPWR 1.46725f
C100 a_16746_11460# VPWR 0.38147f
C101 a_17120_6294# VPWR 0.0853f
C102 _225_.A a_14730_15996# 0.01623f
C103 a_9130_13945# a_9156_14040# 0.36952f
C104 a_7882_15964# _258_.RESET_B 0.24701f
C105 a_11661_4696# VPWR 0.38678f
C106 a_7727_4727# a_8394_4948# 0.0894f
C107 a_7984_4870# a_8044_4965# 0.01042f
C108 _215_.A en 0.0149f
C109 a_4362_9484# a_4744_9318# 0.01012f
C110 a_8870_12210# a_9675_12332# 0.097f
C111 a_9156_12528# a_9573_12189# 0.3749f
C112 _210_.B _243_.Q 0.04072f
C113 _236_.A _194_.X 0.12252f
C114 _170_.B _171_.A 0.0336f
C115 a_5265_12532# VPWR 0.01064f
C116 _145_.X a_11731_8698# 0.01425f
C117 _133_.B a_12132_12528# 0.08627f
C118 a_2628_3904# _243_.CLK 0.09056f
C119 _266_.CLK a_12416_16082# 0.01949f
C120 a_10764_5678# _148_.A 0.01534f
C121 _181_.Y a_8352_11013# 0.3541f
C122 a_9675_13844# a_10033_14018# 0.02138f
C123 _171_.Y a_8488_8436# 0.05104f
C124 a_8427_16007# _258_.RESET_B 0.42191f
C125 a_6095_4270# _210_.Y 0.06183f
C126 _129_.Y _131_.B1 0.04639f
C127 a_11883_16868# VPWR 0.18187f
C128 a_13184_7183# _160_.X 0.10381f
C129 _147_.A1 _243_.Q 0.08914f
C130 a_8014_8492# VPWR 0.19295f
C131 fanout6.A a_8325_16007# 0.01542f
C132 _148_.B a_12132_12528# 0.05091f
C133 a_9734_17946# a_10308_17933# 0.31978f
C134 _232_.Y a_9868_17061# 0.01229f
C135 a_12215_7664# _164_.B1 0.13802f
C136 _165_.Y a_7258_8806# 0.01809f
C137 a_14820_11464# a_15108_11885# 0.43707f
C138 a_2232_15428# a_2298_15532# 0.03308f
C139 a_8352_11013# VPWR 0.23735f
C140 _225_.A fanout7.A 0.03823f
C141 a_6720_17061# _209_.Y 0.21346f
C142 a_6286_15276# VPWR 0.19438f
C143 a_8870_13722# a_9444_13735# 0.31978f
C144 a_8785_15998# _258_.RESET_B 0.01491f
C145 _173_.A a_2150_9186# 0.03636f
C146 _148_.B a_13100_13686# 0.24484f
C147 a_10764_5678# _139_.X 0.33124f
C148 a_2150_9186# VPWR 0.77808f
C149 _225_.A a_10437_17519# 0.0173f
C150 _234_.Y a_12106_12433# 0.26218f
C151 fanout6.A a_9167_16357# 0.01486f
C152 a_10020_17512# a_11279_17869# 0.01529f
C153 _152_.X VPWR 0.31074f
C154 fanout6.A a_13100_13686# 0.26029f
C155 _238_.Y a_14919_16964# 0.42266f
C156 a_1864_6294# _215_.A 0.01103f
C157 a_15237_11471# a_15985_11821# 0.01058f
C158 _136_.A clkbuf_1_0__f_sclk.A 0.1256f
C159 _225_.A _180_.X 0.04319f
C160 a_7908_16000# a_8325_16007# 0.37583f
C161 a_14651_10996# VPWR 0.28495f
C162 a_7622_16434# a_8196_16421# 0.31978f
C163 a_7008_16035# VPWR 0.23754f
C164 _186_.Y _185_.Y 0.20977f
C165 _147_.A1 a_11381_3900# 0.03296f
C166 _120_.A0 sclk 0.0288f
C167 a_3014_4650# VPWR 0.79761f
C168 a_7074_15532# VPWR 0.15379f
C169 _202_.Y _203_.Y 0.20233f
C170 a_8557_4248# _136_.B 0.02872f
C171 a_10415_13799# a_11082_14020# 0.0894f
C172 a_10672_13942# a_10732_14037# 0.01042f
C173 a_9444_12223# a_8870_12210# 0.31978f
C174 a_8156_7972# VPWR 0.20685f
C175 _124_.S a_2150_9186# 0.03844f
C176 a_11846_12210# a_12132_12528# 0.41329f
C177 _145_.A2 _225_.Y 0.02084f
C178 a_2122_15964# a_2148_16000# 0.36952f
C179 _236_.A VPWR 3.37748f
C180 _238_.Y _211_.Y 0.42461f
C181 a_14794_9409# VPWR 0.09631f
C182 _232_.Y a_9169_17042# 0.01494f
C183 _173_.A a_2232_10210# 0.03957f
C184 a_7908_16000# a_9167_16357# 0.01529f
C185 a_2232_10210# VPWR 0.89773f
C186 a_14438_5850# a_15141_5423# 0.02432f
C187 _164_.B1 a_11974_8436# 0.07661f
C188 _250_.Q _247_.CLK 0.03272f
C189 a_12992_15437# VPWR 0.41034f
C190 _250_.Q a_4074_15996# 0.11571f
C191 _131_.Y _260_.CLK 0.15044f
C192 _133_.B a_15339_11471# 0.02814f
C193 a_14724_12528# a_15243_12332# 0.34114f
C194 a_15339_9308# _260_.CLK 0.03438f
C195 a_13775_5782# _149_.A 0.01312f
C196 a_8292_17064# VPWR 0.07154f
C197 a_11338_16969# a_11364_17064# 0.36952f
C198 _241_.Y a_11078_16746# 0.08612f
C199 a_10220_18222# _225_.A 0.26553f
C200 _243_.RESET_B _215_.Y 0.01979f
C201 _222_.A _207_.A1 0.06154f
C202 a_12778_15964# a_12804_16000# 0.36952f
C203 _225_.A a_10539_17519# 0.02799f
C204 a_2565_16725# a_2565_16007# 0.03306f
C205 a_8603_9484# _148_.B 0.02807f
C206 a_2565_16007# a_2667_16007# 0.47795f
C207 a_10539_17519# a_11536_17750# 0.03061f
C208 _154_.X a_9248_7806# 0.0197f
C209 _193_.Y a_7451_14484# 0.1039f
C210 a_16396_8559# _227_.Y 0.01227f
C211 _124_.S a_2232_10210# 0.17205f
C212 fanout7.A _260_.CLK 0.20299f
C213 _210_.B a_6442_4873# 0.02277f
C214 a_9424_16238# a_9167_16357# 0.34468f
C215 _240_.Y a_10020_17512# 0.37775f
C216 _136_.A a_5201_9240# 0.3001f
C217 a_9734_17946# VPWR 0.77415f
C218 a_5226_4948# VPWR 0.38269f
C219 _176_.A a_9573_12189# 0.02192f
C220 _209_.Y a_7328_16878# 0.01127f
C221 a_8501_10702# _182_.Y 0.0358f
C222 a_15243_12332# a_15983_12287# 0.26905f
C223 _180_.X a_11279_9263# 0.02497f
C224 a_14820_11464# _131_.A2 0.01698f
C225 _132_.Y _126_.B1 0.02336f
C226 _230_.Y a_8870_13722# 0.13828f
C227 _136_.A _224_.Y 0.01807f
C228 a_2667_16868# a_3025_17042# 0.02138f
C229 a_1952_7806# _122_.X 0.01442f
C230 a_2565_16725# _247_.CLK 0.25404f
C231 a_13221_16007# a_13681_16349# 0.02396f
C232 _247_.CLK a_2667_16007# 0.03887f
C233 a_12549_12189# a_12420_12223# 0.01562f
C234 a_3664_16238# a_3407_16357# 0.34468f
C235 a_2565_16007# a_3025_15998# 0.01483f
C236 _173_.Y a_6528_8475# 0.02869f
C237 a_9834_15996# _207_.A1 0.11685f
C238 a_5376_17061# VPWR 0.22771f
C239 a_16746_9484# a_17120_9318# 0.01061f
C240 a_11946_9484# _251_.CLK 0.01157f
C241 a_12572_4948# VPWR 0.20766f
C242 a_5608_4782# VPWR 0.13133f
C243 a_2232_13916# _120_.A0 0.10741f
C244 _222_.A _222_.Y 0.30983f
C245 a_15141_12189# a_15889_12287# 0.01058f
C246 _147_.A1 _147_.B1 0.05618f
C247 a_2398_5782# _242_.D 0.20278f
C248 a_2628_3904# a_3045_3911# 0.37583f
C249 a_2342_4338# a_2916_4325# 0.31978f
C250 a_15237_9165# _260_.RESET_B 0.03432f
C251 a_14698_12433# _131_.B1 0.01443f
C252 a_8538_5375# _144_.B 0.31036f
C253 a_6336_11499# a_6485_11830# 0.33493f
C254 _148_.B _179_.Y 0.67063f
C255 _187_.Y _176_.A 0.03491f
C256 a_15983_5773# a_15889_5773# 0.28931f
C257 a_13073_7728# _153_.Y 0.08153f
C258 a_14056_9318# _251_.CLK 0.03205f
C259 fanout6.A _201_.Y 0.08f
C260 _236_.Y a_16336_11702# 0.09868f
C261 a_2126_7864# _148_.A 0.50675f
C262 a_10437_9165# a_10539_9308# 0.47622f
C263 a_14724_12528# VPWR 0.07169f
C264 a_7953_14044# VPWR 0.01063f
C265 a_6389_9484# _173_.Y 0.05061f
C266 _157_.Y VPWR 0.61663f
C267 a_2628_3904# a_3887_4261# 0.01529f
C268 a_4462_16052# _206_.Y 0.24955f
C269 a_16336_9406# _260_.RESET_B 0.10165f
C270 a_14534_8874# a_14820_8440# 0.41329f
C271 _168_.A _122_.A0 0.0404f
C272 a_15141_5423# VPWR 0.25959f
C273 _144_.B a_9348_4968# 0.06388f
C274 _173_.A _219_.Y 0.03713f
C275 a_2661_12189# a_2763_12332# 0.47622f
C276 _203_.Y _258_.RESET_B 0.0912f
C277 _243_.Q a_11274_4948# 0.0151f
C278 _219_.Y VPWR 1.41541f
C279 _148_.B a_8501_10702# 0.01263f
C280 a_12416_16082# VPWR 0.08255f
C281 _173_.A a_2298_11484# 0.01192f
C282 a_2232_11722# a_2558_11484# 0.02726f
C283 a_2150_8874# a_2955_8447# 0.097f
C284 a_11946_17508# VPWR 0.38499f
C285 a_6485_11830# _176_.A 0.01513f
C286 _181_.Y _183_.Y 0.06152f
C287 a_9130_12433# a_9573_12189# 0.02242f
C288 a_2342_4338# _243_.D 0.27171f
C289 _157_.B _157_.Y 0.78712f
C290 a_2126_10214# a_2298_10318# 0.0308f
C291 a_3952_9406# a_4012_9501# 0.01042f
C292 a_3695_9263# a_4362_9484# 0.0894f
C293 a_15983_12287# VPWR 0.17176f
C294 _147_.Y _148_.B 0.02373f
C295 a_2148_12976# _247_.CLK 0.09499f
C296 fanout6.A a_10218_17044# 0.12283f
C297 _215_.A _243_.RESET_B 0.18499f
C298 a_4144_4142# a_3887_4261# 0.34468f
C299 _205_.Y _199_.B1 0.05665f
C300 _206_.Y a_4684_15996# 0.01308f
C301 _215_.Y a_4177_4946# 0.01491f
C302 a_9348_4968# a_9765_4629# 0.3749f
C303 _234_.Y _176_.A 0.01493f
C304 a_9062_4650# a_9867_4772# 0.097f
C305 a_15237_8447# a_15108_8861# 0.01562f
C306 a_14820_8440# a_15697_8789# 0.01835f
C307 _120_.A0 a_2565_12983# 0.0114f
C308 _210_.A a_2075_5468# 0.03593f
C309 _124_.S _219_.Y 0.01283f
C310 fanout8.A _119_.X 0.09293f
C311 a_2763_12332# a_3760_12430# 0.02979f
C312 _247_.CLK _220_.Y 0.027f
C313 _250_.D _222_.A 0.03989f
C314 _250_.Q a_4796_17044# 0.01008f
C315 a_1580_16710# VPWR 0.27993f
C316 a_2436_8440# a_3601_8797# 0.43239f
C317 _183_.Y VPWR 0.45474f
C318 fanout8.A fanout6.A 0.03136f
C319 _148_.B a_12106_12433# 0.02883f
C320 _181_.Y a_8050_10326# 0.01125f
C321 _234_.Y _133_.Y 0.01781f
C322 a_10020_9504# a_11185_9263# 0.43239f
C323 a_10437_9165# a_10897_9207# 0.02396f
C324 a_1862_16746# a_2436_16759# 0.31978f
C325 _226_.Y a_14724_5416# 0.37236f
C326 _186_.Y _164_.Y 0.0188f
C327 _215_.Y a_4559_4727# 0.13292f
C328 a_15339_8447# a_16336_8678# 0.03061f
C329 _133_.B fanout7.A 0.33008f
C330 _168_.A _251_.CLK 2.03334f
C331 _136_.A _173_.A 0.60453f
C332 _225_.A a_14534_11898# 0.04327f
C333 a_2075_4692# a_2398_4654# 0.43036f
C334 a_3760_12430# a_3820_12525# 0.01042f
C335 a_3503_12287# a_4170_12508# 0.0894f
C336 _160_.B a_13244_7972# 0.1f
C337 _148_.A a_2171_6204# 0.04686f
C338 a_2661_12189# a_3409_12287# 0.01058f
C339 _136_.A VPWR 2.38161f
C340 _237_.Y a_13221_16007# 0.03579f
C341 a_3695_8797# a_3601_8797# 0.28931f
C342 a_8050_10326# VPWR 0.01055f
C343 a_6958_13764# a_6760_13854# 0.01393f
C344 a_15141_12189# a_15237_11471# 0.02468f
C345 _143_.A a_8021_5782# 0.01137f
C346 _225_.A a_14859_15356# 0.06609f
C347 a_2126_11726# _173_.A 0.50003f
C348 _222_.A _203_.Y 0.01055f
C349 a_1862_13410# a_2122_12940# 0.75507f
C350 a_2126_17774# _118_.A0 0.49213f
C351 _145_.A2 VPWR 0.63517f
C352 _148_.B fanout7.A 0.0935f
C353 a_1862_13410# VPWR 0.77701f
C354 a_2126_11726# VPWR 0.10988f
C355 _162_.B _153_.Y 0.47806f
C356 _170_.B a_8488_8436# 0.01036f
C357 a_9120_9501# _164_.Y 0.14169f
C358 _133_.Y _260_.CLK 0.01542f
C359 _190_.A _192_.B 0.02512f
C360 _131_.A2 _129_.B1 0.28175f
C361 _202_.Y VPWR 0.45232f
C362 fanout6.A fanout7.A 1.4206f
C363 a_9348_4968# a_9636_4663# 0.43707f
C364 a_10607_4727# a_10864_4870# 0.34468f
C365 _160_.B a_13973_7678# 0.02051f
C366 _250_.RESET_B rst 0.01225f
C367 a_14432_10830# _131_.B1 0.01743f
C368 a_16079_11821# a_15985_11821# 0.28931f
C369 a_9675_13844# fanout7.A 0.04751f
C370 _190_.A a_9156_14040# 0.01198f
C371 _160_.B _151_.B 0.44454f
C372 _192_.Y a_6760_13854# 0.03196f
C373 _147_.A1 _251_.CLK 0.03489f
C374 a_12106_12433# a_11846_12210# 0.75507f
C375 _178_.B1 _178_.Y 0.44322f
C376 _252_.D a_7727_4727# 0.01045f
C377 _180_.X _148_.B 0.15982f
C378 a_2148_12976# a_2436_13397# 0.43707f
C379 _124_.S a_1862_13410# 0.03218f
C380 a_2126_11726# _124_.S 0.1538f
C381 a_13648_12430# _131_.A2 0.02591f
C382 a_5147_15996# _207_.A1 0.04127f
C383 _207_.Y _207_.A1 0.10877f
C384 _192_.Y _187_.Y 0.84145f
C385 _179_.Y _177_.X 0.22622f
C386 _118_.A0 a_1862_16746# 0.0326f
C387 _118_.A0 a_2436_16421# 0.01341f
C388 a_5297_12264# a_5468_12508# 0.37141f
C389 a_7908_16000# fanout7.A 0.09504f
C390 _196_.Y VPWR 0.78182f
C391 a_12712_5498# _152_.X 0.03551f
C392 _143_.Y VPWR 0.4408f
C393 _214_.A a_11338_16969# 0.02178f
C394 a_10672_13942# fanout7.A 0.01626f
C395 _207_.A2 _199_.B1 0.0604f
C396 _170_.B _154_.X 0.18524f
C397 a_2565_12983# a_3313_13333# 0.01058f
C398 a_15071_17016# a_15722_16904# 0.01562f
C399 _170_.B _166_.A 0.19222f
C400 _172_.Y _164_.Y 0.0408f
C401 _148_.B a_4744_15366# 0.01664f
C402 _218_.Y a_2150_8874# 0.13954f
C403 a_17032_15366# VPWR 0.15332f
C404 _144_.Y a_8386_3900# 0.05674f
C405 _215_.A _218_.Y 0.14446f
C406 _126_.B1 _131_.B1 0.01652f
C407 fanout8.A _215_.A 0.27594f
C408 _179_.Y _184_.Y 0.01523f
C409 _228_.Y a_10897_9482# 0.01491f
C410 a_14314_15457# VPWR 0.09587f
C411 a_6970_12214# _192_.B 0.01548f
C412 a_14534_11898# _260_.CLK 0.02966f
C413 _160_.B a_13321_7272# 0.01001f
C414 _207_.A1 a_8266_16969# 0.01617f
C415 _170_.B _122_.A0 0.03848f
C416 a_9424_16238# fanout7.A 0.01921f
C417 a_14438_5850# _149_.A 0.02555f
C418 _168_.Y a_7520_9318# 0.01669f
C419 _227_.Y a_15237_8447# 0.03468f
C420 _191_.Y _193_.Y 0.24471f
C421 fanout6.A a_12778_15964# 0.02328f
C422 a_2667_12983# a_3025_12974# 0.02138f
C423 a_14820_11464# VPWR 0.07192f
C424 a_14940_16710# a_14830_16746# 0.43239f
C425 a_15767_17137# a_15722_16904# 0.31978f
C426 _236_.A _235_.Y 0.20974f
C427 _189_.X _190_.A 0.65984f
C428 _166_.A a_15237_8447# 0.01348f
C429 _122_.A0 a_2436_8440# 0.0725f
C430 _160_.X _157_.Y 0.45554f
C431 _229_.Y a_9156_12528# 0.39823f
C432 _215_.A a_4559_4727# 0.02215f
C433 _228_.Y a_11536_9406# 0.10165f
C434 a_4559_5773# VPWR 0.18455f
C435 _119_.X a_2232_13916# 0.0119f
C436 a_2126_13912# _120_.A0 0.49904f
C437 _168_.A _171_.Y 1.1238f
C438 a_13019_6460# _148_.X 0.08274f
C439 a_3274_5380# a_3300_5416# 0.36952f
C440 a_11781_16725# a_12241_17042# 0.01483f
C441 _168_.A a_11946_9484# 0.13333f
C442 a_13184_7183# _157_.Y 0.01135f
C443 _225_.Y a_9867_4772# 0.42117f
C444 _215_.A sclk 0.04419f
C445 a_4744_9318# a_4928_9318# 0.0524f
C446 _166_.A a_16746_8436# 0.12681f
C447 _122_.A0 a_3695_8797# 0.02143f
C448 a_2232_10210# a_2558_9972# 0.02726f
C449 _122_.A0 a_2298_9972# 0.01051f
C450 a_2126_15424# a_2620_15238# 0.01625f
C451 _236_.A _230_.Y 0.09202f
C452 a_6747_5468# VPWR 0.2864f
C453 a_2724_9199# a_2853_9165# 0.01562f
C454 _222_.A a_2148_17064# 0.03071f
C455 fanout6.A a_4462_16052# 0.06553f
C456 a_13649_4704# _145_.X 0.11398f
C457 _166_.A _164_.B1 0.0589f
C458 a_14314_15457# a_14340_15552# 0.36952f
C459 a_3717_5423# a_3588_5837# 0.01562f
C460 a_3300_5416# a_4177_5765# 0.01835f
C461 a_15983_5773# _251_.CLK 0.0121f
C462 a_7736_8802# _170_.Y 0.01426f
C463 _225_.Y a_10924_4965# 0.01229f
C464 _161_.Y VPWR 0.51007f
C465 _225_.A _236_.Y 0.70538f
C466 _215_.Y a_2075_4692# 0.11416f
C467 _205_.Y _208_.X 0.4737f
C468 a_14438_12210# _131_.B1 0.02875f
C469 _258_.RESET_B VPWR 1.3752f
C470 _210_.B a_6810_3863# 0.22507f
C471 _148_.B _176_.A 1.61246f
C472 _133_.B _133_.Y 0.3622f
C473 _252_.D a_9062_4650# 0.26006f
C474 _157_.Y a_13184_8522# 0.01923f
C475 a_12549_7996# _153_.Y 0.01304f
C476 a_2048_6294# VPWR 0.06687f
C477 a_1580_12936# VPWR 0.28112f
C478 _148_.B _133_.Y 0.02662f
C479 a_14859_15356# a_15217_15530# 0.02138f
C480 a_15237_8447# _251_.CLK 0.28978f
C481 a_12880_16966# a_13290_17044# 0.10373f
C482 a_2410_9409# a_2436_9504# 0.36952f
C483 a_11781_16725# a_12529_16823# 0.01058f
C484 _210_.A a_4559_4727# 0.01497f
C485 _225_.A _207_.A1 0.04581f
C486 _191_.Y a_6862_15532# 0.0116f
C487 a_9928_8522# VPWR 0.16108f
C488 _157_.Y a_13403_8436# 0.01024f
C489 a_8394_4948# VPWR 0.38188f
C490 _185_.Y VPWR 0.25192f
C491 a_14724_5416# a_15889_5773# 0.43239f
C492 _221_.Y a_2667_12983# 0.42104f
C493 a_2048_6294# _124_.S 0.0127f
C494 _149_.A VPWR 0.8477f
C495 _135_.A fanout7.A 0.02728f
C496 _225_.A a_14534_8874# 0.04398f
C497 a_12328_7010# VPWR 0.1466f
C498 a_13073_5770# a_13244_5412# 0.37141f
C499 a_14054_15234# a_14628_15247# 0.31978f
C500 a_4559_5773# a_4465_5773# 0.28931f
C501 a_2955_9308# a_3313_9482# 0.02138f
C502 a_2853_9165# _243_.CLK 0.25564f
C503 _235_.Y a_14724_12528# 0.39374f
C504 a_14698_12433# a_15141_12189# 0.02242f
C505 a_14063_16357# a_14730_15996# 0.0894f
C506 a_3274_4873# a_3300_4968# 0.36952f
C507 a_5376_17061# a_5525_16750# 0.33493f
C508 a_11338_16969# _241_.Y 0.23769f
C509 _157_.B _149_.A 0.09131f
C510 _147_.Y _148_.X 0.3049f
C511 a_12886_13350# VPWR 0.01456f
C512 _222_.Y a_2148_16000# 0.01109f
C513 _122_.A0 a_2410_9409# 0.02655f
C514 _243_.Q a_4554_3900# 0.14282f
C515 _243_.CLK a_3717_4629# 0.28546f
C516 _222_.A VPWR 0.88119f
C517 _221_.Y a_3025_12974# 0.01491f
C518 _134_.Y _128_.B1 0.02789f
C519 a_3592_10830# sclk 0.02389f
C520 _120_.A0 a_2244_12528# 0.06206f
C521 _206_.Y _207_.A1 0.06392f
C522 a_9352_17508# VPWR 0.25066f
C523 a_15856_15454# a_15916_15549# 0.01042f
C524 a_15599_15311# a_16266_15532# 0.0894f
C525 a_14240_16921# a_14572_16746# 0.10373f
C526 clkbuf_1_0__f_sclk.A _243_.CLK 0.01015f
C527 _225_.A a_15108_11885# 0.01597f
C528 _176_.A _229_.Y 0.08043f
C529 a_11082_14020# VPWR 0.3836f
C530 _168_.B a_6528_8475# 0.32484f
C531 _236_.Y _260_.CLK 0.12039f
C532 _235_.Y a_15983_12287# 0.13292f
C533 a_3819_4772# a_4177_4946# 0.02138f
C534 _148_.B a_4913_13330# 0.35252f
C535 a_12549_12189# VPWR 0.23823f
C536 _136_.A _138_.Y 0.11204f
C537 a_13464_12952# VPWR 0.01765f
C538 _129_.B1 VPWR 0.47751f
C539 a_1864_15366# VPWR 0.15006f
C540 _212_.Y a_11944_16082# 0.02581f
C541 _193_.Y a_8156_14020# 0.02549f
C542 _222_.Y a_3025_17042# 0.01491f
C543 _118_.A0 _250_.RESET_B 0.05522f
C544 _124_.S _222_.A 0.02816f
C545 _120_.A0 a_3503_12287# 0.02139f
C546 _207_.A2 _208_.X 0.08251f
C547 _191_.Y _190_.A 0.23373f
C548 _145_.A2 _138_.Y 0.03972f
C549 a_8709_16725# a_8580_16759# 0.01562f
C550 a_12328_8522# a_12512_8522# 0.0524f
C551 _136_.A a_10940_3900# 0.02046f
C552 a_7872_5451# VPWR 0.24938f
C553 a_15071_17016# a_15389_17042# 0.01483f
C554 a_14728_17061# a_14572_16746# 0.01042f
C555 a_9834_15996# VPWR 0.38364f
C556 a_2602_3868# _243_.RESET_B 0.25722f
C557 _170_.B _171_.Y 0.0581f
C558 a_2126_10214# _122_.A0 0.50171f
C559 a_3819_4772# a_4559_4727# 0.26905f
C560 a_13648_12430# VPWR 0.16007f
C561 a_2398_5782# VPWR 0.11388f
C562 a_16240_5654# VPWR 0.16817f
C563 _242_.D a_2398_4654# 0.01269f
C564 _243_.CLK a_3588_4663# 0.0214f
C565 a_13073_5770# VPWR 0.2183f
C566 _236_.A a_9734_17946# 0.03378f
C567 a_15237_9165# a_15339_9308# 0.47622f
C568 _187_.Y _176_.B 0.17681f
C569 a_6885_4629# a_6987_4772# 0.47622f
C570 a_15071_17016# a_15861_16904# 0.02242f
C571 a_14919_16964# a_14940_16710# 0.34102f
C572 _148_.B _192_.Y 0.01194f
C573 a_2171_6204# a_2494_6166# 0.43036f
C574 a_3147_3911# _243_.RESET_B 0.42251f
C575 a_2410_8404# VPWR 0.09796f
C576 a_8006_16746# a_8709_16725# 0.02454f
C577 _148_.B a_12328_8522# 0.01593f
C578 a_6862_15532# _205_.Y 0.42548f
C579 _119_.A0 _196_.Y 0.03677f
C580 _250_.Q a_4074_17044# 0.03837f
C581 a_3717_4629# a_4465_4727# 0.01058f
C582 a_2398_5782# _124_.S 0.15583f
C583 _250_.D a_2148_16000# 0.02577f
C584 _239_.Y a_14054_15234# 0.12159f
C585 _157_.B a_13073_5770# 0.34885f
C586 a_14820_8440# VPWR 0.07175f
C587 _148_.A _225_.Y 0.0613f
C588 a_13413_11460# VPWR 0.01352f
C589 _138_.Y _143_.Y 0.03604f
C590 _184_.Y a_7157_9948# 0.09865f
C591 _252_.D _225_.Y 0.4542f
C592 a_15339_9308# a_16336_9406# 0.02979f
C593 _220_.Y a_2763_12332# 0.42048f
C594 a_9867_4772# VPWR 0.18691f
C595 a_6048_13011# VPWR 0.24746f
C596 a_6987_4772# a_7727_4727# 0.26905f
C597 _199_.Y _191_.Y 0.03472f
C598 a_14940_16710# _211_.Y 0.01288f
C599 a_15767_17137# a_15861_16904# 0.75507f
C600 _124_.S a_2410_8404# 0.02867f
C601 a_3952_8678# VPWR 0.17225f
C602 a_3505_3902# _243_.RESET_B 0.01494f
C603 _226_.Y a_15243_5423# 0.42392f
C604 a_6485_11830# _176_.B 0.02636f
C605 fanout8.A _250_.Q 0.02466f
C606 _186_.Y a_8156_9928# 0.01075f
C607 _160_.X _161_.Y 0.01074f
C608 _229_.Y a_9130_12433# 0.26443f
C609 a_2126_13912# _119_.X 0.20795f
C610 _136_.A a_11661_4696# 0.26796f
C611 a_16079_8797# VPWR 0.17097f
C612 a_3274_5380# _215_.A 0.01229f
C613 _200_.Y fanout6.A 0.01625f
C614 a_16336_9406# fanout7.A 0.01305f
C615 a_4170_12508# VPWR 0.3861f
C616 _219_.Y a_2150_9186# 0.13983f
C617 _152_.X _157_.Y 0.36576f
C618 a_7616_15437# VPWR 0.40941f
C619 a_16336_11702# VPWR 0.15836f
C620 _225_.A _131_.A2 0.04163f
C621 _168_.A _174_.Y 1.10305f
C622 a_13323_16007# a_13221_16007# 0.47795f
C623 _210_.A a_2075_4692# 0.14354f
C624 a_16336_9406# a_16396_9501# 0.01042f
C625 a_16079_9263# a_16746_9484# 0.0894f
C626 a_7622_16434# _258_.RESET_B 0.09254f
C627 _220_.Y a_3820_12525# 0.01227f
C628 a_7727_4727# a_7984_4870# 0.34468f
C629 a_6885_4629# a_7633_4727# 0.01058f
C630 _186_.Y a_7985_13776# 0.09568f
C631 _192_.Y a_6779_12972# 0.02018f
C632 _226_.Y a_15601_5414# 0.0162f
C633 _210_.A a_6060_4166# 0.12931f
C634 a_10020_17512# a_10437_17519# 0.37583f
C635 _179_.Y a_6890_9948# 0.01451f
C636 _181_.Y _164_.Y 0.22013f
C637 a_8870_12210# a_9156_12528# 0.41329f
C638 a_5226_4948# a_5608_4782# 0.01012f
C639 clkbuf_1_0__f_sclk.A _187_.Y 0.04449f
C640 _136_.A a_8014_8492# 0.04773f
C641 _225_.A _266_.CLK 0.74173f
C642 _266_.CLK a_12804_16000# 0.10712f
C643 _225_.A _264_.Q 0.13649f
C644 a_9573_13701# a_9675_13844# 0.47622f
C645 a_13681_15998# a_13221_16007# 0.01483f
C646 a_2232_15428# _118_.A0 0.03998f
C647 _148_.A _224_.Y 0.01555f
C648 _225_.A _225_.Y 0.22325f
C649 a_13073_7728# _160_.B 0.232f
C650 a_7727_4727# a_7633_4727# 0.28931f
C651 _225_.A a_14820_9504# 0.05026f
C652 _133_.B _236_.Y 0.05145f
C653 a_3380_13690# _247_.CLK 1.18882f
C654 a_11364_17064# VPWR 0.07595f
C655 _164_.Y VPWR 0.66875f
C656 _235_.Y a_14820_11464# 0.01383f
C657 fanout6.A a_7882_15964# 0.01177f
C658 a_2126_15424# _118_.X 0.20233f
C659 _232_.Y a_9551_16823# 0.133f
C660 a_9675_12332# _251_.CLK 0.01604f
C661 _234_.Y _131_.A2 0.02135f
C662 _120_.A0 clkbuf_1_0__f_sclk.A 0.08035f
C663 a_2126_15424# a_2298_15532# 0.01057f
C664 a_3952_9406# a_2955_9308# 0.02979f
C665 a_2724_9199# _124_.S 0.01728f
C666 a_5169_9508# VPWR 0.01058f
C667 a_9675_13844# a_10415_13799# 0.26905f
C668 _240_.Y a_9551_16823# 0.01072f
C669 _178_.B1 a_6579_11460# 0.01033f
C670 a_8538_5375# a_8564_5412# 0.37141f
C671 a_12623_16823# VPWR 0.1684f
C672 _225_.A a_9994_17476# 0.03512f
C673 _148_.B _186_.Y 0.18319f
C674 a_10020_17512# a_10539_17519# 0.34102f
C675 fanout6.A a_8427_16007# 0.01659f
C676 a_10437_17519# a_10897_17861# 0.02396f
C677 _238_.Y a_15389_17042# 0.01599f
C678 _165_.Y _170_.Y 0.29438f
C679 _136_.A a_8156_7972# 0.0324f
C680 _131_.A2 _260_.CLK 4.09092f
C681 a_7882_15964# a_7908_16000# 0.36952f
C682 _199_.Y _205_.Y 0.42317f
C683 a_5147_15996# VPWR 0.30315f
C684 _207_.Y VPWR 0.23139f
C685 _202_.Y a_7008_16035# 0.34302f
C686 a_9573_13701# a_10321_13799# 0.01058f
C687 a_10415_13799# a_10672_13942# 0.34468f
C688 _168_.Y VPWR 0.56464f
C689 a_7074_15532# _202_.Y 0.01389f
C690 _242_.D _215_.Y 0.07582f
C691 a_10415_12287# a_9675_12332# 0.26905f
C692 a_7712_7806# VPWR 0.08681f
C693 a_14724_5416# _251_.CLK 0.10641f
C694 a_16650_12508# fanout7.A 0.04392f
C695 _243_.CLK VPWR 3.70217f
C696 _145_.X VPWR 2.30907f
C697 fanout6.A _207_.A1 0.58279f
C698 a_1862_16434# a_2148_16000# 0.41329f
C699 _243_.Q _136_.B 0.38111f
C700 _195_.Y _200_.Y 0.3065f
C701 _238_.Y a_15861_16904# 0.2373f
C702 _120_.A0 a_2218_12433# 0.04864f
C703 _173_.Y a_6124_9945# 0.13141f
C704 a_13775_5782# _151_.B 0.01167f
C705 _232_.Y a_8709_16725# 0.03557f
C706 a_7908_16000# a_8427_16007# 0.34102f
C707 a_8325_16007# a_8785_16349# 0.02396f
C708 a_14438_5850# a_14698_5380# 0.75507f
C709 _179_.Y _178_.Y 0.47924f
C710 _250_.Q a_2667_16868# 0.02541f
C711 a_10415_13799# a_10321_13799# 0.28931f
C712 _157_.B _145_.X 0.03211f
C713 _149_.A a_16650_5412# 0.13426f
C714 _225_.A a_14438_5850# 0.02528f
C715 a_14438_12210# a_15141_12189# 0.02454f
C716 a_2608_6166# a_2494_6166# 0.0308f
C717 a_2398_4654# a_2512_4654# 0.0308f
C718 a_14820_9504# _260_.CLK 0.0675f
C719 _180_.X a_10020_9504# 0.03281f
C720 _126_.Y VPWR 0.30676f
C721 a_10321_12287# a_9573_12189# 0.01058f
C722 a_14572_16746# VPWR 0.15842f
C723 _124_.S _243_.CLK 0.12693f
C724 _144_.Y VPWR 0.42338f
C725 a_8266_16969# VPWR 0.09403f
C726 _225_.A a_14624_4782# 0.0183f
C727 a_12518_16434# a_12804_16000# 0.41329f
C728 a_12549_12189# a_13009_12506# 0.01483f
C729 _225_.A a_10308_17933# 0.01757f
C730 a_2565_16007# a_2436_16421# 0.01562f
C731 a_2148_16000# a_3025_16349# 0.01835f
C732 _160_.B _162_.B 0.5003f
C733 _173_.Y a_6320_10296# 0.01057f
C734 _225_.A a_15243_12332# 0.02368f
C735 a_8557_4248# a_8386_3900# 0.14248f
C736 a_8427_16007# a_9424_16238# 0.03061f
C737 _126_.B1 a_14357_12972# 0.10116f
C738 _122_.A0 _122_.X 0.07506f
C739 a_2126_7864# a_2298_7678# 0.0308f
C740 _179_.Y _171_.A 0.01523f
C741 a_4816_4870# VPWR 0.16263f
C742 _176_.A a_8870_12210# 0.0214f
C743 _166_.A _153_.Y 0.02151f
C744 _210_.A a_6885_4629# 0.01325f
C745 _250_.Q a_4462_16052# 0.08673f
C746 a_6389_9484# _178_.Y 0.17596f
C747 a_14724_12528# a_15983_12287# 0.01529f
C748 a_2075_5468# _243_.Q 0.03975f
C749 _164_.Y a_10895_8436# 0.15454f
C750 _138_.Y a_8042_3900# 0.01284f
C751 _147_.A1 a_11274_4948# 0.13274f
C752 a_2565_16725# a_2667_16868# 0.47622f
C753 _148_.A VPWR 2.3146f
C754 a_11846_12210# a_12420_12223# 0.31978f
C755 a_12804_16000# a_13092_16421# 0.43707f
C756 a_2667_16007# a_3664_16238# 0.03061f
C757 a_11279_17869# a_11185_17869# 0.28931f
C758 a_16746_9484# VPWR 0.37721f
C759 _144_.B _243_.Q 0.01873f
C760 _252_.D VPWR 0.4813f
C761 a_12128_4782# VPWR 0.08263f
C762 a_11536_9406# _251_.CLK 0.01238f
C763 _166_.A a_10408_7806# 0.01715f
C764 a_9573_12189# VPWR 0.24956f
C765 a_6747_5468# a_6949_5782# 0.01117f
C766 a_13649_4704# _151_.B 0.32699f
C767 _260_.RESET_B _227_.Y 0.04728f
C768 _210_.B a_6656_5498# 0.02076f
C769 a_15243_12332# a_15012_12223# 0.12701f
C770 a_14724_12528# a_15601_12231# 0.01835f
C771 _236_.A a_14820_11464# 0.01549f
C772 _148_.A _124_.S 0.87667f
C773 a_2398_5782# a_2301_5782# 0.01625f
C774 a_2602_3868# a_2628_3904# 0.36952f
C775 a_13648_12430# a_14058_12508# 0.10373f
C776 a_14534_9186# _260_.RESET_B 0.10166f
C777 _148_.B _176_.B 0.06305f
C778 _214_.Y freq_in 0.05599f
C779 a_16240_5654# a_16650_5412# 0.10373f
C780 _139_.X VPWR 0.50963f
C781 a_13824_7989# _145_.X 0.0188f
C782 a_13617_4972# VPWR 0.01089f
C783 _126_.Y a_12923_11460# 0.15829f
C784 _145_.X a_10895_8436# 0.02608f
C785 a_2126_7864# a_1952_7806# 0.01107f
C786 a_9734_9186# a_10539_9308# 0.097f
C787 a_10020_9504# a_10437_9165# 0.3749f
C788 _242_.D _215_.A 0.37225f
C789 _195_.Y _207_.A1 0.01904f
C790 _243_.Q _243_.RESET_B 0.04085f
C791 a_6760_13854# VPWR 0.16063f
C792 a_2148_16000# VPWR 0.07884f
C793 a_5333_15532# VPWR 0.29294f
C794 _164_.Y _160_.X 0.11958f
C795 a_3045_3911# a_3505_4253# 0.02396f
C796 a_2628_3904# a_3147_3911# 0.34102f
C797 a_3664_16238# a_3724_16119# 0.01042f
C798 _205_.Y a_6720_17061# 0.1565f
C799 a_14698_5380# VPWR 0.10143f
C800 _133_.B _131_.A2 0.31119f
C801 _144_.B a_9322_4873# 0.03021f
C802 a_1958_12210# a_2763_12332# 0.097f
C803 a_2244_12528# a_2661_12189# 0.3749f
C804 _187_.Y VPWR 0.66351f
C805 a_16240_5654# a_16300_5535# 0.01042f
C806 _225_.A VPWR 4.51591f
C807 a_12804_16000# VPWR 0.07315f
C808 a_2126_11726# a_2298_11484# 0.01057f
C809 a_16736_4782# VPWR 0.09324f
C810 a_2150_8874# a_2724_8861# 0.31978f
C811 a_2410_8404# a_2853_8447# 0.02242f
C812 a_11536_17750# VPWR 0.16072f
C813 a_9130_12433# a_8870_12210# 0.75507f
C814 a_4512_17547# _207_.A2 0.1932f
C815 a_3695_9263# a_3952_9406# 0.34468f
C816 _124_.S a_2148_16000# 0.01696f
C817 a_3407_16357# VPWR 0.18693f
C818 fanout8.A _118_.X 0.09128f
C819 a_10408_7806# _251_.CLK 0.01104f
C820 a_3147_3911# a_4144_4142# 0.03061f
C821 _215_.Y a_3717_4629# 0.03432f
C822 clkbuf_1_0__f_sclk.A _173_.Y 0.07468f
C823 _173_.A _120_.A0 0.4055f
C824 a_9322_4873# a_9765_4629# 0.02242f
C825 a_9062_4650# a_9348_4968# 0.41329f
C826 a_14534_8874# a_15339_8447# 0.097f
C827 _120_.A0 a_2122_12940# 0.03023f
C828 _183_.Y a_8050_10326# 0.12115f
C829 _120_.A0 VPWR 1.22392f
C830 a_10784_8522# VPWR 0.09345f
C831 _260_.RESET_B _251_.CLK 0.02624f
C832 _143_.A _136_.B 0.14695f
C833 a_3045_3911# VPWR 0.2529f
C834 _152_.X _149_.A 0.03203f
C835 a_10888_16878# VPWR 0.15036f
C836 _129_.Y _126_.B1 0.11372f
C837 a_2436_8440# a_3695_8797# 0.01529f
C838 _214_.A VPWR 0.66778f
C839 a_6124_9945# _177_.X 0.16248f
C840 a_2240_3986# _243_.D 0.02803f
C841 fanout6.A _203_.Y 0.03003f
C842 _148_.B clkbuf_1_0__f_sclk.A 0.19393f
C843 a_10437_9165# a_10308_9199# 0.01562f
C844 a_10539_9308# VPWR 0.18582f
C845 _180_.X _171_.A 0.04418f
C846 a_2667_12983# _247_.CLK 0.04195f
C847 _206_.Y VPWR 0.22975f
C848 _160_.X _145_.X 2.72146f
C849 _207_.A1 _209_.Y 0.35789f
C850 _180_.X _228_.Y 0.03411f
C851 fanout6.A _266_.CLK 0.29317f
C852 _234_.Y VPWR 1.46362f
C853 a_6048_13011# _192_.C 0.20971f
C854 _124_.S _120_.A0 0.48744f
C855 _136_.A _145_.A2 0.03508f
C856 _210_.A _242_.D 0.04062f
C857 a_3503_12287# a_3760_12430# 0.34468f
C858 a_2244_12528# a_3121_12231# 0.01835f
C859 a_2763_12332# a_2532_12223# 0.12701f
C860 a_4012_9501# VPWR 0.01228f
C861 a_3956_6888# clkbuf_1_0__f_sclk.A 0.52029f
C862 a_1192_4782# a_1376_4782# 0.0524f
C863 _237_.Y a_12778_15964# 0.26478f
C864 a_3887_4261# VPWR 0.19026f
C865 a_3952_8678# a_4362_8436# 0.10373f
C866 a_7624_10034# VPWR 0.1258f
C867 _225_.A a_14340_15552# 0.03374f
C868 _215_.A _210_.Y 0.03301f
C869 a_11536_9406# a_11946_9484# 0.10373f
C870 a_1192_11460# VPWR 0.22264f
C871 a_2565_16725# a_3313_16823# 0.01058f
C872 a_11279_9263# VPWR 0.17266f
C873 _215_.A _246_.D 0.11049f
C874 a_3717_5423# _244_.RESET_B 0.03615f
C875 _199_.Y _199_.B1 0.19226f
C876 a_4928_16082# VPWR 0.07711f
C877 _151_.X a_13649_4704# 0.22448f
C878 a_2398_4654# VPWR 0.10802f
C879 _260_.CLK VPWR 1.87257f
C880 _147_.Y _243_.Q 0.37503f
C881 a_16336_11702# a_16746_11460# 0.10373f
C882 a_9156_14040# fanout7.A 0.08736f
C883 a_7985_13776# _194_.X 0.22638f
C884 _236_.A a_11082_14020# 0.04383f
C885 a_2148_12976# a_2565_12983# 0.37583f
C886 _224_.Y a_6987_4772# 0.42048f
C887 a_1192_11460# _124_.S 0.25056f
C888 a_4816_5654# _244_.RESET_B 0.09868f
C889 _236_.A a_12549_12189# 0.02137f
C890 _136_.A _143_.Y 0.02627f
C891 _250_.RESET_B a_2565_16007# 0.03512f
C892 a_15776_7806# _251_.CLK 0.01543f
C893 _124_.S a_2398_4654# 0.11711f
C894 _236_.A _129_.B1 0.02512f
C895 _129_.Y a_14438_12210# 0.27011f
C896 _132_.Y _133_.Y 0.12148f
C897 _145_.A2 _143_.Y 0.17932f
C898 a_13073_5770# _152_.X 0.01146f
C899 _138_.Y _145_.X 0.02117f
C900 a_16336_11702# a_16396_11583# 0.01042f
C901 a_6836_3900# VPWR 0.20762f
C902 _134_.Y a_12984_12952# 0.01075f
C903 _134_.Y a_13366_13350# 0.05227f
C904 _178_.Y a_7157_9948# 0.01249f
C905 _207_.A2 a_4796_17044# 0.01422f
C906 _224_.Y a_7984_4870# 0.10165f
C907 a_2436_13397# a_2667_12983# 0.12701f
C908 _161_.Y _157_.Y 0.33664f
C909 _145_.X a_13403_8436# 0.03948f
C910 _250_.RESET_B _247_.CLK 0.02584f
C911 _126_.B1 a_14240_13058# 0.01974f
C912 a_11731_8698# a_11974_8436# 0.13617f
C913 _147_.Y a_11381_3900# 0.15809f
C914 _133_.B a_15243_12332# 0.03401f
C915 _228_.Y a_10437_9165# 0.03432f
C916 _131_.Y _131_.B1 0.75419f
C917 a_3300_5416# VPWR 0.10824f
C918 _215_.A a_3717_4629# 0.01285f
C919 _181_.Y _182_.Y 0.05565f
C920 _134_.Y a_13100_13686# 0.04954f
C921 _118_.A0 a_4074_15996# 0.01001f
C922 _210_.A _210_.Y 0.16294f
C923 _168_.A _178_.B1 0.39765f
C924 _138_.Y _144_.Y 0.14615f
C925 a_13775_5782# _148_.X 0.02079f
C926 _243_.CLK a_2853_8447# 0.28568f
C927 _222_.Y a_3724_17061# 0.01227f
C928 _125_.A1 VPWR 0.67966f
C929 _227_.Y a_14794_8404# 0.24218f
C930 _171_.A a_7157_9948# 0.05573f
C931 fanout6.A a_12518_16434# 0.05714f
C932 a_4593_17068# VPWR 0.01074f
C933 _136_.B _251_.CLK 0.12876f
C934 a_8156_9928# VPWR 0.01841f
C935 a_3407_13333# a_4074_12972# 0.0894f
C936 a_14940_16710# a_15722_16904# 0.43707f
C937 _166_.A a_14794_8404# 0.01304f
C938 a_13244_5412# _151_.B 0.10068f
C939 a_4512_17547# _118_.A0 0.13611f
C940 _182_.Y VPWR 0.62156f
C941 a_3819_5423# VPWR 0.21478f
C942 a_2126_13912# a_1864_13854# 0.01053f
C943 a_12923_11460# _260_.CLK 0.05556f
C944 _221_.Y _247_.CLK 0.03194f
C945 _149_.A _157_.Y 0.56336f
C946 _162_.Y VPWR 0.2565f
C947 a_15141_5423# _149_.A 0.02073f
C948 _225_.A _160_.X 0.08741f
C949 a_3014_5850# a_3300_5416# 0.41329f
C950 _266_.CLK _135_.X 0.06972f
C951 _138_.Y _148_.A 0.02672f
C952 a_11364_17064# a_11883_16868# 0.34114f
C953 a_7985_13776# VPWR 0.22187f
C954 _168_.A a_11536_9406# 0.01216f
C955 _125_.A1 _124_.S 0.10696f
C956 _225_.Y a_9348_4968# 0.37726f
C957 _227_.Y a_16336_8678# 0.09868f
C958 _160_.B _158_.Y 0.40195f
C959 fanout6.A a_13092_16421# 0.02256f
C960 a_2122_16969# _222_.Y 0.23657f
C961 _138_.Y _252_.D 0.14058f
C962 _241_.Y VPWR 1.41203f
C963 _122_.A0 a_2955_8447# 0.0257f
C964 a_2126_10214# a_2298_9972# 0.01057f
C965 a_2724_9199# a_2150_9186# 0.31978f
C966 a_14240_16921# _135_.A 0.11571f
C967 a_14320_16238# _135_.A 0.01111f
C968 _160_.X a_10784_8522# 0.01868f
C969 a_13244_7972# VPWR 0.20682f
C970 _147_.Y a_12401_4704# 0.03199f
C971 a_3014_5850# a_3819_5423# 0.097f
C972 a_15243_5423# _251_.CLK 0.04316f
C973 a_11883_16868# a_12623_16823# 0.26905f
C974 _225_.Y a_10607_4727# 0.13301f
C975 a_12512_8522# VPWR 0.07127f
C976 _191_.Y _201_.Y 0.0126f
C977 _185_.Y _183_.Y 0.25942f
C978 a_2218_12433# a_2661_12189# 0.02242f
C979 _120_.X a_2244_12528# 0.01075f
C980 _148_.B _181_.Y 0.17992f
C981 a_12215_7664# a_12032_7806# 0.01069f
C982 _192_.B _176_.A 0.21725f
C983 _218_.Y a_4012_8559# 0.01227f
C984 a_8990_5412# VPWR 0.01094f
C985 _144_.B _251_.CLK 0.14283f
C986 _173_.A _173_.Y 0.30612f
C987 a_6987_4772# VPWR 0.18903f
C988 a_2494_6166# VPWR 0.10974f
C989 _133_.B VPWR 1.14322f
C990 _173_.Y VPWR 0.77707f
C991 _215_.A _224_.Y 0.08816f
C992 _266_.CLK _135_.A 0.09323f
C993 _190_.A a_6197_13342# 0.02833f
C994 _139_.X a_10940_3900# 0.09955f
C995 a_14757_15213# a_14859_15356# 0.47622f
C996 _147_.Y _147_.B1 0.22299f
C997 a_3300_5416# a_4465_5773# 0.43239f
C998 a_11364_17064# a_12241_16767# 0.01835f
C999 _215_.Y VPWR 1.35902f
C1000 a_11883_16868# a_11652_16759# 0.12701f
C1001 _201_.Y a_7157_16366# 0.01075f
C1002 a_14794_11428# a_15237_11471# 0.02242f
C1003 a_3664_16966# a_3724_17061# 0.01042f
C1004 a_3407_16823# a_4074_17044# 0.0894f
C1005 _171_.Y a_8236_8436# 0.01409f
C1006 _151_.B VPWR 0.91109f
C1007 _210_.A a_2512_4654# 0.01717f
C1008 _222_.A a_1580_16710# 0.27823f
C1009 _148_.B VPWR 4.26248f
C1010 a_10672_12430# _229_.Y 0.10179f
C1011 _119_.X VPWR 0.3888f
C1012 _185_.Y a_8050_10326# 0.0367f
C1013 _225_.A _138_.Y 0.23406f
C1014 a_9765_4629# _251_.CLK 0.28259f
C1015 _243_.Q a_2628_3904# 0.01883f
C1016 _193_.Y _190_.A 0.04882f
C1017 _145_.A2 a_8394_4948# 0.06693f
C1018 _178_.B1 _174_.Y 0.98169f
C1019 a_9808_16966# a_9868_17061# 0.01042f
C1020 a_9551_16823# a_10218_17044# 0.0894f
C1021 _122_.A0 a_6528_8475# 0.01665f
C1022 fanout6.A VPWR 1.46496f
C1023 a_2494_6166# _124_.S 0.15709f
C1024 a_7984_4870# VPWR 0.1606f
C1025 a_14724_5416# a_15983_5773# 0.01529f
C1026 a_13073_5770# _157_.Y 0.05459f
C1027 _157_.B _151_.B 0.39357f
C1028 _119_.A0 _120_.A0 0.8426f
C1029 a_3956_6888# VPWR 2.0954f
C1030 _148_.A a_11661_4696# 0.01028f
C1031 _151_.X a_14438_5850# 0.27444f
C1032 a_14859_15356# a_15599_15311# 0.26905f
C1033 a_4625_16800# VPWR 0.21351f
C1034 _124_.S _215_.Y 0.03597f
C1035 a_4816_5654# a_5226_5412# 0.10373f
C1036 a_2853_9165# a_2955_9308# 0.47622f
C1037 a_14240_16921# a_14359_16710# 0.0894f
C1038 _250_.D a_2122_16969# 0.02135f
C1039 a_9675_13844# VPWR 0.18681f
C1040 _250_.Q _222_.Y 0.01827f
C1041 a_14320_16238# a_14063_16357# 0.34468f
C1042 a_14698_12433# a_14438_12210# 0.75507f
C1043 _243_.Q a_4144_4142# 0.0108f
C1044 _234_.Y a_13009_12506# 0.01491f
C1045 _135_.X a_12518_16434# 0.27674f
C1046 _122_.A0 _170_.Y 0.05659f
C1047 _243_.CLK a_3014_4650# 0.0272f
C1048 a_5800_9318# clkbuf_1_0__f_sclk.A 0.01103f
C1049 _225_.A _235_.Y 0.07592f
C1050 _214_.Y _240_.Y 0.12124f
C1051 a_15599_15311# a_15856_15454# 0.34468f
C1052 a_14757_15213# a_15505_15311# 0.01058f
C1053 a_7908_16000# VPWR 0.07158f
C1054 a_10672_13942# VPWR 0.16164f
C1055 _202_.Y a_7251_15996# 0.01244f
C1056 a_14063_16357# _266_.CLK 0.01769f
C1057 _243_.Q a_2075_4692# 0.0511f
C1058 _128_.B1 _126_.B1 0.352f
C1059 _210_.A _224_.Y 0.08806f
C1060 a_1192_17508# rst 0.2641f
C1061 a_3717_4629# a_3819_4772# 0.47622f
C1062 a_6810_3863# _136_.B 0.30975f
C1063 _192_.C _187_.Y 0.04618f
C1064 a_11846_12210# VPWR 0.77538f
C1065 _136_.A a_7872_5451# 0.04385f
C1066 a_8557_4248# VPWR 0.37791f
C1067 a_6779_12972# VPWR 0.30325f
C1068 _243_.Q a_6060_4166# 0.01483f
C1069 _193_.Y a_7180_14020# 0.01455f
C1070 a_17032_16082# VPWR 0.13631f
C1071 _222_.Y a_2565_16725# 0.03432f
C1072 _191_.Y _204_.X 0.21532f
C1073 _221_.Y a_3724_13095# 0.01227f
C1074 a_8006_16746# a_8580_16759# 0.31978f
C1075 _145_.A2 a_7872_5451# 0.35113f
C1076 a_7616_5498# VPWR 0.10131f
C1077 _201_.Y _205_.Y 0.27832f
C1078 a_9424_16238# VPWR 0.15793f
C1079 _122_.A0 _218_.Y 0.23174f
C1080 a_15599_15311# a_15505_15311# 0.28931f
C1081 _266_.CLK a_15071_17016# 0.25406f
C1082 a_2342_4338# _243_.RESET_B 0.09347f
C1083 _236_.A _126_.Y 0.15964f
C1084 _229_.Y VPWR 1.47607f
C1085 a_9120_9501# a_9269_9190# 0.33493f
C1086 a_3300_4968# a_4559_4727# 0.01529f
C1087 a_13824_7989# a_13973_7678# 0.33493f
C1088 a_13824_7989# _151_.B 0.01485f
C1089 a_14534_9186# a_15339_9308# 0.097f
C1090 a_14820_9504# a_15237_9165# 0.3749f
C1091 a_5201_9240# a_5800_9318# 0.01213f
C1092 a_8538_5375# VPWR 0.22389f
C1093 a_6182_4650# a_6987_4772# 0.097f
C1094 a_6468_4968# a_6885_4629# 0.3749f
C1095 _153_.Y a_13000_8522# 0.02623f
C1096 a_15985_8797# a_14820_8440# 0.43239f
C1097 _162_.Y _160_.X 0.01219f
C1098 a_2150_8874# VPWR 0.77856f
C1099 _173_.A _215_.A 0.08482f
C1100 a_8266_16969# a_8292_17064# 0.36952f
C1101 _215_.A VPWR 2.8697f
C1102 _192_.Y _192_.B 0.22644f
C1103 _166_.A fanout7.A 0.19023f
C1104 _250_.Q a_3664_16966# 0.01532f
C1105 a_3300_4968# a_4177_4671# 0.01835f
C1106 a_3819_4772# a_3588_4663# 0.12701f
C1107 a_2661_12189# VPWR 0.24435f
C1108 a_4913_13330# a_5084_12972# 0.37141f
C1109 _215_.A a_1568_12342# 0.02019f
C1110 _119_.A0 a_3313_13333# 0.01099f
C1111 a_14380_16119# _237_.Y 0.01227f
C1112 _195_.Y VPWR 0.58813f
C1113 _151_.X VPWR 0.53225f
C1114 a_2232_7868# _122_.A0 0.04329f
C1115 _159_.Y a_14534_8874# 0.2602f
C1116 _134_.Y fanout7.A 0.03505f
C1117 _235_.Y _260_.CLK 0.49919f
C1118 _122_.A0 sclk 0.0141f
C1119 _220_.Y a_2244_12528# 0.39775f
C1120 a_9348_4968# VPWR 0.08118f
C1121 a_6468_4968# a_7727_4727# 0.01529f
C1122 a_14940_16710# a_15861_16904# 0.36952f
C1123 a_15985_8797# a_16079_8797# 0.28931f
C1124 a_13883_11460# _260_.CLK 0.02706f
C1125 _124_.S a_2150_8874# 0.04436f
C1126 _135_.X VPWR 0.48496f
C1127 a_2494_6166# a_2671_6460# 0.01057f
C1128 a_2171_6204# _244_.D 0.01628f
C1129 a_8603_9484# _171_.Y 0.07922f
C1130 _166_.A _160_.B 0.04163f
C1131 a_8709_16725# fanout7.A 0.25647f
C1132 _177_.X VPWR 0.32975f
C1133 _124_.S _215_.A 0.28413f
C1134 a_8811_16868# a_9169_17042# 0.02138f
C1135 a_7168_15260# _205_.Y 0.01657f
C1136 _168_.B clkbuf_1_0__f_sclk.A 0.23144f
C1137 fanout8.A a_2126_17774# 0.02072f
C1138 _135_.A a_14048_16878# 0.01342f
C1139 a_14534_11898# _131_.B1 0.04913f
C1140 _172_.Y a_9269_9190# 0.04946f
C1141 a_4816_4870# a_5226_4948# 0.10373f
C1142 a_15339_8447# VPWR 0.18418f
C1143 a_7739_9484# VPWR 0.31173f
C1144 a_3014_5850# _215_.A 0.0556f
C1145 _124_.S a_2661_12189# 0.01766f
C1146 _186_.Y _178_.Y 0.01004f
C1147 _189_.X a_4913_13330# 0.22528f
C1148 a_1376_4782# VPWR 0.0695f
C1149 a_3760_12430# VPWR 0.18483f
C1150 a_12800_6294# VPWR 0.08107f
C1151 a_2075_5468# a_2575_5436# 0.03308f
C1152 a_2398_5782# a_2301_5436# 0.02903f
C1153 _208_.X a_6720_17061# 0.34521f
C1154 a_2667_16868# a_3407_16823# 0.26905f
C1155 _243_.RESET_B _243_.D 0.1088f
C1156 _214_.A a_11883_16868# 0.07031f
C1157 a_15237_9165# a_15697_9207# 0.02396f
C1158 _183_.Y _164_.Y 0.25338f
C1159 a_16079_9263# a_16336_9406# 0.34468f
C1160 sdata VPWR 0.11012f
C1161 _220_.Y a_3503_12287# 0.13292f
C1162 a_4074_12972# a_4456_13058# 0.01012f
C1163 a_10607_4727# VPWR 0.17654f
C1164 fanout8.A rst 0.0877f
C1165 a_6987_4772# a_6756_4663# 0.12701f
C1166 a_6468_4968# a_7345_4671# 0.01835f
C1167 _210_.B _136_.B 0.03817f
C1168 a_16746_11460# _260_.CLK 0.12437f
C1169 _184_.Y VPWR 0.67303f
C1170 a_9994_17476# a_10020_17512# 0.36952f
C1171 _160_.X _151_.B 0.01152f
C1172 _145_.X _157_.Y 0.0958f
C1173 _204_.X _205_.Y 0.28607f
C1174 _148_.B _160_.X 0.1144f
C1175 _210_.A VPWR 1.22046f
C1176 _222_.A _258_.RESET_B 0.26329f
C1177 fanout8.A a_1862_16746# 0.01717f
C1178 _208_.X a_4796_17044# 0.10059f
C1179 fanout7.A _251_.CLK 0.05408f
C1180 a_13184_7183# _151_.B 0.1527f
C1181 _148_.A a_12572_4948# 0.01008f
C1182 a_9156_14040# a_9573_13701# 0.3749f
C1183 a_8870_13722# a_9675_13844# 0.097f
C1184 _225_.A _236_.A 0.8057f
C1185 a_2126_15424# _118_.A0 0.09275f
C1186 _135_.A VPWR 0.6827f
C1187 _164_.Y a_8050_10326# 0.11656f
C1188 _209_.Y VPWR 0.39789f
C1189 a_2122_16969# a_2148_17064# 0.36952f
C1190 _225_.A a_14794_9409# 0.02336f
C1191 a_16650_12508# _131_.A2 0.12692f
C1192 a_14438_12210# _126_.B1 0.03695f
C1193 a_16396_8559# a_16336_8678# 0.01042f
C1194 fanout6.A a_7622_16434# 0.02288f
C1195 a_9573_12189# a_10033_12506# 0.01483f
C1196 _243_.Q a_2171_6204# 0.1076f
C1197 a_9156_12528# _251_.CLK 0.10137f
C1198 _179_.Y _171_.Y 0.04507f
C1199 a_5201_9240# _168_.B 0.22362f
C1200 _210_.A _124_.S 0.16943f
C1201 _180_.X _251_.CLK 1.53317f
C1202 a_3592_10830# VPWR 0.17783f
C1203 a_4744_9318# _173_.A 0.03898f
C1204 a_9156_14040# a_10415_13799# 0.01529f
C1205 a_4744_9318# VPWR 0.12902f
C1206 _236_.A a_10888_16878# 0.02166f
C1207 a_13391_12287# _129_.Y 0.01012f
C1208 _236_.A _214_.A 0.0833f
C1209 a_17032_12342# _131_.A2 0.02647f
C1210 _225_.A a_9734_17946# 0.09031f
C1211 _136_.A _168_.Y 0.1631f
C1212 a_10020_17512# a_10308_17933# 0.43707f
C1213 a_2232_17770# _250_.Q 0.03057f
C1214 _186_.Y a_7451_14484# 0.05529f
C1215 _238_.Y a_14728_17061# 0.01227f
C1216 _186_.Y _192_.B 0.02298f
C1217 a_15237_11471# a_15339_11471# 0.47795f
C1218 _266_.CLK _238_.Y 0.37213f
C1219 _207_.A2 fanout8.A 0.02805f
C1220 _119_.A0 _148_.B 2.33053f
C1221 _215_.A a_1864_10034# 0.01298f
C1222 _236_.A _234_.Y 0.16952f
C1223 _119_.A0 _119_.X 0.0265f
C1224 _264_.Q _238_.Y 0.09011f
C1225 _136_.A _145_.X 2.48454f
C1226 a_7622_16434# a_7908_16000# 0.41329f
C1227 a_3724_17061# VPWR 0.01342f
C1228 a_9675_13844# a_9444_13735# 0.12701f
C1229 a_9156_14040# a_10033_13743# 0.01835f
C1230 a_5800_9318# VPWR 0.14111f
C1231 a_9484_16119# _258_.RESET_B 0.01227f
C1232 a_10415_12287# a_9156_12528# 0.01529f
C1233 _173_.A a_2955_9308# 0.02389f
C1234 _144_.B _147_.A1 0.03968f
C1235 a_2955_9308# VPWR 0.20006f
C1236 a_14359_16710# VPWR 0.17248f
C1237 a_14651_10996# _260_.CLK 0.04927f
C1238 a_14340_15552# _135_.A 0.02338f
C1239 _151_.B a_13403_8436# 0.10554f
C1240 a_14063_16357# VPWR 0.16601f
C1241 clkload0.Y _247_.CLK 0.10831f
C1242 a_10437_17519# a_11185_17869# 0.01058f
C1243 _148_.X VPWR 0.59334f
C1244 a_15237_11471# a_15697_11462# 0.01483f
C1245 _232_.Y a_8006_16746# 0.13828f
C1246 _136_.A _144_.Y 0.05452f
C1247 a_17032_10830# VPWR 0.15299f
C1248 a_7908_16000# a_8196_16421# 0.43707f
C1249 _133_.B _235_.Y 0.60136f
C1250 _242_.D _244_.D 0.08938f
C1251 a_3819_4772# VPWR 0.20648f
C1252 _236_.A _260_.CLK 0.10612f
C1253 _172_.Y _228_.Y 0.08139f
C1254 _250_.Q a_2148_17064# 0.01944f
C1255 _149_.A a_16240_5654# 0.01544f
C1256 a_8288_3986# _136_.B 0.01648f
C1257 a_2122_16969# VPWR 0.09801f
C1258 _132_.Y _131_.A2 0.3777f
C1259 a_10033_12231# a_9156_12528# 0.01835f
C1260 a_9444_12223# a_9675_12332# 0.12701f
C1261 _145_.A2 _144_.Y 0.01111f
C1262 a_15071_17016# VPWR 0.24248f
C1263 _157_.B _148_.X 0.08813f
C1264 a_12132_12528# a_12651_12332# 0.34114f
C1265 _222_.Y _118_.X 0.23118f
C1266 a_1862_16434# a_2667_16007# 0.097f
C1267 _134_.Y _133_.Y 0.21755f
C1268 a_3407_16823# a_3313_16823# 0.28931f
C1269 a_15237_9165# a_15985_9263# 0.01058f
C1270 a_15237_9165# VPWR 0.22827f
C1271 _225_.A a_14724_12528# 0.02371f
C1272 _129_.B1 a_13464_12952# 0.01075f
C1273 a_8325_16007# a_9073_16357# 0.01058f
C1274 a_14698_5380# a_15141_5423# 0.02242f
C1275 a_10437_9165# _251_.CLK 0.26208f
C1276 a_2558_17532# a_2126_17774# 0.02903f
C1277 a_2298_17532# a_2232_17770# 0.03308f
C1278 _136_.A _148_.A 0.0468f
C1279 a_2126_15424# a_2232_15428# 0.43036f
C1280 _143_.Y _145_.X 0.01958f
C1281 a_8352_11013# _182_.Y 0.19315f
C1282 _148_.B _192_.C 0.04024f
C1283 _210_.A a_6182_4650# 0.06991f
C1284 a_15243_12332# a_15601_12506# 0.02138f
C1285 _168_.A a_6528_8475# 0.13614f
C1286 _180_.X a_8705_9212# 0.01071f
C1287 a_13985_11808# _131_.A2 0.01181f
C1288 _138_.Y a_8557_4248# 0.02761f
C1289 a_15767_17137# VPWR 0.78234f
C1290 _241_.Y a_11883_16868# 0.42215f
C1291 _145_.A2 _148_.A 0.07894f
C1292 a_14320_16238# _237_.Y 0.09868f
C1293 a_1952_7806# VPWR 0.09663f
C1294 a_12651_12332# a_13391_12287# 0.26905f
C1295 a_2148_17064# a_2565_16725# 0.3749f
C1296 a_1862_16746# a_2667_16868# 0.097f
C1297 _247_.CLK a_2565_16007# 0.27741f
C1298 _225_.A a_11946_17508# 0.0123f
C1299 a_2148_16000# a_3313_16357# 0.43239f
C1300 _168_.A _179_.Y 0.03692f
C1301 a_11536_17750# a_11946_17508# 0.10373f
C1302 a_13648_12430# _129_.B1 0.03515f
C1303 _145_.A2 _252_.D 0.42521f
C1304 _191_.Y a_6958_13764# 0.10764f
C1305 a_16336_9406# VPWR 0.1602f
C1306 a_6442_4873# a_6885_4629# 0.02242f
C1307 a_10415_12287# a_11082_12508# 0.0894f
C1308 a_10672_12430# a_10732_12525# 0.01042f
C1309 a_9167_16357# a_9073_16357# 0.28931f
C1310 a_10020_17512# VPWR 0.0745f
C1311 _180_.X _171_.Y 0.84356f
C1312 a_8870_12210# VPWR 0.7739f
C1313 _143_.Y _144_.Y 0.22971f
C1314 _176_.A _251_.CLK 0.02054f
C1315 a_13100_13686# a_12808_13854# 0.01f
C1316 a_14724_12528# a_15012_12223# 0.43707f
C1317 a_6106_9190# _174_.Y 0.01562f
C1318 _242_.D _243_.Q 0.11707f
C1319 _173_.A _120_.X 0.04447f
C1320 a_13073_7728# VPWR 0.21301f
C1321 _136_.A _139_.X 0.05556f
C1322 _120_.X VPWR 0.3851f
C1323 _241_.Y a_12940_17061# 0.01227f
C1324 _266_.CLK _237_.Y 0.05452f
C1325 a_2075_5468# a_1864_5498# 0.02132f
C1326 _230_.Y a_9675_13844# 0.42146f
C1327 _168_.B VPWR 0.49585f
C1328 a_2342_4338# a_2628_3904# 0.41329f
C1329 a_12549_12189# a_13297_12287# 0.01058f
C1330 a_3407_16357# a_3313_16357# 0.28931f
C1331 a_2126_7864# _122_.A0 0.09461f
C1332 a_14757_15213# _266_.CLK 0.26042f
C1333 a_11946_17508# _214_.A 0.11591f
C1334 _220_.Y a_2218_12433# 0.26267f
C1335 _138_.Y a_8538_5375# 0.08333f
C1336 _191_.Y _192_.Y 0.28738f
C1337 _236_.A _182_.Y 0.01314f
C1338 _192_.B _176_.B 0.12189f
C1339 a_15243_5423# a_15983_5773# 0.26905f
C1340 _250_.Q VPWR 0.61314f
C1341 _119_.A0 _195_.Y 0.26309f
C1342 _210_.A a_6756_4663# 0.01954f
C1343 _118_.A0 a_4074_17044# 0.12548f
C1344 _236_.A a_7985_13776# 0.01336f
C1345 _250_.D _118_.X 0.18548f
C1346 a_9734_9186# a_10020_9504# 0.41329f
C1347 a_4012_9501# _219_.Y 0.01227f
C1348 _124_.S _120_.X 0.04041f
C1349 a_2608_6166# _243_.Q 0.01879f
C1350 _230_.Y a_10672_13942# 0.10165f
C1351 a_2628_3904# a_2916_4325# 0.43707f
C1352 _236_.A _241_.Y 0.08783f
C1353 fanout6.A a_11883_16868# 0.01102f
C1354 a_10415_12287# _176_.A 0.02138f
C1355 _138_.Y a_9348_4968# 0.02681f
C1356 a_14724_12528# _260_.CLK 0.0358f
C1357 a_1958_12210# a_2244_12528# 0.41329f
C1358 _148_.B a_8352_11013# 0.02672f
C1359 _225_.A _145_.A2 0.0939f
C1360 fanout8.A _250_.RESET_B 0.17807f
C1361 _200_.Y _191_.Y 0.11381f
C1362 _143_.A a_7727_4727# 0.01953f
C1363 a_2126_11726# a_2620_11830# 0.01625f
C1364 a_16840_4688# VPWR 0.2676f
C1365 _250_.Q _124_.S 0.18855f
C1366 a_2150_8874# a_2853_8447# 0.02432f
C1367 _240_.Y a_11279_17869# 0.13297f
C1368 fanout8.A _118_.A0 0.27764f
C1369 a_1952_11546# VPWR 0.0956f
C1370 a_2565_16725# VPWR 0.2335f
C1371 a_2667_16007# VPWR 0.19085f
C1372 _230_.Y _229_.Y 0.01807f
C1373 _147_.A1 _147_.Y 0.51514f
C1374 _152_.X _148_.B 0.14472f
C1375 a_3045_3911# a_3793_4261# 0.01058f
C1376 _215_.Y a_3014_4650# 0.08334f
C1377 a_2126_11726# _120_.A0 0.10551f
C1378 a_14794_8404# a_15237_8447# 0.02242f
C1379 a_4456_13058# a_4640_13058# 0.0524f
C1380 a_9322_4873# a_9062_4650# 0.75507f
C1381 _120_.A0 a_1862_13410# 0.044f
C1382 a_14534_8874# a_15108_8861# 0.31978f
C1383 a_1864_13854# VPWR 0.14653f
C1384 a_4559_5773# _148_.A 0.0133f
C1385 _236_.A _133_.B 1.18014f
C1386 a_2602_3868# VPWR 0.09944f
C1387 a_2853_8447# a_3313_8789# 0.02396f
C1388 a_2436_8440# a_2955_8447# 0.34102f
C1389 _196_.Y a_5333_15532# 0.07886f
C1390 fanout6.A a_7008_16035# 0.02008f
C1391 _243_.Q _210_.Y 0.02331f
C1392 fanout8.A _221_.Y 0.06122f
C1393 a_9734_9186# a_10308_9199# 0.31978f
C1394 a_10020_9504# VPWR 0.07276f
C1395 a_16650_12508# VPWR 0.38124f
C1396 _226_.Y a_14438_5850# 0.1026f
C1397 _124_.S a_2565_16725# 0.01488f
C1398 _124_.S a_2667_16007# 0.03918f
C1399 _236_.A _148_.B 4.42248f
C1400 a_3887_4261# a_3793_4261# 0.28931f
C1401 a_7336_9318# a_7520_9318# 0.0524f
C1402 a_14820_8440# a_16079_8797# 0.01529f
C1403 a_9765_4629# a_10225_4946# 0.01483f
C1404 a_3695_9263# _173_.A 0.01821f
C1405 _238_.Y VPWR 1.47553f
C1406 _149_.A _145_.X 0.16392f
C1407 _236_.A fanout6.A 0.12451f
C1408 a_2244_12528# a_2532_12223# 0.43707f
C1409 _162_.B VPWR 1.04837f
C1410 a_6747_5468# _148_.A 0.0134f
C1411 a_3695_9263# VPWR 0.19272f
C1412 _237_.Y a_12518_16434# 0.1083f
C1413 a_3147_3911# VPWR 0.20725f
C1414 _168_.A _180_.X 0.34985f
C1415 a_2955_8447# a_3695_8797# 0.26905f
C1416 _225_.A a_14314_15457# 0.01666f
C1417 _222_.A _207_.Y 0.05607f
C1418 a_2667_16868# a_2436_16759# 0.12701f
C1419 a_2148_17064# a_3025_16767# 0.01835f
C1420 a_12992_15437# fanout6.A 0.02899f
C1421 a_17032_12342# VPWR 0.12787f
C1422 a_6272_12342# VPWR 0.09664f
C1423 a_7064_9194# _184_.Y 0.01426f
C1424 a_3274_5380# _244_.RESET_B 0.23937f
C1425 _128_.B1 a_13366_13350# 0.04221f
C1426 a_3724_16119# VPWR 0.01395f
C1427 a_6389_9484# _174_.Y 0.09045f
C1428 fanout6.A a_8292_17064# 0.01345f
C1429 a_16336_8678# a_16746_8436# 0.10373f
C1430 _225_.A a_14820_11464# 0.0186f
C1431 a_2075_4692# _243_.D 0.02301f
C1432 a_2398_4654# a_2575_4948# 0.01057f
C1433 a_15339_11471# a_16079_11821# 0.26905f
C1434 _191_.Y _186_.Y 0.2562f
C1435 _162_.Y _157_.Y 0.16728f
C1436 a_2122_12940# a_2148_12976# 0.36952f
C1437 a_6885_4629# _251_.CLK 0.25709f
C1438 _224_.Y a_6468_4968# 0.39775f
C1439 a_10752_7989# _162_.B 0.19109f
C1440 a_2148_12976# VPWR 0.0794f
C1441 _170_.B _170_.Y 0.2993f
C1442 _131_.A2 _131_.B1 0.26942f
C1443 clkbuf_1_0__f_sclk.A a_5084_12972# 0.01038f
C1444 _236_.A a_11846_12210# 0.06741f
C1445 _136_.A a_6836_3900# 0.0135f
C1446 _250_.RESET_B a_2122_15964# 0.25425f
C1447 _200_.Y _205_.Y 0.38895f
C1448 _207_.A1 a_9551_16823# 0.03568f
C1449 _118_.A0 a_2122_15964# 0.03246f
C1450 _165_.Y VPWR 0.52407f
C1451 a_10864_4870# a_11274_4948# 0.10373f
C1452 a_9348_4968# a_10513_4727# 0.43239f
C1453 a_9765_4629# a_10225_4671# 0.02396f
C1454 _143_.A a_8288_3270# 0.02196f
C1455 _159_.Y VPWR 0.5618f
C1456 _220_.Y VPWR 1.44593f
C1457 a_12572_4948# _148_.B 0.02806f
C1458 a_10764_5678# _147_.A1 0.11624f
C1459 a_13244_7972# _157_.Y 0.02324f
C1460 _252_.D a_8394_4948# 0.0156f
C1461 _118_.X a_1862_16434# 0.02436f
C1462 _236_.A _229_.Y 0.15438f
C1463 _132_.Y VPWR 0.40212f
C1464 a_7727_4727# _251_.CLK 0.02065f
C1465 a_2565_12983# a_2667_12983# 0.47795f
C1466 a_2126_17774# a_2620_17878# 0.01625f
C1467 _124_.S a_2148_12976# 0.01927f
C1468 a_3407_13333# VPWR 0.18828f
C1469 clkbuf_1_0__f_sclk.A _189_.X 0.17814f
C1470 a_13073_7728# _160_.X 0.01599f
C1471 _120_.A0 a_2298_13726# 0.01887f
C1472 _250_.RESET_B a_3664_16238# 0.09873f
C1473 _133_.B a_14724_12528# 0.1199f
C1474 _126_.B1 a_13366_13350# 0.07477f
C1475 _215_.A a_3014_4650# 0.05263f
C1476 _118_.A0 a_2667_16868# 0.01286f
C1477 a_9994_9409# a_10020_9504# 0.36952f
C1478 _228_.Y a_9734_9186# 0.08323f
C1479 a_10607_4727# a_10513_4727# 0.28931f
C1480 _124_.S _220_.Y 0.01901f
C1481 a_9457_16823# a_8292_17064# 0.43239f
C1482 a_12215_7664# VPWR 0.3759f
C1483 a_12712_5498# _148_.X 0.01696f
C1484 _193_.Y _201_.Y 0.07106f
C1485 _168_.A a_10437_9165# 0.01574f
C1486 _222_.Y a_3407_16823# 0.13292f
C1487 _227_.Y a_14534_8874# 0.13941f
C1488 _226_.Y VPWR 1.49272f
C1489 _239_.Y fanout7.A 0.0109f
C1490 a_1192_7712# VPWR 0.22258f
C1491 a_3664_13214# a_3407_13333# 0.34468f
C1492 a_2565_12983# a_3025_12974# 0.01483f
C1493 fanout8.A _208_.X 0.03362f
C1494 a_15071_17016# a_15389_16767# 0.02396f
C1495 _157_.Y _151_.B 0.17178f
C1496 a_14919_16964# a_15722_16904# 0.12701f
C1497 a_13391_12287# _126_.B1 0.01008f
C1498 _237_.Y VPWR 1.43632f
C1499 a_7232_14570# VPWR 0.08011f
C1500 _218_.Y a_2436_8440# 0.41094f
C1501 _148_.B _157_.Y 0.0525f
C1502 _178_.Y VPWR 0.41229f
C1503 _166_.A a_14534_8874# 0.02849f
C1504 _214_.Y a_10437_17519# 0.04395f
C1505 _181_.Y _171_.A 0.19322f
C1506 _133_.B a_15983_12287# 0.03281f
C1507 a_14757_15213# VPWR 0.25151f
C1508 a_3588_5837# VPWR 0.01721f
C1509 _118_.A0 a_4462_16052# 0.28608f
C1510 a_14820_11464# _260_.CLK 0.06332f
C1511 a_12800_6294# _152_.X 0.01775f
C1512 _207_.A1 a_8709_16725# 0.0227f
C1513 a_5468_12508# _176_.B 0.09877f
C1514 _225_.A a_9928_8522# 0.01763f
C1515 a_9073_16357# fanout7.A 0.01746f
C1516 a_11078_16746# a_11781_16725# 0.02454f
C1517 a_14698_5380# _149_.A 0.01817f
C1518 _266_.CLK a_11944_16082# 0.01343f
C1519 a_7872_5451# _148_.A 0.01028f
C1520 _225_.Y a_9322_4873# 0.25336f
C1521 _236_.A _135_.X 0.10177f
C1522 _225_.A a_8394_4948# 0.01017f
C1523 _225_.A _149_.A 0.02979f
C1524 freq_out VPWR 0.11596f
C1525 a_7872_5451# _252_.D 0.19033f
C1526 _218_.Y a_3695_8797# 0.13297f
C1527 a_15697_8438# a_15339_8447# 0.02138f
C1528 _171_.A VPWR 0.47633f
C1529 _229_.Y a_10033_12506# 0.01494f
C1530 a_12992_15437# _135_.X 0.11753f
C1531 a_15599_15311# VPWR 0.17959f
C1532 _215_.A a_5226_4948# 0.01722f
C1533 _186_.Y _205_.Y 0.22915f
C1534 _222_.A a_2148_16000# 0.01247f
C1535 _228_.Y VPWR 1.35842f
C1536 a_12549_7996# VPWR 0.3602f
C1537 _148_.B _183_.Y 0.03311f
C1538 a_3014_5850# a_3588_5837# 0.31978f
C1539 a_11364_17064# a_12623_16823# 0.01529f
C1540 a_5888_13854# VPWR 0.07244f
C1541 _136_.A a_6987_4772# 0.01402f
C1542 _210_.A a_3014_4650# 0.02415f
C1543 a_11974_8436# VPWR 0.31719f
C1544 _136_.A _173_.Y 0.58056f
C1545 _170_.B _180_.X 0.03136f
C1546 _207_.A1 _205_.Y 0.01618f
C1547 a_13824_7989# _159_.Y 0.19315f
C1548 _210_.B a_6060_4166# 0.3773f
C1549 a_2218_12433# a_1958_12210# 0.75507f
C1550 a_10752_7989# a_10901_7678# 0.33493f
C1551 _225_.A a_9352_17508# 0.24776f
C1552 _129_.Y _133_.Y 0.0757f
C1553 a_6468_4968# VPWR 0.07865f
C1554 _214_.Y a_10539_17519# 0.04678f
C1555 _215_.A a_5608_4782# 0.01181f
C1556 a_3601_9263# a_2853_9165# 0.01058f
C1557 _168_.Y a_6677_8806# 0.03685f
C1558 _136_.A _148_.B 0.16737f
C1559 _160_.X _162_.B 1.00403f
C1560 a_14054_15234# a_14859_15356# 0.097f
C1561 a_14340_15552# a_14757_15213# 0.3749f
C1562 a_14534_8874# _251_.CLK 0.01335f
C1563 a_3300_5416# a_4559_5773# 0.01529f
C1564 a_11364_17064# a_11652_16759# 0.43707f
C1565 _118_.X VPWR 0.54196f
C1566 a_14534_11898# a_15237_11471# 0.02432f
C1567 _136_.A a_7984_4870# 0.01348f
C1568 _164_.Y _145_.X 0.10241f
C1569 a_3407_16823# a_3664_16966# 0.34468f
C1570 a_6862_15532# _201_.Y 0.03453f
C1571 _119_.X a_1862_13410# 0.27253f
C1572 _185_.Y a_7624_10034# 0.02604f
C1573 clkbuf_1_0__f_sclk.A a_5468_12508# 0.02017f
C1574 a_7451_14484# VPWR 0.30319f
C1575 a_10437_17519# freq_in 0.25229f
C1576 a_13184_7183# _162_.B 0.0174f
C1577 fanout7.A a_16746_8436# 0.04984f
C1578 _186_.Y a_8156_14020# 0.01008f
C1579 _204_.X _193_.Y 0.01209f
C1580 _192_.B VPWR 0.65328f
C1581 a_9062_4650# _251_.CLK 0.02045f
C1582 a_12992_15437# _135_.A 0.11006f
C1583 a_16079_11821# fanout7.A 0.01583f
C1584 a_9551_16823# a_9808_16966# 0.34468f
C1585 _221_.Y a_2565_12983# 0.03512f
C1586 _244_.D VPWR 0.40092f
C1587 a_14724_5416# a_15243_5423# 0.34102f
C1588 a_15141_5423# a_15601_5765# 0.02396f
C1589 fanout6.A _202_.Y 0.02188f
C1590 _122_.A0 _246_.D 0.02048f
C1591 a_14340_15552# a_15599_15311# 0.01529f
C1592 a_3819_5423# a_4559_5773# 0.26905f
C1593 a_2436_9504# a_2853_9165# 0.3749f
C1594 a_2150_9186# a_2955_9308# 0.097f
C1595 a_9156_14040# VPWR 0.07789f
C1596 _207_.Y a_5147_15996# 0.15829f
C1597 a_6720_17061# a_7328_16878# 0.01162f
C1598 _136_.A a_7633_4727# 0.01786f
C1599 _210_.A a_5226_4948# 0.13251f
C1600 a_13323_16007# a_14320_16238# 0.03061f
C1601 a_12712_5842# _152_.X 0.01197f
C1602 a_8325_16007# _232_.Y 0.01746f
C1603 _215_.A _219_.Y 0.14146f
C1604 _234_.Y a_12549_12189# 0.03432f
C1605 _152_.X _148_.X 0.03495f
C1606 _180_.X _164_.B1 0.09795f
C1607 _234_.Y _129_.B1 0.02418f
C1608 _148_.B _196_.Y 0.052f
C1609 _225_.A a_14820_8440# 0.08111f
C1610 a_14340_15552# a_15217_15255# 0.01835f
C1611 a_14859_15356# a_14628_15247# 0.12701f
C1612 a_3014_5850# _244_.D 0.26783f
C1613 a_13290_17044# _266_.CLK 0.11628f
C1614 a_7157_16366# _203_.Y 0.0358f
C1615 a_9994_9409# _228_.Y 0.23658f
C1616 a_13323_16007# _266_.CLK 0.06427f
C1617 _210_.A a_5608_4782# 0.02662f
C1618 _235_.Y a_15601_12506# 0.01491f
C1619 a_3014_4650# a_3819_4772# 0.097f
C1620 a_3300_4968# a_3717_4629# 0.3749f
C1621 _145_.A2 a_8557_4248# 0.01207f
C1622 a_10539_17519# freq_in 0.01423f
C1623 a_5084_12972# VPWR 0.20683f
C1624 _247_.CLK a_2763_12332# 0.03457f
C1625 _222_.Y a_1862_16746# 0.08182f
C1626 _133_.B a_14820_11464# 0.11223f
C1627 _135_.X a_12416_16082# 0.03001f
C1628 _234_.Y a_13648_12430# 0.10165f
C1629 a_5704_13854# a_5888_13854# 0.0524f
C1630 _162_.Y _161_.Y 0.01214f
C1631 _134_.Y _131_.A2 0.04242f
C1632 _207_.A2 _207_.A1 0.86936f
C1633 a_8811_16868# a_9551_16823# 0.26905f
C1634 _224_.Y a_6442_4873# 0.26298f
C1635 a_12651_12332# _133_.Y 0.03249f
C1636 a_3380_13690# clkbuf_1_0__f_sclk.A 0.48412f
C1637 _243_.Q VPWR 1.39257f
C1638 _129_.B1 _260_.CLK 0.25097f
C1639 _200_.Y _199_.B1 0.03135f
C1640 a_2232_7868# a_2298_7972# 0.03308f
C1641 fanout7.A _128_.B1 0.06487f
C1642 _144_.Y _145_.X 0.07354f
C1643 _158_.Y VPWR 0.50799f
C1644 _131_.B1 VPWR 0.31568f
C1645 _189_.X VPWR 0.61747f
C1646 _119_.A0 a_2148_12976# 0.03739f
C1647 a_10769_4258# VPWR 0.21872f
C1648 clkbuf_1_0__f_sclk.A _122_.A0 0.03468f
C1649 _120_.A0 a_4170_12508# 0.14128f
C1650 a_14534_9186# a_14820_9504# 0.41329f
C1651 a_14794_9409# a_15237_9165# 0.02242f
C1652 _145_.A2 a_8538_5375# 0.25244f
C1653 a_6182_4650# a_6468_4968# 0.41329f
C1654 a_2126_17774# _250_.D 0.20251f
C1655 _243_.Q _124_.S 0.10924f
C1656 a_15389_17042# a_14919_16964# 0.02138f
C1657 _143_.A _224_.Y 0.02076f
C1658 a_2126_13912# a_2620_13726# 0.01625f
C1659 a_9120_9501# _171_.Y 0.34226f
C1660 _266_.CLK a_14940_16710# 0.09281f
C1661 a_9160_17594# fanout8.A 0.0333f
C1662 _143_.Y a_8557_4248# 0.02188f
C1663 a_17120_13854# VPWR 0.08639f
C1664 _148_.A _243_.CLK 0.08678f
C1665 _164_.B1 a_11731_8698# 0.26823f
C1666 a_3300_4968# a_3588_4663# 0.43707f
C1667 a_14144_8522# VPWR 0.09826f
C1668 a_1958_12210# VPWR 0.77706f
C1669 _162_.Y a_12328_7010# 0.01072f
C1670 _119_.A0 a_3407_13333# 0.01867f
C1671 a_11381_3900# VPWR 0.23337f
C1672 _242_.D _243_.D 0.14039f
C1673 _225_.A _164_.Y 1.29095f
C1674 _199_.Y _201_.Y 0.20044f
C1675 _236_.A a_10020_17512# 0.04429f
C1676 _236_.A a_8870_12210# 0.0121f
C1677 a_4456_13058# VPWR 0.13025f
C1678 a_9322_4873# VPWR 0.09595f
C1679 _148_.X a_12572_4948# 0.12331f
C1680 _192_.C a_6272_12342# 0.01919f
C1681 a_2171_6204# a_2397_6460# 0.02726f
C1682 a_11944_16082# VPWR 0.16325f
C1683 _148_.B _161_.Y 0.05407f
C1684 a_8709_16725# a_8811_16868# 0.47622f
C1685 a_13527_11460# _133_.Y 0.02655f
C1686 fanout7.A _126_.B1 0.01774f
C1687 _160_.X a_11974_8436# 0.02926f
C1688 _250_.D a_1862_16746# 0.03712f
C1689 a_7336_9318# VPWR 0.12243f
C1690 _239_.Y a_14859_15356# 0.42204f
C1691 _124_.S a_1958_12210# 0.05382f
C1692 a_17032_5498# VPWR 0.13173f
C1693 fanout6.A _258_.RESET_B 0.04953f
C1694 _225_.A a_12623_16823# 0.01143f
C1695 _236_.Y a_15237_11471# 0.03591f
C1696 _212_.Y a_11078_16746# 0.27212f
C1697 a_2148_17064# a_3407_16823# 0.01529f
C1698 _214_.A a_11364_17064# 0.09201f
C1699 a_13323_16007# a_12518_16434# 0.097f
C1700 _119_.X a_1580_12936# 0.04483f
C1701 a_15237_9165# a_15108_9199# 0.01562f
C1702 _225_.Y _251_.CLK 0.1659f
C1703 a_6468_4968# a_6756_4663# 0.43707f
C1704 a_15141_12189# _131_.A2 0.01363f
C1705 _136_.A _210_.A 0.03655f
C1706 a_2398_5782# _125_.A1 0.49351f
C1707 a_16336_11702# _260_.CLK 0.01174f
C1708 a_14820_9504# _251_.CLK 0.0146f
C1709 _172_.Y _171_.Y 0.05493f
C1710 a_4204_4023# _243_.RESET_B 0.0123f
C1711 _190_.A fanout7.A 0.08937f
C1712 _196_.Y _195_.Y 1.0215f
C1713 a_9734_17946# a_10020_17512# 0.41329f
C1714 _239_.Y a_15856_15454# 0.1017f
C1715 _219_.Y a_2955_9308# 0.42048f
C1716 _149_.A _151_.B 0.08466f
C1717 _148_.X _157_.Y 0.05796f
C1718 _222_.A a_6869_16750# 0.01017f
C1719 _225_.A _145_.X 3.39143f
C1720 _252_.D _148_.A 0.05343f
C1721 _207_.A1 _199_.B1 0.12182f
C1722 a_13969_16357# a_12804_16000# 0.43239f
C1723 a_13323_16007# a_13092_16421# 0.12701f
C1724 _148_.A a_12128_4782# 0.01683f
C1725 _165_.Y a_7841_9212# 0.01177f
C1726 a_8870_13722# a_9156_14040# 0.41329f
C1727 a_9130_13945# a_9573_13701# 0.02242f
C1728 _210_.A a_2575_4948# 0.01308f
C1729 a_7908_16000# _258_.RESET_B 0.40994f
C1730 a_13824_7989# _158_.Y 0.33169f
C1731 a_6376_16878# VPWR 0.17281f
C1732 a_12328_7010# _148_.B 0.01596f
C1733 a_12401_4704# VPWR 0.21369f
C1734 a_7984_4870# a_8394_4948# 0.10373f
C1735 a_4012_8559# VPWR 0.01284f
C1736 a_13019_6460# _153_.Y 0.15665f
C1737 _210_.A a_6095_4270# 0.02574f
C1738 _226_.Y a_16300_5535# 0.01227f
C1739 a_6442_4873# VPWR 0.09586f
C1740 a_9156_12528# a_9675_12332# 0.34114f
C1741 a_2232_13916# a_2298_14020# 0.03308f
C1742 _148_.B a_12886_13350# 0.12437f
C1743 _124_.S a_2532_12223# 0.02032f
C1744 a_5468_12508# VPWR 0.20677f
C1745 a_6389_9484# _178_.B1 0.03015f
C1746 a_17120_11546# VPWR 0.06817f
C1747 _133_.B a_12549_12189# 0.25335f
C1748 a_3045_3911# _243_.CLK 0.25319f
C1749 _139_.X _148_.A 0.05724f
C1750 _207_.Y _206_.Y 0.21921f
C1751 _133_.B _129_.B1 0.03669f
C1752 a_9424_16238# _258_.RESET_B 0.09868f
C1753 _147_.B1 VPWR 0.30956f
C1754 fanout6.A _222_.A 0.25034f
C1755 _199_.Y _204_.X 0.34124f
C1756 a_8488_8436# VPWR 0.22293f
C1757 a_2126_17774# a_2232_17770# 0.43036f
C1758 _224_.Y _251_.CLK 0.01267f
C1759 _143_.A VPWR 1.04793f
C1760 a_14820_11464# a_15697_11813# 0.01835f
C1761 a_15237_11471# a_15108_11885# 0.01562f
C1762 a_2232_15428# a_2558_15532# 0.02726f
C1763 a_4512_17547# fanout8.A 0.01691f
C1764 a_3407_16823# VPWR 0.1847f
C1765 _128_.B1 _133_.Y 0.27777f
C1766 _225_.A _148_.A 0.02278f
C1767 _191_.Y VPWR 0.74016f
C1768 a_9156_14040# a_9444_13735# 0.43707f
C1769 _240_.Y a_10218_17044# 0.02574f
C1770 a_9551_16823# VPWR 0.17263f
C1771 a_7985_7728# VPWR 0.22043f
C1772 _173_.A a_2436_9504# 0.0197f
C1773 _225_.A _252_.D 0.0596f
C1774 _144_.B a_10592_5498# 0.01168f
C1775 a_13290_17044# VPWR 0.38085f
C1776 a_14314_15457# _135_.A 0.01216f
C1777 a_2436_9504# VPWR 0.08921f
C1778 a_13073_7728# _157_.Y 0.04081f
C1779 a_13323_16007# VPWR 0.18538f
C1780 a_12128_5498# VPWR 0.08282f
C1781 _193_.Y a_6958_13764# 0.24788f
C1782 _234_.Y _126_.Y 0.14896f
C1783 _215_.A a_1580_12936# 0.27896f
C1784 _131_.A2 a_14357_12972# 0.05457f
C1785 a_13073_5770# _151_.B 0.22469f
C1786 _250_.RESET_B _222_.Y 0.27117f
C1787 a_2232_13916# clkload0.Y 0.10086f
C1788 a_3300_4968# VPWR 0.08986f
C1789 a_6483_9212# _173_.Y 0.01223f
C1790 _118_.A0 _222_.Y 0.50553f
C1791 a_10672_13942# a_11082_14020# 0.10373f
C1792 _227_.Y VPWR 1.39764f
C1793 _154_.X VPWR 0.73935f
C1794 a_9444_12223# a_9156_12528# 0.43707f
C1795 a_3380_13690# VPWR 2.08017f
C1796 _124_.S a_2436_9504# 0.02838f
C1797 _168_.A _172_.Y 0.01649f
C1798 _166_.A VPWR 1.36491f
C1799 a_11846_12210# a_12549_12189# 0.02454f
C1800 a_2122_15964# a_2565_16007# 0.02242f
C1801 a_1862_16434# a_2436_16421# 0.31978f
C1802 _126_.Y _260_.CLK 0.10962f
C1803 a_14534_9186# VPWR 0.77386f
C1804 _232_.Y fanout7.A 0.01076f
C1805 _122_.X _218_.Y 0.19602f
C1806 _173_.A _122_.A0 0.88433f
C1807 _122_.A0 VPWR 1.80071f
C1808 a_9734_9186# _251_.CLK 0.05439f
C1809 _119_.A0 a_5084_12972# 0.01008f
C1810 a_2126_7864# a_2298_7972# 0.01057f
C1811 _134_.Y VPWR 0.52672f
C1812 _213_.Y _227_.Y 0.0282f
C1813 _168_.A a_6184_8522# 0.01617f
C1814 _133_.Y _126_.B1 0.08389f
C1815 _225_.A a_14698_5380# 0.02611f
C1816 a_15141_12189# a_15243_12332# 0.47622f
C1817 _210_.A a_6747_5468# 0.26466f
C1818 _192_.C _192_.B 0.39413f
C1819 a_14940_16710# VPWR 0.07649f
C1820 _151_.X _149_.A 0.0722f
C1821 _241_.Y a_11364_17064# 0.40213f
C1822 a_11338_16969# a_11781_16725# 0.02242f
C1823 a_8709_16725# VPWR 0.23377f
C1824 _225_.A a_12804_16000# 0.02351f
C1825 a_8156_14020# _194_.X 0.09999f
C1826 a_1862_16746# a_2148_17064# 0.41329f
C1827 _171_.A a_8014_8492# 0.0602f
C1828 a_12778_15964# a_13221_16007# 0.02242f
C1829 a_12132_12528# a_13391_12287# 0.01529f
C1830 a_2148_16000# a_3407_16357# 0.01529f
C1831 a_3300_5416# _243_.CLK 0.09562f
C1832 a_10539_17519# a_11279_17869# 0.26905f
C1833 _213_.Y a_14534_9186# 0.28999f
C1834 _173_.Y a_5242_8806# 0.01575f
C1835 _154_.X a_10752_7989# 0.33678f
C1836 _138_.Y _243_.Q 1.09285f
C1837 a_6442_4873# a_6182_4650# 0.75507f
C1838 _240_.Y a_10437_17519# 0.03468f
C1839 a_9424_16238# a_9834_15996# 0.10373f
C1840 a_10415_12287# a_10672_12430# 0.34468f
C1841 _124_.S _122_.A0 1.43769f
C1842 _210_.B _210_.Y 0.06491f
C1843 _136_.A _168_.B 0.75339f
C1844 _119_.A0 _189_.X 0.02272f
C1845 _166_.A a_10752_7989# 0.13313f
C1846 _176_.A a_9675_12332# 0.02628f
C1847 _209_.Y _258_.RESET_B 0.1042f
C1848 _120_.A0 _187_.Y 0.64797f
C1849 a_15243_12332# a_16240_12430# 0.02979f
C1850 _166_.A a_17120_8522# 0.01342f
C1851 _180_.X a_11536_9406# 0.01553f
C1852 a_2126_11726# _120_.X 0.22282f
C1853 _243_.Q a_10940_3900# 0.01089f
C1854 _241_.Y a_12623_16823# 0.13313f
C1855 a_2667_16868# _247_.CLK 0.01437f
C1856 a_2232_7868# _122_.X 0.01147f
C1857 _230_.Y a_9156_14040# 0.39816f
C1858 _236_.A _237_.Y 0.08362f
C1859 a_12132_12528# a_13009_12231# 0.01835f
C1860 a_12651_12332# a_12420_12223# 0.12701f
C1861 _225_.A _214_.A 0.14014f
C1862 a_3664_16238# a_4074_15996# 0.10373f
C1863 _250_.D _250_.RESET_B 0.09392f
C1864 _158_.Y a_13403_8436# 0.16188f
C1865 a_3819_5423# _243_.CLK 0.04023f
C1866 a_7872_5451# a_8538_5375# 0.01061f
C1867 _205_.Y VPWR 0.55225f
C1868 _118_.A0 _250_.D 0.11898f
C1869 _225_.A a_15012_12223# 0.02086f
C1870 a_10769_4258# a_10940_3900# 0.37141f
C1871 a_9424_16238# a_9484_16119# 0.01042f
C1872 _174_.Y a_6124_9945# 0.20118f
C1873 a_10415_12287# a_10321_12287# 0.28931f
C1874 _162_.B _157_.Y 0.82578f
C1875 _251_.CLK VPWR 3.31826f
C1876 a_2126_17774# VPWR 0.11014f
C1877 a_5792_4782# VPWR 0.06948f
C1878 a_16240_12430# a_16300_12525# 0.01042f
C1879 a_15983_12287# a_16650_12508# 0.0894f
C1880 _180_.X a_11185_9263# 0.01197f
C1881 a_3695_9263# _219_.Y 0.13292f
C1882 _148_.B _164_.Y 0.11714f
C1883 _119_.A0 a_4456_13058# 0.03214f
C1884 a_15339_9308# _260_.RESET_B 0.42048f
C1885 _207_.A1 _208_.X 1.5967f
C1886 fanout6.A a_11364_17064# 0.03572f
C1887 _235_.Y _131_.B1 0.05307f
C1888 _138_.Y a_9322_4873# 0.01009f
C1889 a_6336_11499# _178_.B1 0.19474f
C1890 a_3300_5416# _148_.A 0.0146f
C1891 rst VPWR 0.15896f
C1892 a_15243_5423# a_15601_5414# 0.02138f
C1893 _129_.Y _131_.A2 0.66363f
C1894 a_2126_11726# a_1952_11546# 0.01107f
C1895 _213_.Y _251_.CLK 0.15724f
C1896 a_2126_17774# _124_.S 0.11828f
C1897 _240_.Y a_10539_17519# 0.42054f
C1898 a_2150_8874# a_2410_8404# 0.75507f
C1899 _236_.Y a_16079_11821# 0.13297f
C1900 _166_.A a_10895_8436# 0.02993f
C1901 a_10437_9165# a_10897_9482# 0.01483f
C1902 _125_.A1 _148_.A 0.01823f
C1903 a_15141_12189# VPWR 0.22401f
C1904 _189_.X _192_.C 0.05947f
C1905 _225_.A _260_.CLK 0.274f
C1906 a_13740_5678# a_13775_5782# 0.33493f
C1907 en sclk 0.14967f
C1908 _168_.Y _173_.Y 0.02696f
C1909 a_8156_14020# VPWR 0.20684f
C1910 a_1862_16746# VPWR 0.77673f
C1911 _222_.A _209_.Y 0.56094f
C1912 a_16396_9501# _260_.RESET_B 0.01227f
C1913 a_10415_12287# VPWR 0.17765f
C1914 fanout6.A a_12623_16823# 0.01664f
C1915 a_14534_8874# a_15237_8447# 0.02432f
C1916 a_13041_5412# VPWR 0.0107f
C1917 a_2661_12189# a_3121_12506# 0.01483f
C1918 _243_.Q a_11661_4696# 0.10859f
C1919 _186_.Y _193_.Y 1.06266f
C1920 a_16650_5412# a_17032_5498# 0.01012f
C1921 a_2342_4338# VPWR 0.78922f
C1922 a_13973_7678# _145_.X 0.01234f
C1923 a_2436_8440# a_2724_8861# 0.43707f
C1924 _243_.CLK _215_.Y 0.08586f
C1925 _240_.Y a_10897_17510# 0.01491f
C1926 _244_.RESET_B VPWR 1.42798f
C1927 _178_.B1 _176_.A 0.04445f
C1928 fanout6.A _207_.Y 0.65492f
C1929 _145_.X _151_.B 0.67588f
C1930 a_10539_9308# a_11279_9263# 0.26905f
C1931 a_2126_10214# a_2620_10318# 0.01625f
C1932 a_16240_12430# VPWR 0.15857f
C1933 a_2126_13912# a_2298_14020# 0.01057f
C1934 a_3952_9406# a_4362_9484# 0.10373f
C1935 _148_.B _145_.X 0.01797f
C1936 a_2565_12983# _247_.CLK 0.28437f
C1937 _124_.S a_1862_16746# 0.02926f
C1938 _124_.S a_2436_16421# 0.02635f
C1939 _133_.B _126_.Y 0.03926f
C1940 _207_.Y a_4625_16800# 0.30015f
C1941 a_4144_4142# a_4554_3900# 0.10373f
C1942 _206_.Y a_4928_16082# 0.02758f
C1943 fanout6.A a_11652_16759# 0.011f
C1944 a_9348_4968# a_9867_4772# 0.34114f
C1945 a_14820_8440# a_15339_8447# 0.34102f
C1946 a_15237_8447# a_15697_8789# 0.02396f
C1947 _147_.A1 _225_.Y 0.01825f
C1948 _210_.A a_2398_5782# 0.09385f
C1949 a_3956_6888# _243_.CLK 1.18768f
C1950 _149_.A _148_.X 1.27739f
C1951 a_12215_7664# _157_.Y 0.01974f
C1952 a_2853_8447# a_3601_8797# 0.01058f
C1953 _190_.A _192_.Y 0.07376f
C1954 _148_.B _126_.Y 0.09351f
C1955 _181_.Y _171_.Y 0.61873f
C1956 a_10437_9165# a_11185_9263# 0.01058f
C1957 a_2148_17064# a_2436_16759# 0.43707f
C1958 a_9994_9409# _251_.CLK 0.04095f
C1959 _128_.B1 a_13978_13342# 0.01613f
C1960 _207_.A2 VPWR 0.86533f
C1961 a_3014_5850# _244_.RESET_B 0.08401f
C1962 _226_.Y a_15141_5423# 0.03687f
C1963 _166_.A _160_.X 0.60115f
C1964 a_4144_4142# a_4204_4023# 0.01042f
C1965 _215_.Y a_4816_4870# 0.10165f
C1966 a_9867_4772# a_10607_4727# 0.26905f
C1967 a_15339_8447# a_16079_8797# 0.26905f
C1968 a_2075_4692# a_2301_4948# 0.02726f
C1969 a_3760_12430# a_4170_12508# 0.10373f
C1970 _148_.A a_2494_6166# 0.10373f
C1971 a_2955_8447# a_3313_8438# 0.02138f
C1972 _171_.Y VPWR 0.76472f
C1973 _136_.A _165_.Y 0.25806f
C1974 _143_.A _138_.Y 0.13645f
C1975 a_4755_17508# fanout6.A 0.0138f
C1976 a_2232_11722# _173_.A 0.14073f
C1977 a_2232_17770# _118_.A0 0.1402f
C1978 a_1862_13410# a_2148_12976# 0.41329f
C1979 a_2232_11722# VPWR 0.8921f
C1980 _210_.B _224_.Y 0.07299f
C1981 a_11946_9484# VPWR 0.38416f
C1982 _131_.A2 a_14240_13058# 0.01858f
C1983 _148_.A _148_.B 0.54799f
C1984 a_8557_4248# _145_.X 0.13871f
C1985 _250_.RESET_B a_1862_16434# 0.08975f
C1986 a_15980_7638# _251_.CLK 0.25967f
C1987 _243_.D VPWR 0.42697f
C1988 a_9765_4629# a_9636_4663# 0.01562f
C1989 _118_.A0 a_1862_16434# 0.0476f
C1990 a_14357_12972# VPWR 0.2717f
C1991 clkbuf_1_0__f_sclk.A _174_.Y 0.04675f
C1992 a_14651_10996# _131_.B1 0.02408f
C1993 _225_.A _241_.Y 0.01329f
C1994 a_10764_5678# a_10592_5498# 0.01162f
C1995 a_6810_3863# VPWR 0.21963f
C1996 a_15339_11471# a_15697_11462# 0.02138f
C1997 a_12549_7996# _157_.Y 0.08972f
C1998 _148_.A a_3956_6888# 0.01886f
C1999 _239_.Y _266_.CLK 0.02351f
C2000 _252_.D a_7984_4870# 0.02986f
C2001 a_12106_12433# a_12132_12528# 0.36952f
C2002 _126_.Y a_11846_12210# 0.27758f
C2003 a_2126_17774# a_1952_17594# 0.01107f
C2004 a_2565_12983# a_2436_13397# 0.01562f
C2005 a_2232_11722# _124_.S 0.18778f
C2006 a_2148_12976# a_3025_13325# 0.01835f
C2007 a_2667_12983# VPWR 0.18972f
C2008 a_14056_9318# VPWR 0.17032f
C2009 _144_.Y a_8557_4248# 0.26026f
C2010 _119_.A0 a_3380_13690# 0.08551f
C2011 _236_.A _131_.B1 0.03395f
C2012 _124_.S _243_.D 0.06903f
C2013 _118_.A0 a_2148_17064# 0.04709f
C2014 a_5297_12264# _176_.B 0.22394f
C2015 a_9248_7806# VPWR 0.0866f
C2016 a_8325_16007# fanout7.A 0.26303f
C2017 _168_.A a_9734_9186# 0.01792f
C2018 a_16746_11460# a_17120_11546# 0.01061f
C2019 _214_.A _241_.Y 0.06595f
C2020 _160_.X _251_.CLK 0.01471f
C2021 _215_.A _243_.CLK 0.8382f
C2022 _225_.A _133_.B 0.17809f
C2023 _199_.Y _200_.Y 0.28368f
C2024 _124_.S a_2667_12983# 0.03918f
C2025 a_2667_12983# a_3664_13214# 0.03061f
C2026 a_14698_12433# _131_.A2 0.01326f
C2027 _144_.Y a_9290_3900# 0.01543f
C2028 _214_.Y a_9994_17476# 0.01845f
C2029 _191_.Y _192_.C 0.23726f
C2030 a_14054_15234# VPWR 0.77532f
C2031 _148_.B _187_.Y 0.71167f
C2032 a_11661_4696# _147_.B1 0.10688f
C2033 _151_.X _145_.X 0.33847f
C2034 _225_.A _148_.B 0.02564f
C2035 _207_.A1 a_8006_16746# 0.02079f
C2036 _136_.A _171_.A 0.26399f
C2037 a_9167_16357# fanout7.A 0.04627f
C2038 a_13100_13686# fanout7.A 0.01108f
C2039 a_2126_7864# _122_.X 0.20454f
C2040 _225_.A fanout6.A 0.18975f
C2041 _124_.S a_2436_16759# 0.02635f
C2042 fanout6.A a_12804_16000# 0.0294f
C2043 _168_.A _181_.Y 0.01877f
C2044 _199_.B1 VPWR 0.76448f
C2045 a_15237_11471# VPWR 0.22742f
C2046 _250_.Q _222_.A 0.69116f
C2047 a_14940_16710# a_15389_16767# 0.01835f
C2048 _186_.Y _190_.A 0.03593f
C2049 _218_.Y a_2955_8447# 0.42054f
C2050 _162_.B _161_.Y 0.11264f
C2051 _122_.A0 a_2853_8447# 0.0199f
C2052 a_3045_3911# _215_.Y 0.02742f
C2053 _229_.Y a_9573_12189# 0.03557f
C2054 _148_.B _120_.A0 0.5717f
C2055 a_1580_16710# _118_.X 0.05089f
C2056 a_5226_5412# VPWR 0.38472f
C2057 _228_.Y a_11596_9501# 0.01227f
C2058 _119_.X _120_.A0 0.05779f
C2059 _215_.A a_4816_4870# 0.01302f
C2060 a_3274_5380# a_3717_5423# 0.02242f
C2061 a_8538_5375# _148_.A 0.0104f
C2062 a_11883_16868# a_12241_17042# 0.02138f
C2063 _136_.A a_6468_4968# 0.01478f
C2064 _225_.Y a_10225_4946# 0.01494f
C2065 _168_.A VPWR 1.01298f
C2066 _148_.A _215_.A 0.12168f
C2067 fanout6.A _214_.A 0.46753f
C2068 a_11536_17750# a_11596_17631# 0.01042f
C2069 a_1192_17508# fanout8.A 0.24695f
C2070 clkbuf_1_0__f_sclk.A a_5297_12264# 0.07343f
C2071 _148_.B _206_.Y 0.02784f
C2072 _145_.A2 a_8115_5412# 0.01104f
C2073 _250_.RESET_B VPWR 1.4266f
C2074 _218_.Y a_3313_8438# 0.01491f
C2075 _138_.Y _251_.CLK 0.05903f
C2076 _210_.A _243_.CLK 0.17416f
C2077 _148_.B _234_.Y 0.13092f
C2078 _122_.A0 a_4362_8436# 0.13431f
C2079 _118_.A0 VPWR 1.68789f
C2080 _210_.B VPWR 0.55193f
C2081 a_3313_9207# a_2436_9504# 0.01835f
C2082 fanout6.A _206_.Y 0.27882f
C2083 a_2724_9199# a_2955_9308# 0.12701f
C2084 a_13969_16357# _135_.A 0.01733f
C2085 _129_.Y VPWR 0.16931f
C2086 _187_.Y a_6779_12972# 0.04786f
C2087 a_14054_15234# a_14340_15552# 0.41329f
C2088 a_14314_15457# a_14757_15213# 0.02242f
C2089 a_3717_5423# a_4177_5765# 0.02396f
C2090 a_3300_5416# a_3819_5423# 0.34102f
C2091 _179_.Y a_8501_10702# 0.02385f
C2092 _133_.B _260_.CLK 0.21039f
C2093 a_14534_11898# a_14794_11428# 0.75507f
C2094 a_14724_12528# _131_.B1 0.04349f
C2095 a_12328_7010# _162_.B 0.02241f
C2096 fanout7.A a_16336_8678# 0.01012f
C2097 _124_.S _250_.RESET_B 0.02024f
C2098 _144_.B a_10764_5678# 0.193f
C2099 _199_.Y _186_.Y 0.35732f
C2100 _147_.A1 VPWR 0.64739f
C2101 a_7451_14484# _202_.Y 0.15782f
C2102 _157_.Y _158_.Y 0.19529f
C2103 _118_.A0 _124_.S 0.3128f
C2104 _221_.Y a_2122_12940# 0.25307f
C2105 a_14724_5416# a_15012_5837# 0.43707f
C2106 _221_.Y VPWR 1.41418f
C2107 fanout6.A a_4928_16082# 0.01789f
C2108 a_2126_10214# _246_.D 0.20454f
C2109 a_16936_7806# VPWR 0.13364f
C2110 _128_.B1 _131_.A2 0.25818f
C2111 a_2410_9409# a_2853_9165# 0.02242f
C2112 a_2150_9186# a_2436_9504# 0.41329f
C2113 a_9130_13945# VPWR 0.09739f
C2114 _180_.X a_8603_9484# 0.03313f
C2115 _225_.A a_8538_5375# 0.04116f
C2116 _234_.Y a_11846_12210# 0.13768f
C2117 _210_.A _148_.A 0.15101f
C2118 _195_.Y a_5333_15532# 0.03987f
C2119 _221_.Y a_3664_13214# 0.09873f
C2120 a_15141_5423# a_15889_5773# 0.01058f
C2121 _124_.S _221_.Y 0.04193f
C2122 a_7985_7728# a_8156_7972# 0.37141f
C2123 a_14340_15552# a_14628_15247# 0.43707f
C2124 a_3819_5423# a_4177_5414# 0.02138f
C2125 _186_.Y _178_.B1 0.03242f
C2126 a_2955_9308# _243_.CLK 0.01463f
C2127 a_7008_16035# a_7157_16366# 0.33493f
C2128 _235_.Y a_15141_12189# 0.03508f
C2129 a_14063_16357# a_13969_16357# 0.28931f
C2130 _225_.A _151_.X 0.15639f
C2131 a_3014_4650# a_3300_4968# 0.41329f
C2132 a_3274_4873# a_3717_4629# 0.02242f
C2133 _148_.X _145_.X 0.07893f
C2134 _139_.X a_10607_4727# 0.03031f
C2135 _136_.A _243_.Q 4.57876f
C2136 a_12572_4948# a_12401_4704# 0.37141f
C2137 _204_.X _201_.Y 0.16746f
C2138 _120_.A0 _215_.A 0.03772f
C2139 _168_.A a_9994_9409# 0.01749f
C2140 _247_.CLK a_2244_12528# 0.06711f
C2141 _122_.A0 a_2150_9186# 0.02427f
C2142 _243_.CLK a_3819_4772# 0.05519f
C2143 _125_.A1 _215_.Y 0.02207f
C2144 a_8156_7972# _154_.X 0.10069f
C2145 _120_.A0 a_2661_12189# 0.02382f
C2146 a_8292_17064# a_9551_16823# 0.01529f
C2147 a_12132_12528# _133_.Y 0.04792f
C2148 _174_.Y VPWR 0.73952f
C2149 a_15697_8438# _227_.Y 0.01491f
C2150 _136_.A a_10769_4258# 0.33055f
C2151 a_15856_15454# a_16266_15532# 0.10373f
C2152 a_16936_7010# VPWR 0.13326f
C2153 _214_.Y VPWR 0.52481f
C2154 a_14359_16710# a_14572_16746# 0.34468f
C2155 _239_.Y VPWR 1.43513f
C2156 _131_.A2 _126_.B1 3.24037f
C2157 _235_.Y a_16240_12430# 0.10165f
C2158 _207_.A1 _232_.Y 0.08217f
C2159 a_12651_12332# VPWR 0.18463f
C2160 a_13000_8522# VPWR 0.13407f
C2161 a_14240_13058# VPWR 0.08058f
C2162 _226_.Y _149_.A 0.04664f
C2163 a_8156_7972# _122_.A0 0.01008f
C2164 a_13820_4948# a_13649_4704# 0.37141f
C2165 a_8288_3986# VPWR 0.07362f
C2166 _148_.B _182_.Y 0.2972f
C2167 a_12904_7010# _153_.Y 0.03764f
C2168 a_2232_15428# VPWR 0.89779f
C2169 _193_.Y _194_.X 0.04997f
C2170 a_12549_7996# _161_.Y 0.10779f
C2171 a_14794_9409# a_14534_9186# 0.75507f
C2172 _178_.B1 a_6124_9945# 0.21813f
C2173 _178_.Y _185_.Y 0.21427f
C2174 _162_.Y _148_.B 0.17188f
C2175 _120_.A0 a_3760_12430# 0.01591f
C2176 a_8811_16868# a_8580_16759# 0.12701f
C2177 a_8292_17064# a_9169_16767# 0.01835f
C2178 a_5201_9240# a_5372_9484# 0.37141f
C2179 _236_.A _134_.Y 0.14772f
C2180 a_13391_12287# _133_.Y 0.01432f
C2181 _210_.B a_6182_4650# 0.03662f
C2182 _266_.CLK a_14919_16964# 0.01597f
C2183 _148_.A a_2298_7678# 0.01906f
C2184 a_2628_3904# _243_.RESET_B 0.38585f
C2185 a_12808_13854# VPWR 0.14827f
C2186 a_2232_10210# _122_.A0 0.14661f
C2187 a_3819_4772# a_4816_4870# 0.02979f
C2188 a_1864_5498# VPWR 0.14807f
C2189 _225_.A _135_.A 0.22402f
C2190 _215_.A a_2398_4654# 0.01182f
C2191 _132_.Y _129_.B1 0.04788f
C2192 _170_.B VPWR 0.85153f
C2193 a_12992_15437# _134_.Y 0.25465f
C2194 a_12704_11546# _126_.B1 0.01747f
C2195 _135_.A a_12804_16000# 0.02321f
C2196 a_15983_5773# VPWR 0.18523f
C2197 a_10737_3900# VPWR 0.01074f
C2198 _119_.A0 a_2667_12983# 0.01781f
C2199 a_2232_15428# _124_.S 0.17891f
C2200 _243_.Q _143_.Y 0.01363f
C2201 fanout6.A _241_.Y 0.03663f
C2202 a_13740_5678# VPWR 0.23509f
C2203 a_15237_9165# a_15697_9482# 0.01483f
C2204 _171_.A _185_.Y 0.16459f
C2205 _228_.Y a_9928_8522# 0.02424f
C2206 _208_.X VPWR 0.37051f
C2207 _168_.B _168_.Y 0.06816f
C2208 a_6885_4629# a_7345_4946# 0.01483f
C2209 a_11168_16082# VPWR 0.08273f
C2210 _196_.Y _189_.X 0.12379f
C2211 a_2436_8440# VPWR 0.08938f
C2212 _266_.CLK _211_.Y 0.04777f
C2213 a_8292_17064# a_8709_16725# 0.3749f
C2214 a_8006_16746# a_8811_16868# 0.097f
C2215 a_4144_4142# _243_.RESET_B 0.09889f
C2216 a_7074_15532# _205_.Y 0.16096f
C2217 _264_.Q _211_.Y 0.08414f
C2218 _250_.Q _207_.Y 0.14027f
C2219 a_1864_5498# _124_.S 0.01636f
C2220 a_14698_12433# VPWR 0.09615f
C2221 _157_.B a_13740_5678# 0.19247f
C2222 _239_.Y a_14340_15552# 0.39752f
C2223 a_15237_8447# VPWR 0.22657f
C2224 _236_.Y a_14794_11428# 0.2508f
C2225 _207_.A1 a_6720_17061# 0.01052f
C2226 a_14534_9186# a_15108_9199# 0.31978f
C2227 freq_in VPWR 0.28705f
C2228 _220_.Y a_3121_12506# 0.01491f
C2229 a_14438_12210# _131_.A2 0.03296f
C2230 a_6987_4772# a_7984_4870# 0.02979f
C2231 _124_.S a_2436_8440# 0.02788f
C2232 _210_.B a_6756_4663# 0.01179f
C2233 a_3695_8797# VPWR 0.19228f
C2234 a_10020_9504# _164_.Y 0.01288f
C2235 _178_.B1 _176_.B 0.10451f
C2236 _226_.Y a_16240_5654# 0.09868f
C2237 _178_.B1 a_3886_10702# 0.01009f
C2238 _229_.Y _182_.Y 0.14499f
C2239 a_14820_11464# _131_.B1 0.01345f
C2240 a_3300_5416# _215_.A 0.02732f
C2241 a_16746_8436# VPWR 0.37857f
C2242 a_5297_12264# VPWR 0.21537f
C2243 a_16936_7806# a_17120_7806# 0.0524f
C2244 _219_.Y a_2436_9504# 0.41094f
C2245 a_16079_11821# VPWR 0.17105f
C2246 _193_.Y VPWR 0.81371f
C2247 a_14063_16357# a_12804_16000# 0.01529f
C2248 _210_.A a_2398_4654# 0.50585f
C2249 a_9130_13945# a_8870_13722# 0.75507f
C2250 a_16336_9406# a_16746_9484# 0.10373f
C2251 _125_.A1 _215_.A 0.29507f
C2252 _164_.B1 VPWR 0.79863f
C2253 a_11274_4948# VPWR 0.38319f
C2254 a_9269_9190# _164_.Y 0.02749f
C2255 fanout6.A a_4625_16800# 0.0565f
C2256 _179_.Y a_7157_9948# 0.05106f
C2257 a_8870_12210# a_9573_12189# 0.02454f
C2258 _166_.A _157_.Y 0.09136f
C2259 _222_.A _118_.X 0.16343f
C2260 _136_.A _147_.B1 0.3048f
C2261 a_4552_12342# VPWR 0.15033f
C2262 _136_.A a_8488_8436# 0.25434f
C2263 _266_.CLK a_13221_16007# 0.2732f
C2264 a_9573_13701# a_10033_14018# 0.01483f
C2265 _171_.Y a_8014_8492# 0.24729f
C2266 _136_.A _143_.A 1.4989f
C2267 _119_.A0 _118_.A0 0.33692f
C2268 _122_.A0 _219_.Y 0.20329f
C2269 a_11781_16725# VPWR 0.23855f
C2270 a_17120_8522# a_16746_8436# 0.01061f
C2271 _148_.B a_11846_12210# 0.03599f
C2272 fanout6.A a_7908_16000# 0.03186f
C2273 a_1864_15366# _118_.X 0.03499f
C2274 _143_.A _145_.A2 0.52895f
C2275 _232_.Y a_9808_16966# 0.10178f
C2276 a_5608_4782# a_5792_4782# 0.0524f
C2277 a_6656_5498# VPWR 0.09161f
C2278 _136_.A a_7985_7728# 0.36628f
C2279 a_14534_11898# a_15339_11471# 0.097f
C2280 a_2126_15424# a_2558_15532# 0.02903f
C2281 _145_.X _162_.B 0.01526f
C2282 _125_.A1 sdata 0.09496f
C2283 _212_.Y _266_.CLK 0.08129f
C2284 a_3147_3911# _243_.CLK 0.01453f
C2285 _178_.B1 clkbuf_1_0__f_sclk.A 0.05106f
C2286 a_5372_9484# _173_.A 0.01577f
C2287 a_9675_13844# a_10672_13942# 0.02979f
C2288 a_5372_9484# VPWR 0.20677f
C2289 a_14058_12508# _129_.Y 0.02433f
C2290 _210_.A a_3300_5416# 0.01062f
C2291 _191_.Y _202_.Y 0.21248f
C2292 _173_.A a_2410_9409# 0.01473f
C2293 _144_.B a_8564_5412# 0.01421f
C2294 a_12880_16966# VPWR 0.1602f
C2295 a_2410_9409# VPWR 0.09818f
C2296 _128_.B1 VPWR 0.56671f
C2297 _225_.A a_10020_17512# 0.04317f
C2298 _190_.A _194_.X 0.04619f
C2299 a_12237_5760# VPWR 0.4102f
C2300 a_10437_17519# a_10539_17519# 0.47795f
C2301 _210_.A _125_.A1 0.4057f
C2302 _238_.Y a_14572_16746# 0.09868f
C2303 _136_.A _154_.X 0.09187f
C2304 a_2494_6166# _215_.A 0.0112f
C2305 a_14820_11464# a_15985_11821# 0.43239f
C2306 a_7882_15964# a_8325_16007# 0.02242f
C2307 a_14432_10830# VPWR 0.09455f
C2308 a_2398_5782# _244_.D 0.01464f
C2309 a_3274_4873# VPWR 0.11035f
C2310 _202_.Y a_7157_16366# 0.01023f
C2311 _215_.A _215_.Y 1.96415f
C2312 _199_.B1 a_5525_16750# 0.04952f
C2313 a_6862_15532# VPWR 0.25187f
C2314 a_13130_4948# _157_.Y 0.01677f
C2315 _235_.Y _129_.Y 0.08501f
C2316 _243_.D a_3014_4650# 0.03995f
C2317 a_10672_12430# a_9675_12332# 0.02979f
C2318 _143_.A _143_.Y 0.11491f
C2319 a_15141_5423# _251_.CLK 0.282f
C2320 a_7953_7996# VPWR 0.01061f
C2321 _129_.Y a_13883_11460# 0.15731f
C2322 _124_.S a_2410_9409# 0.02451f
C2323 _136_.A _122_.A0 0.44179f
C2324 _168_.Y _165_.Y 0.20582f
C2325 a_1862_16434# a_2565_16007# 0.02432f
C2326 a_10437_17519# a_10897_17510# 0.01483f
C2327 _196_.Y _191_.Y 0.04366f
C2328 _180_.X a_11731_8698# 0.17607f
C2329 _120_.A0 _120_.X 0.05727f
C2330 _132_.Y a_13804_10996# 0.01284f
C2331 _145_.X _159_.Y 0.14536f
C2332 _151_.X _151_.B 0.04668f
C2333 _148_.B _195_.Y 0.21032f
C2334 a_16936_7010# a_17120_7010# 0.0524f
C2335 _173_.A a_2126_10214# 0.12557f
C2336 _232_.Y a_8811_16868# 0.4215f
C2337 a_8325_16007# a_8427_16007# 0.47795f
C2338 a_14438_5850# a_14724_5416# 0.41329f
C2339 a_2126_10214# VPWR 0.11164f
C2340 _164_.B1 a_10895_8436# 0.07791f
C2341 a_12424_15366# VPWR 0.16967f
C2342 a_14438_12210# a_15243_12332# 0.097f
C2343 a_14724_12528# a_15141_12189# 0.3749f
C2344 _195_.Y fanout6.A 0.03565f
C2345 _133_.B a_15697_11813# 0.01093f
C2346 a_15237_9165# _260_.CLK 0.26116f
C2347 _180_.X a_10437_9165# 0.01109f
C2348 a_14919_16964# VPWR 0.18699f
C2349 a_11338_16969# a_11078_16746# 0.75507f
C2350 a_8006_16746# VPWR 0.77417f
C2351 _126_.B1 VPWR 0.93778f
C2352 a_12651_12332# a_13009_12506# 0.02138f
C2353 a_12518_16434# a_13221_16007# 0.02432f
C2354 a_2148_16000# a_2667_16007# 0.34102f
C2355 a_2565_16007# a_3025_16349# 0.02396f
C2356 fanout6.A _135_.X 0.02307f
C2357 _196_.Y a_5906_15242# 0.01044f
C2358 a_13000_8522# a_13184_8522# 0.0524f
C2359 _207_.A2 a_5376_17061# 0.38043f
C2360 _173_.Y _184_.Y 0.23121f
C2361 _228_.Y _164_.Y 0.04326f
C2362 a_8427_16007# a_9167_16357# 0.26905f
C2363 _124_.S a_2126_10214# 0.1294f
C2364 a_8325_16007# a_8785_15998# 0.01483f
C2365 a_9160_17594# VPWR 0.14388f
C2366 _240_.Y a_9994_17476# 0.25711f
C2367 a_2126_7864# a_2620_7678# 0.01625f
C2368 _176_.A a_9156_12528# 0.02745f
C2369 a_2232_15428# _119_.A0 0.10761f
C2370 _209_.Y a_6869_16750# 0.03944f
C2371 _149_.A a_17032_5498# 0.02925f
C2372 _210_.A a_6987_4772# 0.01454f
C2373 a_2398_5782# _243_.Q 0.03546f
C2374 a_14794_11428# _131_.A2 0.02671f
C2375 _147_.A1 a_11661_4696# 0.08626f
C2376 _211_.Y VPWR 0.44488f
C2377 _190_.A VPWR 0.96939f
C2378 fanout7.A a_17120_9318# 0.01522f
C2379 _136_.A _251_.CLK 0.04467f
C2380 _210_.A _215_.Y 0.14357f
C2381 clkload0.Y VPWR 0.18969f
C2382 _230_.Y a_9130_13945# 0.26443f
C2383 a_2148_17064# _247_.CLK 0.08837f
C2384 a_12804_16000# a_13681_16349# 0.01835f
C2385 a_13221_16007# a_13092_16421# 0.01562f
C2386 a_2565_16725# a_3025_17042# 0.01483f
C2387 a_12132_12528# a_12420_12223# 0.43707f
C2388 a_2667_16007# a_3407_16357# 0.26905f
C2389 a_10539_17519# a_10897_17510# 0.02138f
C2390 a_15012_5837# a_15243_5423# 0.12701f
C2391 _145_.A2 _251_.CLK 0.0257f
C2392 _202_.Y _205_.Y 0.0465f
C2393 a_12369_4972# VPWR 0.01089f
C2394 a_9675_12332# VPWR 0.18741f
C2395 a_6747_5468# _143_.A 0.29864f
C2396 a_15141_12189# a_15601_12231# 0.02396f
C2397 a_15983_12287# a_16240_12430# 0.34468f
C2398 a_14724_12528# a_15889_12287# 0.43239f
C2399 _168_.Y _171_.A 0.30864f
C2400 _160_.X _164_.B1 0.1033f
C2401 _225_.A _238_.Y 0.20521f
C2402 fanout6.A _135_.A 0.16754f
C2403 fanout6.A _209_.Y 0.04903f
C2404 _131_.Y a_14534_11898# 0.26618f
C2405 a_2398_5782# a_2512_5782# 0.0308f
C2406 a_2602_3868# a_3045_3911# 0.02242f
C2407 a_14820_9504# _260_.RESET_B 0.37703f
C2408 _200_.Y _201_.Y 0.11756f
C2409 a_15983_5773# a_16650_5412# 0.0894f
C2410 a_11082_12508# a_11456_12342# 0.01061f
C2411 a_13820_4948# VPWR 0.20784f
C2412 a_15983_12287# a_15889_12287# 0.28931f
C2413 _236_.Y a_15339_11471# 0.42054f
C2414 _145_.X a_11974_8436# 0.07097f
C2415 a_2126_7864# a_2232_7868# 0.43036f
C2416 a_10020_9504# a_10539_9308# 0.34114f
C2417 _189_.X a_6048_13011# 0.35517f
C2418 a_14438_12210# VPWR 0.77366f
C2419 a_2565_16007# VPWR 0.233f
C2420 _199_.Y VPWR 0.33423f
C2421 a_3045_3911# a_3147_3911# 0.47795f
C2422 a_16079_9263# _260_.RESET_B 0.13292f
C2423 a_14534_8874# a_14794_8404# 0.75507f
C2424 a_14724_5416# VPWR 0.08962f
C2425 a_11082_12508# _176_.A 0.13948f
C2426 _144_.B a_9062_4650# 0.03814f
C2427 a_2244_12528# a_2763_12332# 0.34114f
C2428 a_17120_10034# VPWR 0.0717f
C2429 a_2126_11726# a_2558_11484# 0.02903f
C2430 a_13221_16007# VPWR 0.23835f
C2431 a_2232_11722# a_2298_11484# 0.03308f
C2432 a_2436_8440# a_2853_8447# 0.37583f
C2433 _236_.A _129_.Y 0.10135f
C2434 a_11279_17869# VPWR 0.17328f
C2435 a_6336_11499# _176_.A 0.12416f
C2436 _182_.Y a_8870_12210# 0.27173f
C2437 _236_.Y a_15697_11462# 0.01491f
C2438 a_9130_12433# a_9156_12528# 0.36952f
C2439 a_2126_10214# a_1864_10034# 0.01053f
C2440 _225_.A _159_.Y 0.27167f
C2441 _166_.A _161_.Y 0.01295f
C2442 a_10020_9504# a_11279_9263# 0.01529f
C2443 a_4661_17878# _207_.A2 0.0358f
C2444 _247_.CLK VPWR 3.60032f
C2445 _124_.S a_2565_16007# 0.01173f
C2446 _148_.X _151_.B 0.7021f
C2447 _215_.A a_1376_4782# 0.01815f
C2448 a_4074_15996# VPWR 0.38893f
C2449 a_3147_3911# a_3887_4261# 0.26905f
C2450 _148_.X _148_.B 0.31233f
C2451 a_3045_3911# a_3505_3902# 0.01483f
C2452 a_14698_12433# _235_.Y 0.23749f
C2453 _215_.Y a_3819_4772# 0.42048f
C2454 a_5376_17061# _199_.B1 0.19104f
C2455 a_9062_4650# a_9765_4629# 0.02454f
C2456 a_11456_12342# _176_.A 0.01526f
C2457 _120_.A0 a_2148_12976# 0.05166f
C2458 a_14820_8440# a_15108_8861# 0.43707f
C2459 _183_.Y _171_.Y 0.40311f
C2460 a_2763_12332# a_3503_12287# 0.26905f
C2461 _215_.A sdata 0.02053f
C2462 _212_.Y VPWR 0.38735f
C2463 a_2240_3986# VPWR 0.09716f
C2464 a_2724_8861# a_2955_8447# 0.12701f
C2465 _178_.B1 VPWR 0.95909f
C2466 _120_.A0 _220_.Y 0.08411f
C2467 a_10539_9308# a_10308_9199# 0.12701f
C2468 a_10020_9504# a_10897_9207# 0.01835f
C2469 _226_.Y a_14698_5380# 0.25729f
C2470 a_4512_17547# VPWR 0.24465f
C2471 _124_.S _247_.CLK 0.56264f
C2472 _136_.A _171_.Y 0.30309f
C2473 _225_.A _226_.Y 0.62881f
C2474 _210_.A _215_.A 0.78484f
C2475 a_9348_4968# a_10607_4727# 0.01529f
C2476 a_6197_13342# _192_.C 0.03651f
C2477 a_4362_9484# _173_.A 0.13386f
C2478 a_2244_12528# a_3409_12287# 0.43239f
C2479 a_2661_12189# a_3121_12231# 0.02396f
C2480 a_13073_7728# a_13244_7972# 0.37141f
C2481 _232_.Y VPWR 1.42913f
C2482 _186_.Y _179_.Y 0.0237f
C2483 a_4362_9484# VPWR 0.38236f
C2484 _225_.A _237_.Y 0.02572f
C2485 _237_.Y a_12804_16000# 0.38128f
C2486 a_15108_11885# a_15339_11471# 0.12701f
C2487 a_4554_3900# VPWR 0.38622f
C2488 a_3695_8797# a_4362_8436# 0.0894f
C2489 _200_.Y _204_.X 0.01012f
C2490 a_7808_10034# VPWR 0.0678f
C2491 _225_.A a_14757_15213# 0.04086f
C2492 _143_.A a_7872_5451# 0.12185f
C2493 a_2126_11726# a_2232_11722# 0.43036f
C2494 _170_.B a_8014_8492# 0.01895f
C2495 a_11536_9406# VPWR 0.15848f
C2496 _240_.Y VPWR 1.48439f
C2497 _136_.A a_6810_3863# 0.0892f
C2498 _131_.A2 a_13366_13350# 0.09162f
C2499 a_9062_4650# a_9636_4663# 0.31978f
C2500 _205_.Y _258_.RESET_B 0.01586f
C2501 a_3503_12287# a_3409_12287# 0.28931f
C2502 _148_.A _244_.D 0.06918f
C2503 _168_.B _173_.Y 0.6008f
C2504 _136_.B _225_.Y 0.1433f
C2505 _243_.Q _243_.CLK 0.05435f
C2506 a_16079_11821# a_16746_11460# 0.0894f
C2507 a_3952_8678# a_4012_8559# 0.01042f
C2508 a_13073_7728# _151_.B 0.01519f
C2509 a_9573_13701# fanout7.A 0.28014f
C2510 _134_.Y a_12886_13350# 0.10537f
C2511 _236_.A _214_.Y 0.34982f
C2512 _224_.Y a_7345_4946# 0.01491f
C2513 _225_.A _228_.Y 0.09305f
C2514 a_1862_13410# a_2667_12983# 0.097f
C2515 a_13391_12287# _131_.A2 0.02901f
C2516 _145_.X _158_.Y 0.42143f
C2517 _122_.X VPWR 0.4884f
C2518 a_4559_5773# _244_.RESET_B 0.13297f
C2519 _236_.A a_12651_12332# 0.0348f
C2520 _207_.A1 a_10218_17044# 0.01521f
C2521 _132_.Y _260_.CLK 0.12627f
C2522 _131_.Y _236_.Y 0.06556f
C2523 _153_.Y VPWR 0.77494f
C2524 _243_.Q _144_.Y 0.0614f
C2525 a_10415_13799# fanout7.A 0.02579f
C2526 _178_.Y a_7624_10034# 0.02403f
C2527 _207_.A2 a_5619_17044# 0.01107f
C2528 _195_.Y a_5050_15238# 0.01646f
C2529 a_6720_17061# VPWR 0.23701f
C2530 _250_.Q fanout6.A 0.01601f
C2531 _224_.Y a_8044_4965# 0.01227f
C2532 fanout8.A _207_.A1 0.23747f
C2533 a_2148_12976# a_3313_13333# 0.43239f
C2534 _162_.Y _162_.B 0.1727f
C2535 _149_.A _251_.CLK 0.12693f
C2536 _124_.S a_2436_13397# 0.02536f
C2537 a_11381_3900# _145_.X 0.01131f
C2538 _214_.Y a_9734_17946# 0.28217f
C2539 _250_.Q a_4625_16800# 0.07945f
C2540 _176_.A a_9130_12433# 0.01605f
C2541 _215_.A a_3819_4772# 0.01436f
C2542 _228_.Y a_10539_9308# 0.42048f
C2543 a_3717_5423# VPWR 0.26933f
C2544 _168_.A _183_.Y 0.01325f
C2545 a_10408_7806# VPWR 0.1555f
C2546 _187_.Y _192_.B 0.85363f
C2547 a_8427_16007# fanout7.A 0.03507f
C2548 _222_.A _205_.Y 0.03938f
C2549 _148_.A _243_.Q 0.43562f
C2550 _227_.Y a_14820_8440# 0.41074f
C2551 _236_.A a_11168_16082# 0.02331f
C2552 _144_.B _225_.Y 0.17148f
C2553 en VPWR 0.11232f
C2554 _204_.X _186_.Y 0.23103f
C2555 _260_.RESET_B VPWR 1.46523f
C2556 a_4796_17044# VPWR 0.20772f
C2557 a_14794_11428# VPWR 0.09629f
C2558 a_3407_13333# a_3313_13333# 0.28931f
C2559 a_13244_7972# _162_.B 0.0122f
C2560 a_3724_13095# VPWR 0.01395f
C2561 a_14058_12508# _126_.B1 0.13947f
C2562 _166_.A a_14820_8440# 0.01408f
C2563 a_15697_8438# a_15237_8447# 0.01483f
C2564 _162_.B a_12512_8522# 0.01831f
C2565 _122_.A0 a_2410_8404# 0.04763f
C2566 _133_.B a_16650_12508# 0.01314f
C2567 a_4661_17878# _118_.A0 0.0116f
C2568 _136_.A _168_.A 0.24553f
C2569 _243_.Q a_4465_4727# 0.02214f
C2570 _229_.Y a_8870_12210# 0.13832f
C2571 a_2126_13912# a_2232_13916# 0.43036f
C2572 _228_.Y a_11279_9263# 0.13292f
C2573 _119_.X a_1864_13854# 0.0465f
C2574 a_4816_5654# VPWR 0.16476f
C2575 _207_.A1 fanout7.A 0.08001f
C2576 fanout8.A _222_.Y 0.0136f
C2577 a_3014_5850# a_3717_5423# 0.02432f
C2578 a_11781_16725# a_11883_16868# 0.47622f
C2579 _225_.Y a_9765_4629# 0.03505f
C2580 _227_.Y a_16079_8797# 0.13297f
C2581 _136_.A _210_.B 0.02046f
C2582 _213_.Y _260_.RESET_B 0.06533f
C2583 a_3664_13214# a_3724_13095# 0.01042f
C2584 _139_.X _243_.Q 0.06648f
C2585 _166_.A a_16079_8797# 0.01481f
C2586 _122_.A0 a_3952_8678# 0.01544f
C2587 _162_.B _151_.B 0.04003f
C2588 a_2126_10214# a_2558_9972# 0.02903f
C2589 a_2232_10210# a_2298_9972# 0.03308f
C2590 a_13883_11460# _126_.B1 0.08423f
C2591 a_16266_15532# VPWR 0.38276f
C2592 a_2126_15424# a_2298_15238# 0.0308f
C2593 _148_.B _162_.B 0.1385f
C2594 _222_.A a_1862_16746# 0.01469f
C2595 a_2724_9199# a_2436_9504# 0.43707f
C2596 _196_.Y _199_.B1 0.19419f
C2597 a_1192_7712# _125_.A1 0.24484f
C2598 _160_.X a_10989_8784# 0.02617f
C2599 a_14063_16357# _135_.A 0.04777f
C2600 _139_.X a_10769_4258# 0.23818f
C2601 _136_.A _147_.A1 0.01187f
C2602 a_14314_15457# a_14054_15234# 0.75507f
C2603 a_3300_5416# a_3588_5837# 0.43707f
C2604 a_11883_16868# a_12880_16966# 0.02979f
C2605 _215_.A _120_.X 0.12057f
C2606 _225_.Y a_10864_4870# 0.10174f
C2607 _210_.A a_3819_4772# 0.01909f
C2608 a_5376_17061# _208_.X 0.04492f
C2609 _180_.X a_9120_9501# 0.01555f
C2610 a_7328_16878# VPWR 0.08131f
C2611 a_12215_7664# _162_.Y 0.23306f
C2612 a_10592_5498# VPWR 0.08554f
C2613 _221_.Y a_1862_13410# 0.09173f
C2614 a_1864_6294# VPWR 0.13442f
C2615 a_14438_5850# a_15243_5423# 0.097f
C2616 _225_.A _158_.Y 0.05836f
C2617 _190_.A _192_.C 0.07263f
C2618 a_15776_7806# VPWR 0.08376f
C2619 a_14820_8440# _251_.CLK 0.09659f
C2620 _139_.X a_11381_3900# 0.1658f
C2621 a_14757_15213# a_15217_15530# 0.01483f
C2622 a_3717_5423# a_4465_5773# 0.01058f
C2623 a_3588_5837# a_3819_5423# 0.12701f
C2624 a_11781_16725# a_12241_16767# 0.02396f
C2625 a_12880_16966# a_12940_17061# 0.01042f
C2626 a_12623_16823# a_13290_17044# 0.0894f
C2627 a_11364_17064# a_12529_16823# 0.43239f
C2628 a_2410_9409# a_2150_9186# 0.75507f
C2629 _201_.Y _203_.Y 0.01215f
C2630 a_14820_11464# a_15237_11471# 0.37583f
C2631 a_3664_16966# a_4074_17044# 0.10373f
C2632 _166_.A _164_.Y 0.03292f
C2633 a_13973_7678# _159_.Y 0.0358f
C2634 a_10732_12525# _229_.Y 0.01229f
C2635 _185_.Y _171_.Y 0.01992f
C2636 a_12237_5760# _152_.X 0.10381f
C2637 a_9867_4772# _251_.CLK 0.05295f
C2638 a_9808_16966# a_10218_17044# 0.10373f
C2639 _133_.B _132_.Y 0.16661f
C2640 a_2494_6166# a_2397_6166# 0.01625f
C2641 _119_.A0 _247_.CLK 0.11787f
C2642 _207_.A2 _222_.A 0.03048f
C2643 fanout8.A _250_.D 0.09658f
C2644 _225_.A a_14144_8522# 0.02007f
C2645 a_14859_15356# a_15856_15454# 0.02979f
C2646 _148_.A a_12401_4704# 0.08827f
C2647 a_4559_5773# a_5226_5412# 0.0894f
C2648 a_2853_9165# a_3313_9482# 0.01483f
C2649 a_2436_9504# _243_.CLK 0.0901f
C2650 a_12623_16823# a_12529_16823# 0.28931f
C2651 _148_.B _132_.Y 0.01472f
C2652 a_14698_12433# a_14724_12528# 0.36952f
C2653 _235_.Y a_14438_12210# 0.08677f
C2654 a_14320_16238# a_14730_15996# 0.10373f
C2655 a_3274_4873# a_3014_4650# 0.75507f
C2656 _236_.A _128_.B1 0.01447f
C2657 _180_.X _172_.Y 0.02787f
C2658 _136_.A _174_.Y 0.03318f
C2659 a_6862_15532# a_7074_15532# 0.20304f
C2660 _162_.Y a_12549_7996# 0.05308f
C2661 _243_.Q a_3887_4261# 0.01787f
C2662 _243_.CLK a_3300_4968# 0.1112f
C2663 _136_.B VPWR 0.48074f
C2664 a_6958_13764# _192_.Y 0.26328f
C2665 a_17032_17594# VPWR 0.1393f
C2666 _120_.A0 a_1958_12210# 0.06502f
C2667 a_3886_10702# sclk 0.49711f
C2668 _173_.Y _178_.Y 0.7963f
C2669 a_12215_7664# _148_.B 0.04187f
C2670 a_8325_16007# VPWR 0.22347f
C2671 _148_.A _147_.B1 0.02393f
C2672 _160_.X _153_.Y 0.04751f
C2673 a_14730_15996# _266_.CLK 0.01675f
C2674 _166_.A _145_.X 0.21368f
C2675 _243_.Q a_2398_4654# 0.11134f
C2676 a_3717_4629# a_4177_4946# 0.01483f
C2677 a_14730_15996# _264_.Q 0.1193f
C2678 _168_.Y _122_.A0 0.71074f
C2679 a_12132_12528# VPWR 0.07597f
C2680 _131_.Y _131_.A2 0.02566f
C2681 _186_.Y _176_.A 0.07041f
C2682 _145_.A2 a_8288_3986# 0.01884f
C2683 a_12984_12952# VPWR 0.01847f
C2684 a_10220_18222# a_9928_18390# 0.01f
C2685 _143_.A _148_.A 0.36001f
C2686 a_7712_7806# _122_.A0 0.01768f
C2687 a_12128_4782# _147_.B1 0.0171f
C2688 a_7262_3900# VPWR 0.01082f
C2689 a_13366_13350# VPWR 0.01153f
C2690 _222_.Y a_2667_16868# 0.42048f
C2691 a_2126_15424# VPWR 0.1102f
C2692 _122_.A0 _243_.CLK 0.05347f
C2693 fanout6.A _237_.Y 0.09188f
C2694 _164_.Y _251_.CLK 0.06101f
C2695 _145_.A2 a_8021_5782# 0.01132f
C2696 _136_.A _170_.B 0.35101f
C2697 _143_.A _252_.D 0.19607f
C2698 a_8292_17064# a_8580_16759# 0.43707f
C2699 _260_.CLK _131_.B1 2.05967f
C2700 _236_.A a_12424_15366# 0.02057f
C2701 a_9167_16357# VPWR 0.17342f
C2702 a_6747_5468# _210_.B 0.17783f
C2703 fanout7.A _131_.A2 0.24021f
C2704 a_13100_13686# VPWR 0.28706f
C2705 a_2126_10214# a_2232_10210# 0.43036f
C2706 a_12128_5498# _148_.A 0.02001f
C2707 a_13391_12287# VPWR 0.1737f
C2708 a_2075_5468# VPWR 0.86656f
C2709 _236_.A _126_.B1 0.24237f
C2710 _148_.B _171_.A 0.24508f
C2711 a_15243_5423# VPWR 0.19189f
C2712 _119_.A0 a_2436_13397# 0.01907f
C2713 a_2126_15424# _124_.S 0.13123f
C2714 _120_.A0 a_2532_12223# 0.01864f
C2715 a_14820_9504# a_15339_9308# 0.34114f
C2716 a_6468_4968# a_6987_4772# 0.34114f
C2717 _168_.B a_5800_9318# 0.05331f
C2718 a_15071_17016# a_15767_17137# 0.02432f
C2719 _144_.B VPWR 0.83384f
C2720 a_15985_8797# a_15237_8447# 0.01058f
C2721 _148_.B a_11974_8436# 0.01159f
C2722 a_8006_16746# a_8292_17064# 0.41329f
C2723 a_8266_16969# a_8709_16725# 0.02242f
C2724 _236_.A _190_.A 0.56407f
C2725 a_3717_4629# a_4177_4671# 0.02396f
C2726 a_2075_5468# _124_.S 0.17864f
C2727 a_3300_4968# a_4465_4727# 0.43239f
C2728 a_14794_8404# VPWR 0.09426f
C2729 _239_.Y a_14314_15457# 0.2446f
C2730 a_2763_12332# VPWR 0.19287f
C2731 a_15980_7638# a_15776_7806# 0.01048f
C2732 a_8603_9484# _181_.Y 0.15644f
C2733 _162_.Y a_12652_6924# 0.01398f
C2734 _215_.A _220_.Y 0.14819f
C2735 a_17120_3270# VPWR 0.08585f
C2736 _222_.A _199_.B1 0.01404f
C2737 _236_.Y a_14534_11898# 0.10858f
C2738 a_10799_5782# _147_.A1 0.0107f
C2739 _125_.A1 _243_.Q 0.12939f
C2740 _148_.A _122_.A0 0.33434f
C2741 a_15339_9308# a_16079_9263# 0.26905f
C2742 _120_.A0 a_5468_12508# 0.01032f
C2743 _220_.Y a_2661_12189# 0.03432f
C2744 a_9765_4629# VPWR 0.25637f
C2745 _199_.Y a_6286_15276# 0.06839f
C2746 a_2494_6166# _244_.D 0.22118f
C2747 a_4876_5535# _244_.RESET_B 0.01227f
C2748 a_2955_8447# VPWR 0.19926f
C2749 a_8811_16868# fanout7.A 0.01462f
C2750 fanout8.A a_2232_17770# 0.02208f
C2751 a_1580_12936# _221_.Y 0.01298f
C2752 a_6336_11499# _176_.B 0.35656f
C2753 _191_.Y _187_.Y 0.12141f
C2754 a_8603_9484# VPWR 0.28018f
C2755 _148_.B _192_.B 0.59879f
C2756 a_16336_8678# VPWR 0.15788f
C2757 _124_.S a_2763_12332# 0.02288f
C2758 a_3820_12525# VPWR 0.0137f
C2759 a_16079_9263# fanout7.A 0.02013f
C2760 _219_.Y a_2410_9409# 0.24278f
C2761 _250_.Q a_2122_16969# 0.03003f
C2762 _243_.RESET_B VPWR 1.53352f
C2763 _126_.Y _251_.CLK 0.01238f
C2764 a_15339_11471# VPWR 0.1852f
C2765 _225_.A a_13290_17044# 0.01401f
C2766 a_13019_6460# VPWR 0.30411f
C2767 a_2398_5782# a_2575_5436# 0.01057f
C2768 _193_.Y _202_.Y 0.02182f
C2769 a_2667_16868# a_3664_16966# 0.02979f
C2770 _225_.A a_13323_16007# 0.03684f
C2771 _165_.Y a_7739_9484# 0.03353f
C2772 _222_.A _250_.RESET_B 0.20405f
C2773 a_13323_16007# a_12804_16000# 0.34102f
C2774 _220_.Y a_3760_12430# 0.10165f
C2775 a_10864_4870# VPWR 0.16009f
C2776 a_1192_17508# VPWR 0.22501f
C2777 _118_.A0 _222_.A 0.07559f
C2778 a_6468_4968# a_7633_4727# 0.43239f
C2779 a_6885_4629# a_7345_4671# 0.02396f
C2780 a_2512_5782# _125_.A1 0.01859f
C2781 a_9994_17476# a_10437_17519# 0.02242f
C2782 _225_.A _227_.Y 0.33352f
C2783 _151_.X _226_.Y 0.06602f
C2784 _147_.Y a_13244_5412# 0.01008f
C2785 _225_.A _154_.X 0.02699f
C2786 _176_.B _176_.A 0.63182f
C2787 _266_.CLK a_12778_15964# 0.01867f
C2788 _192_.Y a_6584_12218# 0.01426f
C2789 _225_.A _166_.A 0.27073f
C2790 _179_.Y _181_.Y 0.52788f
C2791 a_9156_14040# a_9675_13844# 0.34114f
C2792 _244_.RESET_B _243_.CLK 0.05682f
C2793 _164_.Y _171_.Y 0.57031f
C2794 _148_.A _251_.CLK 0.11374f
C2795 a_6060_4166# _210_.Y 0.19976f
C2796 _225_.A a_14534_9186# 0.03633f
C2797 a_2122_16969# a_2565_16725# 0.02242f
C2798 _129_.Y _129_.B1 0.57311f
C2799 _135_.X _237_.Y 0.45075f
C2800 a_17120_11546# _260_.CLK 0.0143f
C2801 a_11078_16746# VPWR 0.77568f
C2802 a_6528_8475# VPWR 0.23434f
C2803 _252_.D _251_.CLK 0.98555f
C2804 _177_.X _178_.Y 0.12054f
C2805 _136_.A a_5372_9484# 0.0125f
C2806 a_9675_12332# a_10033_12506# 0.02138f
C2807 a_9573_12189# _251_.CLK 0.25698f
C2808 _243_.Q a_2494_6166# 0.50506f
C2809 _148_.B a_5084_12972# 0.02754f
C2810 a_14534_11898# a_15108_11885# 0.31978f
C2811 a_14359_16710# _238_.Y 0.13297f
C2812 a_3695_9263# a_2955_9308# 0.26905f
C2813 _192_.B a_6779_12972# 0.09979f
C2814 a_1192_7712# sdata 0.26778f
C2815 _207_.A2 a_5147_15996# 0.07874f
C2816 _179_.Y VPWR 0.54193f
C2817 _207_.A2 _207_.Y 0.07702f
C2818 _201_.Y VPWR 0.59187f
C2819 _243_.Q _215_.Y 0.03005f
C2820 a_4928_9318# _173_.A 0.02044f
C2821 _133_.B _131_.B1 0.01297f
C2822 _148_.X _162_.B 0.01788f
C2823 a_4928_9318# VPWR 0.07206f
C2824 _236_.A _212_.Y 0.02909f
C2825 a_13648_12430# _129_.Y 0.02216f
C2826 _170_.Y VPWR 0.62337f
C2827 _151_.B _158_.Y 0.18569f
C2828 _139_.X _251_.CLK 0.02095f
C2829 _178_.Y _184_.Y 0.14692f
C2830 a_10020_17512# a_10897_17861# 0.01835f
C2831 a_10437_17519# a_10308_17933# 0.01562f
C2832 _238_.Y a_15071_17016# 0.04024f
C2833 _148_.B _189_.X 0.07649f
C2834 a_14820_11464# a_16079_11821# 0.01529f
C2835 a_7739_9484# _171_.A 0.15978f
C2836 a_7622_16434# a_8325_16007# 0.02432f
C2837 _147_.A1 a_11475_4248# 0.01175f
C2838 a_4074_17044# VPWR 0.38783f
C2839 _133_.Y _131_.A2 0.35648f
C2840 a_1952_11546# _120_.X 0.01746f
C2841 a_6389_9484# VPWR 0.29285f
C2842 a_9573_13701# a_10033_13743# 0.02396f
C2843 a_9156_14040# a_10321_13799# 0.43239f
C2844 a_10218_17044# VPWR 0.38144f
C2845 _135_.A _237_.Y 0.02838f
C2846 _148_.A _244_.RESET_B 0.02683f
C2847 _147_.Y VPWR 0.64671f
C2848 _225_.A _251_.CLK 3.23271f
C2849 a_14730_15996# VPWR 0.37922f
C2850 _184_.Y _171_.A 0.67527f
C2851 _236_.A _240_.Y 0.89073f
C2852 a_1862_16434# a_2122_15964# 0.75507f
C2853 a_16736_4782# _251_.CLK 0.02529f
C2854 _243_.CLK _243_.D 0.01508f
C2855 _238_.Y a_15767_17137# 0.08572f
C2856 _244_.D _215_.A 0.25138f
C2857 _218_.Y VPWR 1.41799f
C2858 _232_.Y a_8292_17064# 0.39823f
C2859 fanout8.A VPWR 2.35816f
C2860 a_7908_16000# a_8785_16349# 0.01835f
C2861 a_8325_16007# a_8196_16421# 0.01562f
C2862 a_9352_17508# _214_.Y 0.01335f
C2863 a_7336_9318# _173_.Y 0.02198f
C2864 _250_.Q a_2565_16725# 0.02005f
C2865 _149_.A a_15983_5773# 0.02143f
C2866 _147_.Y _157_.B 0.22823f
C2867 a_14438_12210# a_14724_12528# 0.41329f
C2868 a_2398_4654# a_2301_4654# 0.01625f
C2869 _180_.X a_9734_9186# 0.01096f
C2870 _152_.X _153_.Y 0.19402f
C2871 a_12106_12433# VPWR 0.09872f
C2872 a_10033_12231# a_9573_12189# 0.02396f
C2873 a_10321_12287# a_9156_12528# 0.43239f
C2874 a_13740_5678# _149_.A 0.12952f
C2875 a_12518_16434# a_12778_15964# 0.75507f
C2876 _138_.Y _136_.B 0.81703f
C2877 a_12549_12189# a_12651_12332# 0.47622f
C2878 a_2148_16000# a_2436_16421# 0.43707f
C2879 _131_.Y VPWR 0.29365f
C2880 a_13073_7728# _162_.B 0.34427f
C2881 a_10308_17933# a_10539_17519# 0.12701f
C2882 a_15339_9308# VPWR 0.18179f
C2883 _124_.S _218_.Y 0.01497f
C2884 _173_.Y a_6218_10296# 0.01598f
C2885 _225_.A a_15141_12189# 0.01335f
C2886 fanout8.A _124_.S 0.03134f
C2887 _240_.Y a_9734_17946# 0.10282f
C2888 a_10539_9308# _251_.CLK 0.03082f
C2889 a_14724_5416# a_15141_5423# 0.37583f
C2890 a_2558_17532# a_2232_17770# 0.02726f
C2891 a_4559_4727# VPWR 0.18255f
C2892 a_2126_15424# _119_.A0 0.50548f
C2893 _168_.A a_6677_8806# 0.02521f
C2894 _210_.A a_6468_4968# 0.02453f
C2895 _168_.A _164_.Y 0.0773f
C2896 _204_.X VPWR 0.24063f
C2897 a_14534_11898# _131_.A2 0.01833f
C2898 a_15861_16904# VPWR 0.09808f
C2899 _241_.Y a_12241_17042# 0.01491f
C2900 fanout7.A VPWR 2.88519f
C2901 _180_.X _181_.Y 0.10026f
C2902 _192_.Y _176_.B 0.02401f
C2903 _222_.A _208_.X 0.66951f
C2904 a_14063_16357# _237_.Y 0.13297f
C2905 a_2148_17064# a_2667_16868# 0.34114f
C2906 _173_.A sclk 0.06193f
C2907 a_2232_7868# VPWR 0.89797f
C2908 a_12651_12332# a_13648_12430# 0.02979f
C2909 a_2565_16007# a_3313_16357# 0.01058f
C2910 sclk VPWR 1.04485f
C2911 a_11279_17869# a_11946_17508# 0.0894f
C2912 a_7872_5451# a_8021_5782# 0.33493f
C2913 a_8427_16007# a_8785_15998# 0.02138f
C2914 a_11279_9263# _251_.CLK 0.01594f
C2915 a_10672_12430# a_11082_12508# 0.10373f
C2916 a_10437_17519# VPWR 0.25229f
C2917 _243_.Q _215_.A 2.5567f
C2918 a_9156_12528# VPWR 0.0781f
C2919 _148_.B a_12401_4704# 0.32662f
C2920 a_13121_6188# _149_.A 0.01232f
C2921 a_15141_12189# a_15012_12223# 0.01562f
C2922 clkbuf_1_0__f_sclk.A a_4913_13330# 0.0154f
C2923 _180_.X VPWR 0.28838f
C2924 _160_.B VPWR 0.39934f
C2925 _236_.A a_14794_11428# 0.0237f
C2926 a_2232_7868# _124_.S 0.17944f
C2927 _230_.Y a_10033_14018# 0.01494f
C2928 a_13648_12430# a_13708_12525# 0.01042f
C2929 a_13391_12287# a_14058_12508# 0.0894f
C2930 a_2342_4338# a_3045_3911# 0.02432f
C2931 _124_.S sclk 0.12725f
C2932 a_14794_9409# _260_.RESET_B 0.25674f
C2933 a_2667_16007# a_3025_15998# 0.02138f
C2934 _148_.B a_5468_12508# 0.03142f
C2935 a_14859_15356# _266_.CLK 0.0257f
C2936 _220_.Y _120_.X 0.1768f
C2937 _138_.Y _144_.B 0.45458f
C2938 _168_.A _168_.Y 0.02025f
C2939 _187_.Y a_4858_12214# 0.01646f
C2940 a_16240_5654# a_15983_5773# 0.34468f
C2941 a_10764_5678# VPWR 0.24244f
C2942 a_13376_4782# VPWR 0.08385f
C2943 _196_.Y _190_.A 0.20669f
C2944 _236_.Y a_15108_11885# 0.01288f
C2945 a_9734_9186# a_10437_9165# 0.02454f
C2946 _148_.B a_8488_8436# 0.27727f
C2947 a_13073_5770# a_13740_5678# 0.01061f
C2948 a_2122_15964# VPWR 0.09831f
C2949 a_4744_15366# VPWR 0.17478f
C2950 _230_.Y a_10732_14037# 0.01227f
C2951 a_2628_3904# a_3505_4253# 0.01835f
C2952 a_3045_3911# a_2916_4325# 0.01562f
C2953 _199_.Y _202_.Y 0.21295f
C2954 _157_.B a_13376_4782# 0.01836f
C2955 a_10672_12430# _176_.A 0.01591f
C2956 a_1958_12210# a_2661_12189# 0.02454f
C2957 a_10220_18222# VPWR 0.28385f
C2958 _143_.A a_7984_4870# 0.03238f
C2959 a_12778_15964# VPWR 0.09711f
C2960 _173_.A a_2298_11830# 0.01668f
C2961 _148_.B _191_.Y 0.02532f
C2962 a_2410_8404# a_2436_8440# 0.36952f
C2963 a_10539_17519# VPWR 0.18782f
C2964 a_6080_11546# _176_.A 0.01112f
C2965 a_16650_12508# a_17032_12342# 0.01012f
C2966 a_4512_17547# a_4661_17878# 0.33493f
C2967 _210_.A _243_.Q 1.02255f
C2968 a_3664_16238# VPWR 0.18681f
C2969 a_2667_16868# VPWR 0.19011f
C2970 _215_.Y a_3300_4968# 0.39369f
C2971 fanout6.A a_13290_17044# 0.02055f
C2972 a_2232_11722# _120_.A0 0.01811f
C2973 a_9322_4873# a_9348_4968# 0.36952f
C2974 a_11082_12508# VPWR 0.38013f
C2975 a_14820_8440# a_15237_8447# 0.37583f
C2976 a_2232_13916# VPWR 0.83816f
C2977 a_13323_16007# fanout6.A 0.01295f
C2978 a_2244_12528# a_3503_12287# 0.01529f
C2979 _200_.Y a_6008_15242# 0.01509f
C2980 a_11731_8698# VPWR 0.32612f
C2981 a_5226_5412# _148_.A 0.13809f
C2982 a_2628_3904# VPWR 0.10549f
C2983 a_2853_8447# a_2955_8447# 0.47795f
C2984 _196_.Y _199_.Y 0.51837f
C2985 a_6336_11499# VPWR 0.24564f
C2986 _153_.Y _157_.Y 0.85869f
C2987 _182_.Y _251_.CLK 0.04461f
C2988 _148_.B a_3380_13690# 0.05332f
C2989 a_10020_9504# a_10308_9199# 0.43707f
C2990 _122_.A0 _173_.Y 0.31324f
C2991 _166_.A _151_.B 0.02958f
C2992 a_10437_9165# VPWR 0.24228f
C2993 _166_.A _148_.B 0.03491f
C2994 _124_.S a_2667_16868# 0.04055f
C2995 _128_.B1 a_12886_13350# 0.07707f
C2996 a_4462_16052# VPWR 0.1931f
C2997 a_3147_3911# a_3505_3902# 0.02138f
C2998 a_9120_9501# _172_.Y 0.20164f
C2999 fanout6.A a_12529_16823# 0.01144f
C3000 a_9867_4772# a_10225_4946# 0.02138f
C3001 a_6048_13011# a_6197_13342# 0.33493f
C3002 a_11456_12342# VPWR 0.08358f
C3003 a_15108_8861# a_15339_8447# 0.12701f
C3004 _124_.S a_2232_13916# 0.17954f
C3005 a_3952_9406# _173_.A 0.01061f
C3006 a_2661_12189# a_2532_12223# 0.01562f
C3007 _210_.B _148_.A 0.03539f
C3008 _160_.B a_13824_7989# 0.16858f
C3009 a_3952_9406# VPWR 0.1731f
C3010 _148_.B _134_.Y 0.35084f
C3011 a_15980_7638# fanout7.A 0.2481f
C3012 a_4144_4142# VPWR 0.16665f
C3013 a_2853_8447# a_3313_8438# 0.01483f
C3014 a_3952_8678# a_3695_8797# 0.34468f
C3015 a_7157_9948# VPWR 0.23676f
C3016 _180_.X a_10895_8436# 0.04355f
C3017 _225_.A a_14054_15234# 0.02807f
C3018 _143_.A a_7616_5498# 0.01257f
C3019 _191_.Y a_6779_12972# 0.16413f
C3020 a_2148_17064# a_3313_16823# 0.43239f
C3021 a_11536_9406# a_11596_9501# 0.01042f
C3022 a_11279_9263# a_11946_9484# 0.0894f
C3023 a_2565_16725# a_3025_16767# 0.02396f
C3024 _134_.Y fanout6.A 0.42171f
C3025 a_7336_9318# _184_.Y 0.01018f
C3026 a_3300_5416# _244_.RESET_B 0.40366f
C3027 _170_.B _164_.Y 0.04835f
C3028 _176_.A VPWR 1.0004f
C3029 _128_.B1 _129_.B1 0.35153f
C3030 a_9457_16823# a_9551_16823# 0.28931f
C3031 a_2075_4692# VPWR 0.83937f
C3032 a_14320_16238# a_14380_16119# 0.01042f
C3033 _147_.A1 _148_.A 0.09286f
C3034 _205_.Y a_6869_16750# 0.01678f
C3035 a_16079_8797# a_16746_8436# 0.0894f
C3036 _225_.A a_15237_11471# 0.0116f
C3037 a_16840_4688# freq_out 0.2472f
C3038 a_2398_4654# _243_.D 0.25574f
C3039 a_7616_15437# _193_.Y 0.11184f
C3040 a_6060_4166# VPWR 0.23116f
C3041 _133_.Y VPWR 0.38039f
C3042 a_16336_11702# a_16079_11821# 0.34468f
C3043 a_7985_13776# a_8156_14020# 0.37141f
C3044 a_6987_4772# _251_.CLK 0.02217f
C3045 _260_.CLK a_14357_12972# 0.01049f
C3046 a_1862_13410# a_2436_13397# 0.31978f
C3047 a_2122_12940# a_2565_12983# 0.02242f
C3048 _224_.Y a_6885_4629# 0.03432f
C3049 a_2565_12983# VPWR 0.23735f
C3050 a_17120_9318# VPWR 0.06793f
C3051 a_3819_5423# _244_.RESET_B 0.42215f
C3052 _236_.A a_12132_12528# 0.04125f
C3053 _250_.RESET_B a_2148_16000# 0.38413f
C3054 _124_.S a_2075_4692# 0.17293f
C3055 _207_.A1 a_9808_16966# 0.05275f
C3056 a_9765_4629# a_10513_4727# 0.01058f
C3057 _118_.A0 a_2148_16000# 0.05557f
C3058 a_4170_12508# a_4552_12342# 0.01012f
C3059 _148_.B _251_.CLK 0.05671f
C3060 _139_.X _147_.A1 1.28545f
C3061 _119_.A0 fanout8.A 0.05689f
C3062 _168_.Y _170_.B 0.31901f
C3063 fanout6.A _205_.Y 0.03437f
C3064 _225_.A a_14628_15247# 0.01055f
C3065 a_7984_4870# _251_.CLK 0.01087f
C3066 _124_.S a_2565_12983# 0.01808f
C3067 a_2148_12976# a_3407_13333# 0.01529f
C3068 a_10901_7678# _162_.B 0.04977f
C3069 _224_.Y a_7727_4727# 0.13292f
C3070 a_4074_12972# VPWR 0.38493f
C3071 _160_.B _160_.X 0.02236f
C3072 _180_.X _160_.X 0.01682f
C3073 _207_.Y _208_.X 0.10058f
C3074 a_4177_5414# _244_.RESET_B 0.01491f
C3075 _126_.B1 a_13464_12952# 0.01069f
C3076 a_9352_17508# a_9160_17594# 0.01226f
C3077 _250_.RESET_B a_3407_16357# 0.13305f
C3078 _126_.B1 _129_.B1 0.13659f
C3079 _133_.B a_15141_12189# 0.27916f
C3080 a_6810_3863# a_6836_3900# 0.37141f
C3081 _250_.D _222_.Y 0.25354f
C3082 a_9994_9409# a_10437_9165# 0.02242f
C3083 _228_.Y a_10020_9504# 0.39673f
C3084 a_3274_5380# VPWR 0.11492f
C3085 a_13740_5678# _145_.X 0.0413f
C3086 _215_.A a_3300_4968# 0.04481f
C3087 _147_.Y a_12712_5498# 0.01872f
C3088 a_9457_16823# a_8709_16725# 0.01058f
C3089 _210_.A a_6442_4873# 0.03782f
C3090 _160_.B a_13184_7183# 0.2495f
C3091 _164_.Y _164_.B1 0.18987f
C3092 _243_.CLK a_2436_8440# 0.10851f
C3093 _168_.A a_10539_9308# 0.01983f
C3094 _222_.Y a_3664_16966# 0.10165f
C3095 _190_.A a_11082_14020# 0.11687f
C3096 a_2126_7864# VPWR 0.11144f
C3097 a_3664_13214# a_4074_12972# 0.10373f
C3098 a_14534_11898# VPWR 0.77398f
C3099 _125_.A1 _243_.D 0.01112f
C3100 a_4913_13330# VPWR 0.21266f
C3101 _218_.Y a_2853_8447# 0.03468f
C3102 _122_.A0 a_2150_8874# 0.03826f
C3103 _133_.B a_16240_12430# 0.04229f
C3104 a_9130_12433# VPWR 0.09651f
C3105 _215_.A _122_.A0 0.04822f
C3106 a_14859_15356# VPWR 0.1869f
C3107 a_15237_11471# _260_.CLK 0.02103f
C3108 _244_.RESET_B _215_.Y 0.0547f
C3109 _210_.A _143_.A 0.03949f
C3110 _207_.A1 a_8811_16868# 0.02768f
C3111 a_12032_7806# VPWR 0.08578f
C3112 a_3014_5850# a_3274_5380# 0.75507f
C3113 a_14724_5416# _149_.A 0.02807f
C3114 a_11364_17064# a_11781_16725# 0.3749f
C3115 a_11078_16746# a_11883_16868# 0.097f
C3116 a_6958_13764# VPWR 0.217f
C3117 _168_.A a_11279_9263# 0.01286f
C3118 _225_.Y a_9062_4650# 0.09367f
C3119 a_2126_7864# _124_.S 0.134f
C3120 _120_.A0 _221_.Y 0.14285f
C3121 _227_.Y a_15339_8447# 0.42054f
C3122 a_8021_5782# _252_.D 0.0358f
C3123 a_11338_16969# VPWR 0.09683f
C3124 _166_.A a_15339_8447# 0.02199f
C3125 _235_.Y _131_.Y 0.06218f
C3126 _133_.B a_15889_12287# 0.01343f
C3127 _229_.Y _251_.CLK 0.01152f
C3128 _134_.Y _135_.X 0.05507f
C3129 a_15856_15454# VPWR 0.15972f
C3130 _258_.RESET_B _232_.Y 0.07292f
C3131 _165_.Y _171_.A 0.27099f
C3132 _145_.X _164_.B1 0.3054f
C3133 _160_.X a_11731_8698# 0.014f
C3134 a_13323_16007# _135_.A 0.02745f
C3135 a_13041_7996# VPWR 0.01058f
C3136 _147_.Y a_11661_4696# 0.0236f
C3137 _192_.Y VPWR 0.74682f
C3138 a_8014_8492# _170_.Y 0.33293f
C3139 _179_.Y a_8352_11013# 0.1304f
C3140 a_12328_8522# VPWR 0.12767f
C3141 _210_.A a_3300_4968# 0.01236f
C3142 _148_.X a_12401_4704# 0.24178f
C3143 a_6286_15276# _201_.Y 0.24942f
C3144 _129_.Y _260_.CLK 0.01642f
C3145 a_2218_12433# a_2244_12528# 0.36952f
C3146 _120_.X a_1958_12210# 0.28323f
C3147 a_8564_5412# VPWR 0.20768f
C3148 _225_.A _214_.Y 0.36117f
C3149 _225_.A _239_.Y 0.26305f
C3150 _207_.A2 fanout6.A 0.25456f
C3151 a_6885_4629# VPWR 0.23734f
C3152 _119_.A0 a_4744_15366# 0.0271f
C3153 a_14438_5850# a_15012_5837# 0.31978f
C3154 a_2171_6204# VPWR 0.86605f
C3155 _222_.A _247_.CLK 0.03005f
C3156 _215_.A a_5792_4782# 0.01968f
C3157 _190_.A a_6048_13011# 0.14123f
C3158 a_14340_15552# a_14859_15356# 0.34114f
C3159 _148_.B _171_.Y 0.0781f
C3160 _207_.A2 a_4625_16800# 0.01128f
C3161 a_12623_16823# a_12880_16966# 0.34468f
C3162 a_11781_16725# a_11652_16759# 0.01562f
C3163 _201_.Y a_7008_16035# 0.12415f
C3164 a_8352_11013# a_8501_10702# 0.33493f
C3165 _200_.Y VPWR 0.71347f
C3166 a_14794_11428# a_14820_11464# 0.36952f
C3167 a_7074_15532# _201_.Y 0.02759f
C3168 _215_.Y _243_.D 0.20196f
C3169 a_10415_12287# _229_.Y 0.13301f
C3170 _210_.B a_6836_3900# 0.09955f
C3171 a_2126_13912# VPWR 0.10975f
C3172 _185_.Y a_7808_10034# 0.01765f
C3173 clkbuf_1_0__f_sclk.A _176_.B 0.05197f
C3174 _186_.Y _194_.X 0.02262f
C3175 a_12215_7664# a_12549_7996# 0.14248f
C3176 _134_.Y _135_.A 0.18679f
C3177 clkbuf_1_0__f_sclk.A a_3886_10702# 1.16929f
C3178 a_9348_4968# _251_.CLK 0.0926f
C3179 _230_.Y fanout7.A 0.04182f
C3180 a_16746_11460# fanout7.A 0.06113f
C3181 _178_.Y _171_.A 0.08253f
C3182 _214_.Y a_10888_16878# 0.01691f
C3183 _214_.Y _214_.A 0.56373f
C3184 a_7727_4727# VPWR 0.1775f
C3185 a_2171_6204# _124_.S 0.18921f
C3186 a_15141_5423# a_15243_5423# 0.47795f
C3187 _153_.Y _161_.Y 0.76785f
C3188 _225_.A _170_.B 0.03399f
C3189 _119_.A0 a_2232_13916# 0.05125f
C3190 a_4816_5654# a_4559_5773# 0.34468f
C3191 a_15339_8447# _251_.CLK 0.05319f
C3192 a_9573_13701# VPWR 0.25001f
C3193 a_2436_9504# a_2955_9308# 0.34114f
C3194 _222_.A _232_.Y 0.079f
C3195 _136_.A _136_.B 0.24466f
C3196 a_13323_16007# a_14063_16357# 0.26905f
C3197 _124_.S a_2126_13912# 0.13014f
C3198 _147_.Y _152_.X 0.02278f
C3199 _234_.Y a_12651_12332# 0.42048f
C3200 _243_.Q a_3147_3911# 0.01034f
C3201 _145_.A2 _136_.B 0.16809f
C3202 _222_.Y a_1862_16434# 0.03635f
C3203 _243_.CLK a_3274_4873# 0.01665f
C3204 a_15141_5423# a_15601_5414# 0.01483f
C3205 _225_.A a_14698_12433# 0.02496f
C3206 _244_.RESET_B _215_.A 0.22996f
C3207 a_14757_15213# a_15217_15255# 0.02396f
C3208 a_7882_15964# VPWR 0.09719f
C3209 a_14340_15552# a_15505_15311# 0.43239f
C3210 a_12904_7010# VPWR 0.14298f
C3211 _236_.A a_10218_17044# 0.01316f
C3212 a_10415_13799# VPWR 0.179f
C3213 _210_.A _251_.CLK 0.01247f
C3214 a_14320_16238# _266_.CLK 0.0145f
C3215 a_3300_4968# a_3819_4772# 0.34114f
C3216 _149_.A _153_.Y 0.10251f
C3217 _225_.A freq_in 0.0565f
C3218 _139_.X a_11274_4948# 0.02732f
C3219 _186_.Y _181_.Y 0.06326f
C3220 _234_.Y a_13708_12525# 0.01227f
C3221 _133_.B a_15237_11471# 0.26604f
C3222 _222_.Y a_2148_17064# 0.38722f
C3223 _199_.Y a_7616_15437# 0.01071f
C3224 _214_.A a_11168_16082# 0.01716f
C3225 a_13019_6460# _157_.Y 0.02762f
C3226 _236_.Y VPWR 1.42801f
C3227 a_8811_16868# a_9808_16966# 0.02979f
C3228 _131_.Y a_14651_10996# 0.1565f
C3229 _187_.Y a_5297_12264# 0.01614f
C3230 _224_.Y _210_.Y 0.18749f
C3231 a_14359_16710# a_14940_16710# 0.01529f
C3232 a_8427_16007# VPWR 0.18674f
C3233 a_2232_7868# a_2558_7972# 0.02726f
C3234 _236_.A a_12106_12433# 0.03045f
C3235 _148_.B _199_.B1 0.0114f
C3236 _264_.Q _266_.CLK 0.69011f
C3237 a_12237_5760# _148_.A 0.15315f
C3238 _186_.Y VPWR 1.45585f
C3239 _225_.A _164_.B1 0.01197f
C3240 _168_.A _173_.Y 0.60406f
C3241 a_8386_3900# VPWR 0.31648f
C3242 _236_.A _131_.Y 0.04643f
C3243 _119_.A0 a_2565_12983# 0.01602f
C3244 fanout6.A _199_.B1 0.0322f
C3245 _222_.A a_6720_17061# 0.01077f
C3246 _158_.Y _159_.Y 0.05654f
C3247 a_14534_9186# a_15237_9165# 0.02454f
C3248 _120_.A0 a_5297_12264# 0.08168f
C3249 _145_.A2 _144_.B 0.09996f
C3250 _207_.A1 VPWR 0.8867f
C3251 a_2232_17770# _250_.D 0.01052f
C3252 a_6182_4650# a_6885_4629# 0.02454f
C3253 a_15071_17016# a_14940_16710# 0.37583f
C3254 a_14572_16746# a_14919_16964# 0.03061f
C3255 a_12730_8806# _161_.Y 0.01534f
C3256 _126_.Y _126_.B1 0.24758f
C3257 _168_.A _148_.B 0.08562f
C3258 a_8266_16969# a_8006_16746# 0.75507f
C3259 _133_.B _129_.Y 0.0152f
C3260 _250_.Q a_3407_16823# 0.02316f
C3261 _236_.A fanout7.A 0.17926f
C3262 _210_.A _244_.RESET_B 0.01187f
C3263 a_3717_4629# a_3588_4663# 0.01562f
C3264 _242_.D VPWR 0.53509f
C3265 _215_.A _243_.D 0.02818f
C3266 _172_.Y a_9734_9186# 0.30474f
C3267 a_9120_9501# VPWR 0.22533f
C3268 _250_.D a_1862_16434# 0.28369f
C3269 a_14534_8874# VPWR 0.77395f
C3270 a_17120_16878# VPWR 0.08509f
C3271 a_2244_12528# VPWR 0.08353f
C3272 a_8288_3270# VPWR 0.09775f
C3273 _119_.A0 a_4074_12972# 0.13308f
C3274 a_14820_9504# a_16079_9263# 0.01529f
C3275 a_14698_12433# _260_.CLK 0.03525f
C3276 _220_.Y a_1958_12210# 0.13465f
C3277 _120_.A0 a_4552_12342# 0.0564f
C3278 a_4640_13058# VPWR 0.07083f
C3279 a_9062_4650# VPWR 0.7782f
C3280 _118_.A0 fanout6.A 1.42961f
C3281 a_14940_16710# a_15767_17137# 0.41329f
C3282 a_2171_6204# a_2671_6460# 0.03308f
C3283 a_2494_6166# a_2397_6460# 0.02903f
C3284 a_1864_6294# a_2048_6294# 0.0524f
C3285 a_6862_15260# _205_.Y 0.01832f
C3286 a_8709_16725# a_9169_17042# 0.01483f
C3287 a_6124_9945# VPWR 0.70687f
C3288 a_8292_17064# fanout7.A 0.09077f
C3289 a_5201_9240# clkbuf_1_0__f_sclk.A 0.0132f
C3290 _160_.X a_12328_8522# 0.01856f
C3291 _118_.A0 a_4625_16800# 0.04754f
C3292 a_4559_4727# a_5226_4948# 0.0894f
C3293 _250_.D a_2148_17064# 0.05045f
C3294 a_4816_4870# a_4876_4965# 0.01042f
C3295 a_7520_9318# VPWR 0.06507f
C3296 _157_.B a_13775_5782# 0.0358f
C3297 _124_.S a_2244_12528# 0.02558f
C3298 _239_.Y a_15217_15530# 0.01491f
C3299 a_3503_12287# VPWR 0.2008f
C3300 a_1192_4782# VPWR 0.12086f
C3301 _222_.Y VPWR 1.39886f
C3302 _164_.Y a_10989_8784# 0.26689f
C3303 _119_.A0 a_4913_13330# 0.09533f
C3304 _242_.D a_3014_5850# 0.03916f
C3305 a_2075_5468# a_2301_5436# 0.02726f
C3306 a_13820_4948# _145_.X 0.02692f
C3307 _214_.A a_11781_16725# 0.28444f
C3308 _119_.X _221_.Y 0.0879f
C3309 _168_.B _122_.A0 0.73399f
C3310 a_15339_9308# a_15108_9199# 0.12701f
C3311 a_14820_9504# a_15697_9207# 0.01835f
C3312 _170_.B a_9466_7678# 0.01535f
C3313 a_9928_18390# VPWR 0.14305f
C3314 a_15243_12332# _131_.A2 0.02024f
C3315 a_6885_4629# a_6756_4663# 0.01562f
C3316 _214_.Y _241_.Y 0.0121f
C3317 _124_.S a_2724_8861# 0.01728f
C3318 a_16079_11821# _260_.CLK 0.01907f
C3319 a_9734_17946# a_10437_17519# 0.02432f
C3320 _179_.Y _183_.Y 0.63942f
C3321 a_3695_9263# a_3601_9263# 0.28931f
C3322 _147_.Y _157_.Y 0.77686f
C3323 _172_.Y VPWR 0.4006f
C3324 _239_.Y a_15916_15549# 0.01227f
C3325 _219_.Y a_3313_9482# 0.01491f
C3326 _124_.S _222_.Y 0.02186f
C3327 _222_.A a_7328_16878# 0.01718f
C3328 _136_.A a_6528_8475# 0.01759f
C3329 _266_.CLK a_12518_16434# 0.02363f
C3330 a_10220_18222# _236_.A 0.25528f
C3331 a_8870_13722# a_9573_13701# 0.02454f
C3332 _210_.A _243_.D 0.4666f
C3333 a_13969_16357# a_13221_16007# 0.01058f
C3334 a_8325_16007# _258_.RESET_B 0.0364f
C3335 a_13649_4704# VPWR 0.2173f
C3336 _219_.Y _218_.Y 0.13141f
C3337 a_2122_16969# a_1862_16746# 0.75507f
C3338 a_6184_8522# VPWR 0.15237f
C3339 _189_.X a_5888_13854# 0.01809f
C3340 _210_.A a_6810_3863# 0.01031f
C3341 _235_.Y a_14534_11898# 0.03931f
C3342 _173_.Y _174_.Y 1.32371f
C3343 _210_.Y VPWR 0.42202f
C3344 a_9573_12189# a_9675_12332# 0.47622f
C3345 _173_.A _246_.D 0.05196f
C3346 _246_.D VPWR 0.46969f
C3347 a_2232_13916# a_2558_14020# 0.02726f
C3348 a_14240_16921# a_14048_16878# 0.01061f
C3349 _195_.Y _199_.B1 0.10076f
C3350 _176_.B VPWR 0.63737f
C3351 _145_.X a_10989_8784# 0.02768f
C3352 _136_.A _170_.Y 0.20378f
C3353 a_3695_9263# a_2436_9504# 0.01529f
C3354 a_3886_10702# VPWR 2.10266f
C3355 _133_.B a_12651_12332# 0.01513f
C3356 _266_.CLK a_13092_16421# 0.01461f
C3357 _201_.Y _202_.Y 0.63584f
C3358 a_9167_16357# _258_.RESET_B 0.13321f
C3359 a_8394_4948# _136_.B 0.11567f
C3360 _138_.Y a_8564_5412# 0.01008f
C3361 a_12904_7010# _160_.X 0.03033f
C3362 fanout8.A a_1580_16710# 0.29434f
C3363 _214_.Y fanout6.A 0.02718f
C3364 _243_.Q _244_.D 0.09991f
C3365 _250_.D VPWR 0.46452f
C3366 a_9734_17946# a_10539_17519# 0.097f
C3367 a_2126_17774# _250_.Q 0.09049f
C3368 _186_.Y a_7553_14832# 0.01211f
C3369 _154_.X _162_.B 0.05549f
C3370 a_14820_11464# a_15339_11471# 0.34102f
C3371 a_15237_11471# a_15697_11813# 0.02396f
C3372 a_7336_9318# _171_.A 0.01479f
C3373 _236_.A a_11456_12342# 0.01927f
C3374 _190_.A _187_.Y 0.01139f
C3375 _119_.A0 a_2126_13912# 0.11961f
C3376 _128_.B1 _260_.CLK 0.34145f
C3377 a_7622_16434# a_7882_15964# 0.75507f
C3378 _136_.A _147_.Y 0.09862f
C3379 _166_.A _162_.B 0.65468f
C3380 a_3664_16966# VPWR 0.18348f
C3381 a_9573_13701# a_9444_13735# 0.01562f
C3382 a_9808_16966# VPWR 0.15895f
C3383 _173_.A a_2853_9165# 0.01568f
C3384 _144_.B a_10799_5782# 0.0358f
C3385 _148_.B a_12808_13854# 0.02199f
C3386 a_2853_9165# VPWR 0.23903f
C3387 a_14240_16921# VPWR 0.38181f
C3388 _131_.A2 VPWR 1.55078f
C3389 a_14054_15234# _135_.A 0.3192f
C3390 _168_.A a_7739_9484# 0.01022f
C3391 a_14320_16238# VPWR 0.15935f
C3392 _193_.Y a_7985_13776# 0.3325f
C3393 _170_.B _148_.B 0.02956f
C3394 a_16840_4688# _251_.CLK 0.25504f
C3395 _236_.A _176_.A 0.29228f
C3396 a_10020_17512# a_11185_17869# 0.43239f
C3397 _238_.Y a_14940_16710# 0.40242f
C3398 fanout8.A a_1862_13410# 0.01119f
C3399 a_13740_5678# _151_.B 0.03033f
C3400 _215_.A _221_.Y 0.25093f
C3401 _192_.Y _192_.C 0.1256f
C3402 _232_.Y a_8266_16969# 0.26443f
C3403 a_7622_16434# a_8427_16007# 0.097f
C3404 _203_.Y VPWR 0.39935f
C3405 a_3717_4629# VPWR 0.23845f
C3406 _250_.Q a_1862_16746# 0.03946f
C3407 _149_.A a_15243_5423# 0.02588f
C3408 _168_.A _184_.Y 0.02004f
C3409 _236_.A _133_.Y 0.07933f
C3410 a_9444_12223# a_9573_12189# 0.01562f
C3411 _173_.A clkbuf_1_0__f_sclk.A 0.02192f
C3412 clkbuf_1_0__f_sclk.A VPWR 4.31609f
C3413 _266_.CLK VPWR 0.95904f
C3414 _264_.Q VPWR 0.48087f
C3415 _159_.Y _227_.Y 0.2362f
C3416 a_11846_12210# a_12651_12332# 0.097f
C3417 a_12132_12528# a_12549_12189# 0.3749f
C3418 a_2148_16000# a_2565_16007# 0.37583f
C3419 a_12704_11546# VPWR 0.09299f
C3420 _225_.Y VPWR 1.37275f
C3421 a_5333_15532# _199_.Y 0.15777f
C3422 a_14820_9504# a_15985_9263# 0.43239f
C3423 a_14820_9504# VPWR 0.07158f
C3424 a_4625_16800# _208_.X 0.2283f
C3425 _225_.A a_14438_12210# 0.0536f
C3426 _166_.A _159_.Y 0.03509f
C3427 _189_.X a_5084_12972# 0.09973f
C3428 a_13366_13350# _129_.B1 0.09468f
C3429 a_7908_16000# a_9073_16357# 0.43239f
C3430 a_8196_16421# a_8427_16007# 0.12701f
C3431 a_10020_9504# _251_.CLK 0.13159f
C3432 a_14698_5380# a_14724_5416# 0.36952f
C3433 a_2298_17532# a_2126_17774# 0.01057f
C3434 _126_.B1 _260_.CLK 0.72684f
C3435 a_2126_7864# a_2558_7972# 0.02903f
C3436 a_4816_5654# a_4876_5535# 0.01042f
C3437 a_2126_15424# a_1864_15366# 0.01053f
C3438 a_15141_12189# a_15601_12506# 0.01483f
C3439 _225_.A a_14724_5416# 0.05118f
C3440 _191_.Y a_7232_14570# 0.02416f
C3441 _210_.A _210_.B 1.55659f
C3442 _165_.Y _122_.A0 0.28068f
C3443 _147_.A1 a_10607_4727# 0.01036f
C3444 _243_.Q a_10769_4258# 0.10158f
C3445 _241_.Y a_11781_16725# 0.03602f
C3446 _162_.B _251_.CLK 0.02884f
C3447 _204_.X _202_.Y 0.18017f
C3448 a_8811_16868# VPWR 0.18504f
C3449 a_1862_16746# a_2565_16725# 0.02454f
C3450 _171_.A a_8488_8436# 0.01696f
C3451 a_13323_16007# _237_.Y 0.42058f
C3452 _225_.A a_13221_16007# 0.05299f
C3453 a_12804_16000# a_13221_16007# 0.37583f
C3454 a_12518_16434# a_13092_16421# 0.31978f
C3455 _247_.CLK a_2148_16000# 0.09245f
C3456 _225_.A a_11279_17869# 0.01337f
C3457 a_2436_16421# a_2667_16007# 0.12701f
C3458 a_3717_5423# _243_.CLK 0.27846f
C3459 _148_.B a_5297_12264# 0.33565f
C3460 a_13391_12287# _129_.B1 0.03094f
C3461 a_11536_17750# a_11279_17869# 0.34468f
C3462 _136_.A _180_.X 0.01212f
C3463 a_16079_9263# VPWR 0.16811f
C3464 a_16079_9263# a_15985_9263# 0.28931f
C3465 _207_.Y a_4796_17044# 0.01265f
C3466 a_6442_4873# a_6468_4968# 0.36952f
C3467 _210_.Y a_6182_4650# 0.26832f
C3468 a_9167_16357# a_9834_15996# 0.0894f
C3469 a_9994_17476# VPWR 0.0954f
C3470 _246_.D a_1864_10034# 0.02599f
C3471 a_3588_4663# VPWR 0.011f
C3472 _148_.B _164_.B1 0.12531f
C3473 _210_.A a_5608_4572# 0.01203f
C3474 a_14438_12210# a_15012_12223# 0.31978f
C3475 a_13019_6460# _149_.A 0.03322f
C3476 a_12923_11460# _131_.A2 0.08549f
C3477 a_2232_11722# _120_.X 0.01628f
C3478 _138_.Y a_8386_3900# 0.03466f
C3479 a_2218_12433# VPWR 0.09846f
C3480 _241_.Y a_12880_16966# 0.10178f
C3481 a_5201_9240# _173_.A 0.13887f
C3482 _236_.A a_14534_11898# 0.02195f
C3483 a_5201_9240# VPWR 0.21241f
C3484 _230_.Y a_9573_13701# 0.03523f
C3485 a_13681_15998# _237_.Y 0.01491f
C3486 a_2075_5468# a_2398_5782# 0.43036f
C3487 a_13391_12287# a_13648_12430# 0.34468f
C3488 a_12549_12189# a_13009_12231# 0.02396f
C3489 a_12132_12528# a_13297_12287# 0.43239f
C3490 a_2342_4338# a_2602_3868# 0.75507f
C3491 a_3407_16357# a_4074_15996# 0.0894f
C3492 a_14340_15552# _266_.CLK 0.06692f
C3493 a_15243_5423# a_16240_5654# 0.03061f
C3494 _120_.A0 _247_.CLK 0.03708f
C3495 _235_.Y _236_.Y 0.07749f
C3496 a_10308_9199# _251_.CLK 0.0226f
C3497 _166_.A a_10901_7678# 0.01228f
C3498 _224_.Y VPWR 1.44998f
C3499 a_2232_17770# VPWR 0.89747f
C3500 a_16240_12430# a_16650_12508# 0.10373f
C3501 a_3952_9406# _219_.Y 0.10165f
C3502 a_1864_5498# _215_.A 0.01236f
C3503 _124_.S a_2218_12433# 0.02223f
C3504 _119_.A0 a_4640_13058# 0.01785f
C3505 a_1862_16434# VPWR 0.777f
C3506 _230_.Y a_10415_13799# 0.13292f
C3507 a_2342_4338# a_3147_3911# 0.097f
C3508 a_13391_12287# a_13297_12287# 0.28931f
C3509 a_10888_16878# _212_.Y 0.03101f
C3510 _214_.A _212_.Y 0.42252f
C3511 fanout6.A a_11781_16725# 0.01182f
C3512 a_15697_9482# _260_.RESET_B 0.01491f
C3513 a_14438_5850# VPWR 0.78395f
C3514 _138_.Y a_9062_4650# 0.05808f
C3515 a_6485_11830# _178_.B1 0.03753f
C3516 a_14438_12210# _260_.CLK 0.02011f
C3517 _250_.D a_1952_17594# 0.01466f
C3518 _200_.Y a_6286_15276# 0.34467f
C3519 _225_.A _240_.Y 0.06714f
C3520 _174_.Y _184_.Y 0.15297f
C3521 a_14624_4782# VPWR 0.09946f
C3522 a_12518_16434# VPWR 0.77575f
C3523 a_2126_11726# a_2298_11830# 0.0308f
C3524 clkbuf_1_0__f_sclk.A a_5704_13854# 0.01596f
C3525 a_2150_8874# a_2436_8440# 0.41329f
C3526 a_2232_17770# _124_.S 0.17244f
C3527 _240_.Y a_11536_17750# 0.09868f
C3528 _191_.Y _192_.B 0.10363f
C3529 _179_.Y _185_.Y 0.03168f
C3530 _166_.A a_11974_8436# 0.01009f
C3531 a_10539_9308# a_10897_9482# 0.02138f
C3532 a_15243_12332# VPWR 0.18535f
C3533 _148_.B _128_.B1 0.30896f
C3534 a_13740_5678# _151_.X 0.01934f
C3535 a_12237_5760# _148_.B 0.28439f
C3536 _118_.A0 a_2122_16969# 0.02586f
C3537 a_2148_17064# VPWR 0.07808f
C3538 _124_.S a_1862_16434# 0.02893f
C3539 _194_.X VPWR 0.25468f
C3540 a_2628_3904# a_3793_4261# 0.43239f
C3541 a_2916_4325# a_3147_3911# 0.12701f
C3542 _215_.Y a_3274_4873# 0.24207f
C3543 _170_.B a_7739_9484# 0.0785f
C3544 a_10672_12430# VPWR 0.16079f
C3545 fanout6.A a_12880_16966# 0.01434f
C3546 a_13244_5412# VPWR 0.20834f
C3547 a_14794_8404# a_14820_8440# 0.36952f
C3548 _226_.Y _251_.CLK 0.06518f
C3549 a_2763_12332# a_3121_12506# 0.02138f
C3550 _239_.Y _135_.A 0.30472f
C3551 _196_.Y a_6106_13726# 0.01569f
C3552 a_2436_8440# a_3313_8789# 0.01835f
C3553 a_2853_8447# a_2724_8861# 0.01562f
C3554 a_6080_11546# VPWR 0.10109f
C3555 fanout8.A a_1580_12936# 0.27165f
C3556 _236_.Y a_16396_11583# 0.01227f
C3557 _122_.A0 a_2298_10318# 0.01672f
C3558 a_2126_13912# a_2558_14020# 0.02903f
C3559 a_10539_9308# a_11536_9406# 0.02979f
C3560 a_9734_9186# VPWR 0.77404f
C3561 _157_.B a_13244_5412# 0.04599f
C3562 _124_.S a_2148_17064# 0.01837f
C3563 a_3887_4261# a_4554_3900# 0.0894f
C3564 _207_.A1 a_5525_16750# 0.02532f
C3565 a_9765_4629# a_9867_4772# 0.47622f
C3566 a_15237_8447# a_15339_8447# 0.47795f
C3567 a_7624_10034# a_7808_10034# 0.0524f
C3568 a_14048_16878# VPWR 0.0954f
C3569 _243_.Q _147_.B1 0.36224f
C3570 a_1958_12210# a_2532_12223# 0.31978f
C3571 _133_.B _126_.B1 1.14131f
C3572 a_2955_8447# a_3952_8678# 0.03061f
C3573 _143_.A _243_.Q 0.01504f
C3574 _168_.B _168_.A 0.63209f
C3575 _258_.RESET_B fanout7.A 0.03431f
C3576 a_2565_16725# a_2436_16759# 0.01562f
C3577 a_11279_9263# a_11536_9406# 0.34468f
C3578 _228_.Y _251_.CLK 0.21656f
C3579 _148_.B _126_.B1 0.01607f
C3580 _203_.Y a_7622_16434# 0.29301f
C3581 _181_.Y VPWR 0.51141f
C3582 _215_.Y a_4876_4965# 0.01227f
C3583 _208_.X _209_.Y 0.18761f
C3584 a_9867_4772# a_10864_4870# 0.02979f
C3585 a_16336_8678# a_16079_8797# 0.34468f
C3586 _225_.A _260_.RESET_B 0.67496f
C3587 a_2075_4692# a_2575_4948# 0.03308f
C3588 a_2398_4654# a_2301_4948# 0.02903f
C3589 _225_.A a_14794_11428# 0.03075f
C3590 a_15339_11471# a_16336_11702# 0.03061f
C3591 fanout8.A _222_.A 0.6317f
C3592 _236_.A a_10415_13799# 0.01138f
C3593 a_1862_13410# a_2565_12983# 0.02432f
C3594 a_6468_4968# _251_.CLK 0.08462f
C3595 _250_.Q _118_.A0 1.69312f
C3596 _224_.Y a_6182_4650# 0.13647f
C3597 _148_.B _190_.A 0.98812f
C3598 a_11279_9263# a_11185_9263# 0.28931f
C3599 _173_.A VPWR 1.48924f
C3600 a_2122_12940# VPWR 0.0981f
C3601 a_9352_17508# fanout8.A 0.25713f
C3602 _243_.Q a_3300_4968# 0.03439f
C3603 a_6060_4166# a_6095_4270# 0.33493f
C3604 a_10607_4727# a_11274_4948# 0.0894f
C3605 _144_.Y _136_.B 0.03002f
C3606 a_9867_4772# a_9636_4663# 0.12701f
C3607 a_9348_4968# a_10225_4671# 0.01835f
C3608 a_10864_4870# a_10924_4965# 0.01042f
C3609 a_1568_12342# VPWR 0.09827f
C3610 _236_.A _236_.Y 0.70684f
C3611 _183_.Y a_8506_10318# 0.01574f
C3612 _186_.Y a_7074_15532# 0.01277f
C3613 a_10764_5678# a_10799_5782# 0.33493f
C3614 _157_.B VPWR 0.63687f
C3615 a_12106_12433# a_12549_12189# 0.02242f
C3616 _126_.Y a_12132_12528# 0.01004f
C3617 a_2126_17774# a_2298_17878# 0.0308f
C3618 _192_.C _176_.B 0.02159f
C3619 a_2148_12976# a_2667_12983# 0.34102f
C3620 _173_.A _124_.S 0.30168f
C3621 a_2565_12983# a_3025_13325# 0.02396f
C3622 _124_.S a_2122_12940# 0.01123f
C3623 a_14058_12508# _131_.A2 0.0682f
C3624 _213_.Y VPWR 0.34935f
C3625 _124_.S VPWR 2.95413f
C3626 a_3664_13214# VPWR 0.1839f
C3627 a_14359_16710# a_14830_16746# 0.28931f
C3628 _166_.A _158_.Y 0.03692f
C3629 _119_.A0 clkbuf_1_0__f_sclk.A 0.05566f
C3630 _236_.A _186_.Y 0.04327f
C3631 _250_.RESET_B a_2667_16007# 0.42104f
C3632 a_3014_5850# VPWR 0.80623f
C3633 _215_.A a_3274_4873# 0.01395f
C3634 a_9994_9409# a_9734_9186# 0.75507f
C3635 _118_.A0 a_2565_16725# 0.01068f
C3636 a_13820_4948# _151_.B 0.03239f
C3637 _147_.Y a_13073_5770# 0.09499f
C3638 _148_.A _136_.B 0.01542f
C3639 _242_.D a_3014_4650# 0.2665f
C3640 a_10752_7989# VPWR 0.23664f
C3641 a_13740_5678# _148_.X 0.34048f
C3642 _236_.A _207_.A1 0.01741f
C3643 a_7616_15437# _201_.Y 0.27843f
C3644 _241_.Y _212_.Y 0.16201f
C3645 a_2853_9165# a_2853_8447# 0.03306f
C3646 _168_.A a_10020_9504# 0.01353f
C3647 a_17120_8522# VPWR 0.06793f
C3648 _118_.X a_1862_16746# 0.26914f
C3649 a_11082_14020# fanout7.A 0.01507f
C3650 _252_.D _136_.B 0.0112f
C3651 _138_.Y _225_.Y 0.07002f
C3652 a_1192_11460# en 0.25722f
C3653 a_2667_12983# a_3407_13333# 0.26905f
C3654 _235_.Y _131_.A2 0.06866f
C3655 a_15071_17016# a_14830_16746# 0.01058f
C3656 _218_.Y a_2410_8404# 0.24234f
C3657 _236_.A a_12420_12223# 0.02449f
C3658 _214_.Y a_10020_17512# 0.02547f
C3659 _250_.RESET_B a_3025_15998# 0.01491f
C3660 a_13883_11460# _131_.A2 0.05265f
C3661 a_2298_17532# _118_.A0 0.01214f
C3662 a_14340_15552# VPWR 0.07869f
C3663 a_12401_4704# _147_.B1 0.01487f
C3664 _260_.RESET_B _260_.CLK 0.02734f
C3665 a_14794_11428# _260_.CLK 0.02684f
C3666 _207_.A1 a_8292_17064# 0.03195f
C3667 _144_.B _144_.Y 0.14161f
C3668 a_9834_15996# fanout7.A 0.02424f
C3669 _168_.B _174_.Y 0.11169f
C3670 a_11078_16746# a_11364_17064# 0.41329f
C3671 _243_.CLK a_2955_8447# 0.04153f
C3672 a_6528_8475# a_6677_8806# 0.33493f
C3673 _194_.X a_8870_13722# 0.27066f
C3674 _171_.A _171_.Y 0.97194f
C3675 a_12923_11460# VPWR 0.28337f
C3676 _148_.B _247_.CLK 0.13616f
C3677 _244_.D _244_.RESET_B 0.08434f
C3678 _178_.B1 _173_.Y 0.65609f
C3679 _243_.CLK _243_.RESET_B 0.01292f
C3680 _218_.Y a_3952_8678# 0.09868f
C3681 _250_.RESET_B a_3724_16119# 0.01227f
C3682 _243_.Q _251_.CLK 0.07009f
C3683 _179_.Y _164_.Y 0.54792f
C3684 _229_.Y a_9675_12332# 0.4215f
C3685 a_15237_9165# a_15237_8447# 0.03306f
C3686 a_9994_9409# VPWR 0.09809f
C3687 clkbuf_1_0__f_sclk.A _192_.C 0.0194f
C3688 a_13824_7989# VPWR 0.22622f
C3689 _158_.Y _251_.CLK 0.01038f
C3690 a_3300_5416# a_3717_5423# 0.37583f
C3691 _144_.B _148_.A 2.12497f
C3692 a_5704_13854# VPWR 0.13653f
C3693 _236_.A a_9928_18390# 0.02118f
C3694 _136_.A a_6885_4629# 0.03152f
C3695 a_12904_7010# _157_.Y 0.01014f
C3696 _210_.A a_3274_4873# 0.0125f
C3697 a_10895_8436# VPWR 0.50653f
C3698 _207_.A1 a_5376_17061# 0.13394f
C3699 fanout6.A _212_.Y 0.17418f
C3700 _246_.D a_2150_9186# 0.26484f
C3701 _145_.A2 a_8564_5412# 0.13084f
C3702 _162_.Y _153_.Y 0.18877f
C3703 a_4512_17547# fanout6.A 0.33095f
C3704 a_6182_4650# VPWR 0.77662f
C3705 _119_.A0 a_2298_15238# 0.01893f
C3706 a_1864_10034# VPWR 0.14988f
C3707 a_3601_9263# a_2436_9504# 0.43239f
C3708 a_3313_9207# a_2853_9165# 0.02396f
C3709 _168_.Y a_6528_8475# 0.19503f
C3710 a_15980_7638# VPWR 0.28809f
C3711 a_14054_15234# a_14757_15213# 0.02454f
C3712 a_3717_5423# a_3819_5423# 0.47795f
C3713 a_11078_16746# a_11652_16759# 0.31978f
C3714 _136_.A a_7727_4727# 0.03595f
C3715 a_14534_11898# a_14820_11464# 0.41329f
C3716 a_6508_15532# _201_.Y 0.01455f
C3717 _185_.Y a_7157_9948# 0.15732f
C3718 a_10020_17512# freq_in 0.08919f
C3719 _204_.X a_7616_15437# 0.1073f
C3720 _144_.B _139_.X 0.06105f
C3721 fanout7.A a_16079_8797# 0.01776f
C3722 a_13244_7972# _153_.Y 0.01008f
C3723 _145_.A2 a_7727_4727# 0.0175f
C3724 a_16336_11702# fanout7.A 0.0128f
C3725 a_1952_17594# VPWR 0.09735f
C3726 _240_.Y fanout6.A 0.1736f
C3727 a_14724_5416# a_15601_5765# 0.01835f
C3728 a_15141_5423# a_15012_5837# 0.01562f
C3729 _221_.Y a_2148_12976# 0.38225f
C3730 _168_.Y _170_.Y 0.01852f
C3731 a_2232_10210# _246_.D 0.01147f
C3732 _209_.Y a_8006_16746# 0.27078f
C3733 a_17120_7806# VPWR 0.05657f
C3734 a_15108_8861# _251_.CLK 0.01376f
C3735 a_3819_5423# a_4816_5654# 0.03061f
C3736 a_3717_5423# a_4177_5414# 0.01483f
C3737 a_2150_9186# a_2853_9165# 0.02454f
C3738 a_8870_13722# VPWR 0.7759f
C3739 a_6720_17061# a_6869_16750# 0.33493f
C3740 _221_.Y _220_.Y 0.04988f
C3741 _168_.A _178_.Y 0.06385f
C3742 _151_.X a_13820_4948# 0.09999f
C3743 _225_.A _144_.B 1.61639f
C3744 _160_.X VPWR 0.57592f
C3745 a_14651_10996# _131_.A2 0.09869f
C3746 _234_.Y a_12132_12528# 0.39607f
C3747 _240_.Y a_11596_17631# 0.01227f
C3748 _221_.Y a_3407_13333# 0.13305f
C3749 _196_.Y _200_.Y 0.19075f
C3750 _195_.Y _199_.Y 0.17791f
C3751 a_7985_7728# _154_.X 0.22926f
C3752 _225_.A a_14794_8404# 0.03492f
C3753 _148_.B _153_.Y 0.05658f
C3754 a_13184_7183# VPWR 0.40724f
C3755 a_7622_16434# VPWR 0.77363f
C3756 _186_.Y _183_.Y 0.01301f
C3757 a_14757_15213# a_14628_15247# 0.01562f
C3758 _133_.Y a_12886_13350# 0.03563f
C3759 a_7008_16035# _203_.Y 0.2072f
C3760 _147_.Y _145_.X 0.05906f
C3761 _236_.A _131_.A2 0.99474f
C3762 _168_.A _171_.A 0.18543f
C3763 _235_.Y a_15243_12332# 0.42049f
C3764 a_13323_16007# a_13681_15998# 0.02138f
C3765 _205_.Y a_6376_16878# 0.01252f
C3766 a_3014_4650# a_3717_4629# 0.02454f
C3767 _139_.X a_10864_4870# 0.05158f
C3768 a_7985_7728# _122_.A0 0.08806f
C3769 a_4881_12972# VPWR 0.01071f
C3770 _247_.CLK a_2661_12189# 0.26204f
C3771 _168_.A _228_.Y 0.02245f
C3772 _243_.CLK _218_.Y 0.02765f
C3773 _234_.Y a_13391_12287# 0.13292f
C3774 _122_.A0 a_2436_9504# 0.04788f
C3775 _120_.A0 a_2763_12332# 0.02466f
R0 en.n1 en 20.6581
R1 en.n1 en.n0 15.0122
R2 en en.n1 0.0655
R3 freq_in.n1 freq_in 39.6576
R4 freq_in.n1 freq_in.n0 15.0022
R5 freq_in freq_in.n1 0.0933125
R6 rst.n1 rst 21.3943
R7 rst.n1 rst.n0 15.0122
R8 rst rst.n1 0.0655
R9 sclk.n1 sclk 45.8629
R10 sclk.n1 sclk.n0 5.05138
R11 sclk sclk.n1 0.128146
R12 sdata.n1 sdata 21.7639
R13 sdata.n1 sdata.n0 15.0122
R14 sdata sdata.n1 0.0655
C3776 freq_out VGND 0.7087f
C3777 sdata VGND 0.82471f
C3778 sclk VGND 2.15722f
C3779 en VGND 0.52838f
C3780 freq_in VGND 2.19683f
C3781 rst VGND 0.70122f
C3782 VPWR VGND 0.39129p
C3783 a_17120_3270# VGND 0.08559f
C3784 a_8288_3060# VGND 0.01015f $ **FLOATING
C3785 a_8288_3270# VGND 0.04669f
C3786 a_11475_4248# VGND 0.01118f $ **FLOATING
C3787 a_10769_4258# VGND 0.35936f $ **FLOATING
C3788 a_8288_3986# VGND 0.04109f
C3789 a_8557_4248# VGND 0.7084f $ **FLOATING
C3790 _144_.Y VGND 0.6049f $ **FLOATING
C3791 _143_.Y VGND 0.43329f $ **FLOATING
C3792 a_8288_4330# VGND 0.01052f $ **FLOATING
C3793 a_6810_3863# VGND 0.36266f $ **FLOATING
C3794 a_6095_4270# VGND 0.13999f $ **FLOATING
C3795 a_6060_4166# VGND 0.43431f $ **FLOATING
C3796 a_3793_4261# VGND 0.09545f $ **FLOATING
C3797 a_4554_3900# VGND 0.4366f $ **FLOATING
C3798 a_3887_4261# VGND 0.53467f $ **FLOATING
C3799 a_4144_4142# VGND 0.24462f $ **FLOATING
C3800 a_3147_3911# VGND 0.37325f $ **FLOATING
C3801 a_2916_4325# VGND 0.03599f $ **FLOATING
C3802 a_2240_3986# VGND 0.0454f
C3803 a_3045_3911# VGND 0.77f $ **FLOATING
C3804 a_2628_3904# VGND 1.57733f $ **FLOATING
C3805 a_2602_3868# VGND 0.24143f $ **FLOATING
C3806 a_2342_4338# VGND 0.18801f $ **FLOATING
C3807 a_16736_4782# VGND 0.04656f
C3808 a_14624_4572# VGND 0.01015f $ **FLOATING
C3809 a_16840_4688# VGND 0.38108f $ **FLOATING
C3810 a_14624_4782# VGND 0.04556f
C3811 a_13376_4572# VGND 0.01022f $ **FLOATING
C3812 a_13376_4782# VGND 0.04229f
C3813 a_12128_4782# VGND 0.04481f
C3814 _147_.B1 VGND 0.61253f $ **FLOATING
C3815 a_10513_4727# VGND 0.09498f $ **FLOATING
C3816 a_9636_4663# VGND 0.03599f $ **FLOATING
C3817 a_13649_4704# VGND 0.3612f $ **FLOATING
C3818 a_12401_4704# VGND 0.35097f $ **FLOATING
C3819 a_11661_4696# VGND 0.27022f $ **FLOATING
C3820 a_11274_4948# VGND 0.41931f $ **FLOATING
C3821 a_10864_4870# VGND 0.24092f $ **FLOATING
C3822 a_10607_4727# VGND 0.52552f $ **FLOATING
C3823 a_9867_4772# VGND 0.37331f $ **FLOATING
C3824 a_9765_4629# VGND 0.78562f $ **FLOATING
C3825 a_9348_4968# VGND 1.57475f $ **FLOATING
C3826 a_9062_4650# VGND 0.19544f $ **FLOATING
C3827 a_9322_4873# VGND 0.24066f $ **FLOATING
C3828 _225_.Y VGND 0.8222f $ **FLOATING
C3829 _136_.B VGND 1.2295f $ **FLOATING
C3830 a_7633_4727# VGND 0.09495f $ **FLOATING
C3831 a_6756_4663# VGND 0.03609f $ **FLOATING
C3832 a_8394_4948# VGND 0.42019f $ **FLOATING
C3833 a_7984_4870# VGND 0.24205f $ **FLOATING
C3834 a_7727_4727# VGND 0.52684f $ **FLOATING
C3835 a_5608_4572# VGND 0.02109f
C3836 a_6987_4772# VGND 0.37305f $ **FLOATING
C3837 a_6885_4629# VGND 0.77078f $ **FLOATING
C3838 a_6468_4968# VGND 1.58076f $ **FLOATING
C3839 a_6182_4650# VGND 0.17622f $ **FLOATING
C3840 _210_.Y VGND 0.40508f $ **FLOATING
C3841 a_6442_4873# VGND 0.2416f $ **FLOATING
C3842 _224_.Y VGND 0.86179f $ **FLOATING
C3843 a_5792_4782# VGND 0.03743f
C3844 a_5608_4782# VGND 0.0824f
C3845 a_4465_4727# VGND 0.09571f $ **FLOATING
C3846 a_3588_4663# VGND 0.03601f $ **FLOATING
C3847 a_5226_4948# VGND 0.4404f $ **FLOATING
C3848 a_4816_4870# VGND 0.26344f $ **FLOATING
C3849 a_4559_4727# VGND 0.53708f $ **FLOATING
C3850 a_1192_4572# VGND 0.01807f $ **FLOATING
C3851 a_3819_4772# VGND 0.3743f $ **FLOATING
C3852 a_3717_4629# VGND 0.78593f $ **FLOATING
C3853 a_3300_4968# VGND 1.5798f $ **FLOATING
C3854 a_3014_4650# VGND 0.17123f $ **FLOATING
C3855 a_3274_4873# VGND 0.23681f $ **FLOATING
C3856 _243_.D VGND 0.39403f $ **FLOATING
C3857 a_2398_4654# VGND 0.68939f $ **FLOATING
C3858 a_2075_4692# VGND 0.31024f $ **FLOATING
C3859 _215_.Y VGND 0.81726f $ **FLOATING
C3860 _243_.RESET_B VGND 1.31031f $ **FLOATING
C3861 a_1376_4782# VGND 0.03681f
C3862 a_1192_4782# VGND 0.1158f
C3863 a_17032_5498# VGND 0.12094f
C3864 a_17032_5842# VGND 0.01542f $ **FLOATING
C3865 a_15889_5773# VGND 0.09506f $ **FLOATING
C3866 a_16650_5412# VGND 0.42059f $ **FLOATING
C3867 a_15983_5773# VGND 0.5268f $ **FLOATING
C3868 a_16240_5654# VGND 0.24057f $ **FLOATING
C3869 a_15243_5423# VGND 0.37688f $ **FLOATING
C3870 a_15012_5837# VGND 0.03599f $ **FLOATING
C3871 a_15141_5423# VGND 0.78751f $ **FLOATING
C3872 a_14724_5416# VGND 1.57616f $ **FLOATING
C3873 a_14698_5380# VGND 0.23744f $ **FLOATING
C3874 a_14438_5850# VGND 0.19477f $ **FLOATING
C3875 _226_.Y VGND 0.88494f $ **FLOATING
C3876 _151_.X VGND 0.58396f $ **FLOATING
C3877 a_13775_5782# VGND 0.13912f $ **FLOATING
C3878 a_12712_5498# VGND 0.08463f
C3879 a_13740_5678# VGND 0.42194f $ **FLOATING
C3880 a_13073_5770# VGND 0.34914f $ **FLOATING
C3881 _157_.B VGND 0.88835f $ **FLOATING
C3882 _147_.Y VGND 1.28917f $ **FLOATING
C3883 a_12712_5842# VGND 0.02465f
C3884 a_12128_5498# VGND 0.05981f
C3885 a_12237_5760# VGND 0.28928f $ **FLOATING
C3886 _147_.A1 VGND 1.09106f $ **FLOATING
C3887 a_10799_5782# VGND 0.13908f $ **FLOATING
C3888 a_10592_5498# VGND 0.05866f
C3889 _139_.X VGND 1.18927f $ **FLOATING
C3890 a_10764_5678# VGND 0.43681f $ **FLOATING
C3891 _144_.B VGND 1.23354f $ **FLOATING
C3892 a_8538_5375# VGND 0.35748f $ **FLOATING
C3893 _252_.D VGND 0.28329f $ **FLOATING
C3894 _138_.Y VGND 1.4193f $ **FLOATING
C3895 a_8021_5782# VGND 0.13912f $ **FLOATING
C3896 a_7872_5451# VGND 0.42424f $ **FLOATING
C3897 a_7616_5498# VGND 0.04838f
C3898 _145_.A2 VGND 1.06131f $ **FLOATING
C3899 a_7616_5842# VGND 0.01022f $ **FLOATING
C3900 _143_.A VGND 1.48043f $ **FLOATING
C3901 a_6656_5498# VGND 0.04585f
C3902 _210_.B VGND 1.11183f $ **FLOATING
C3903 a_6747_5468# VGND 0.38664f $ **FLOATING
C3904 a_4465_5773# VGND 0.09693f $ **FLOATING
C3905 a_5226_5412# VGND 0.45565f $ **FLOATING
C3906 a_4559_5773# VGND 0.54287f $ **FLOATING
C3907 a_4816_5654# VGND 0.26145f $ **FLOATING
C3908 a_3819_5423# VGND 0.37523f $ **FLOATING
C3909 a_3588_5837# VGND 0.03599f $ **FLOATING
C3910 a_3717_5423# VGND 0.78091f $ **FLOATING
C3911 a_3300_5416# VGND 1.57781f $ **FLOATING
C3912 a_3274_5380# VGND 0.2368f $ **FLOATING
C3913 a_3014_5850# VGND 0.1713f $ **FLOATING
C3914 _242_.D VGND 0.26598f $ **FLOATING
C3915 a_1864_5498# VGND 0.10214f
C3916 a_2398_5782# VGND 0.69103f $ **FLOATING
C3917 a_2075_5468# VGND 0.33684f $ **FLOATING
C3918 _210_.A VGND 1.87299f $ **FLOATING
C3919 a_1864_5842# VGND 0.02626f $ **FLOATING
C3920 a_17120_6294# VGND 0.08416f
C3921 a_13121_6188# VGND 0.01151f $ **FLOATING
C3922 a_12800_6084# VGND 0.01026f $ **FLOATING
C3923 a_12800_6294# VGND 0.05981f
C3924 a_1864_6084# VGND 0.02549f $ **FLOATING
C3925 _148_.X VGND 1.24399f $ **FLOATING
C3926 _149_.A VGND 1.6808f $ **FLOATING
C3927 _152_.X VGND 0.63358f $ **FLOATING
C3928 _244_.RESET_B VGND 1.0182f $ **FLOATING
C3929 _244_.D VGND 0.39232f $ **FLOATING
C3930 a_2048_6294# VGND 0.04029f
C3931 a_1864_6294# VGND 0.09943f
C3932 a_2494_6166# VGND 0.69932f $ **FLOATING
C3933 a_2171_6204# VGND 0.33867f $ **FLOATING
C3934 _243_.Q VGND 3.08436f $ **FLOATING
C3935 a_17120_7010# VGND 0.07523f
C3936 a_16936_7010# VGND 0.10058f
C3937 a_16936_7354# VGND 0.02351f $ **FLOATING
C3938 a_12904_7010# VGND 0.08623f
C3939 a_13184_7183# VGND 0.30525f $ **FLOATING
C3940 a_12904_7354# VGND 0.02415f $ **FLOATING
C3941 a_12328_7010# VGND 0.10431f
C3942 a_12328_7354# VGND 0.03224f $ **FLOATING
C3943 a_3956_6888# VGND 4.51242f $ **FLOATING
C3944 a_16936_7596# VGND 0.0235f $ **FLOATING
C3945 a_17120_7806# VGND 0.07483f
C3946 a_16936_7806# VGND 0.09782f
C3947 a_15776_7806# VGND 0.06085f
C3948 a_13973_7678# VGND 0.13969f $ **FLOATING
C3949 a_15980_7638# VGND 0.3854f $ **FLOATING
C3950 a_12032_7596# VGND 0.01061f $ **FLOATING
C3951 a_12549_7996# VGND 0.01023f $ **FLOATING
C3952 a_13824_7989# VGND 0.43869f $ **FLOATING
C3953 _160_.B VGND 1.20133f $ **FLOATING
C3954 a_13073_7728# VGND 0.35665f $ **FLOATING
C3955 _162_.Y VGND 0.58894f $ **FLOATING
C3956 a_12032_7806# VGND 0.06045f
C3957 a_10901_7678# VGND 0.13988f $ **FLOATING
C3958 a_10408_7596# VGND 0.03168f $ **FLOATING
C3959 a_10408_7806# VGND 0.10628f
C3960 a_9466_7678# VGND 0.01001f $ **FLOATING
C3961 a_9248_7596# VGND 0.01046f $ **FLOATING
C3962 a_12215_7664# VGND 0.71017f $ **FLOATING
C3963 a_10752_7989# VGND 0.44107f $ **FLOATING
C3964 a_9248_7806# VGND 0.05999f
C3965 a_7712_7596# VGND 0.01057f $ **FLOATING
C3966 _154_.X VGND 1.44741f $ **FLOATING
C3967 a_7712_7806# VGND 0.06068f
C3968 a_7985_7728# VGND 0.36988f $ **FLOATING
C3969 _148_.A VGND 3.4946f $ **FLOATING
C3970 a_2232_7868# VGND 0.36376f $ **FLOATING
C3971 a_1952_7806# VGND 0.04753f
C3972 _125_.A1 VGND 1.12586f $ **FLOATING
C3973 a_2126_7864# VGND 0.69774f $ **FLOATING
C3974 a_1192_7712# VGND 0.41752f $ **FLOATING
C3975 a_17120_8522# VGND 0.08024f
C3976 _166_.A VGND 1.68578f $ **FLOATING
C3977 a_15985_8797# VGND 0.095f $ **FLOATING
C3978 a_16746_8436# VGND 0.42278f $ **FLOATING
C3979 a_16079_8797# VGND 0.52611f $ **FLOATING
C3980 a_16336_8678# VGND 0.24233f $ **FLOATING
C3981 a_15339_8447# VGND 0.37483f $ **FLOATING
C3982 a_15108_8861# VGND 0.03619f $ **FLOATING
C3983 a_15237_8447# VGND 0.76922f $ **FLOATING
C3984 a_14820_8440# VGND 1.57628f $ **FLOATING
C3985 a_14794_8404# VGND 0.24195f $ **FLOATING
C3986 a_14534_8874# VGND 0.17654f $ **FLOATING
C3987 a_14144_8522# VGND 0.04603f
C3988 _227_.Y VGND 0.91546f $ **FLOATING
C3989 _159_.Y VGND 0.33888f $ **FLOATING
C3990 a_14144_8866# VGND 0.01015f $ **FLOATING
C3991 a_13505_8784# VGND 0.01136f $ **FLOATING
C3992 _158_.Y VGND 0.76822f $ **FLOATING
C3993 a_13184_8522# VGND 0.03626f
C3994 a_13000_8522# VGND 0.07619f
C3995 _151_.B VGND 1.95683f $ **FLOATING
C3996 _157_.Y VGND 0.98002f $ **FLOATING
C3997 a_13000_8866# VGND 0.01918f $ **FLOATING
C3998 _161_.Y VGND 0.38884f $ **FLOATING
C3999 a_12512_8522# VGND 0.0362f
C4000 a_12328_8522# VGND 0.08032f
C4001 a_11974_8436# VGND 0.02698f $ **FLOATING
C4002 _153_.Y VGND 1.4857f $ **FLOATING
C4003 _162_.B VGND 1.81212f $ **FLOATING
C4004 a_12328_8866# VGND 0.01962f $ **FLOATING
C4005 a_12110_8784# VGND 0.01081f $ **FLOATING
C4006 a_10989_8784# VGND 0.43635f $ **FLOATING
C4007 a_10784_8522# VGND 0.04702f
C4008 a_11731_8698# VGND 0.51241f $ **FLOATING
C4009 _164_.B1 VGND 1.07372f $ **FLOATING
C4010 _145_.X VGND 3.52815f $ **FLOATING
C4011 _160_.X VGND 1.44182f $ **FLOATING
C4012 a_10784_8866# VGND 0.01039f $ **FLOATING
C4013 a_9928_8522# VGND 0.08855f
C4014 a_9928_8866# VGND 0.02484f $ **FLOATING
C4015 _170_.Y VGND 0.30481f $ **FLOATING
C4016 a_7634_8802# VGND 0.01188f $ **FLOATING
C4017 a_8488_8436# VGND 0.38969f $ **FLOATING
C4018 a_8014_8492# VGND 0.34972f $ **FLOATING
C4019 a_6677_8806# VGND 0.13968f $ **FLOATING
C4020 a_6528_8475# VGND 0.43476f $ **FLOATING
C4021 a_6184_8522# VGND 0.10907f
C4022 a_6184_8866# VGND 0.03172f $ **FLOATING
C4023 a_5242_8806# VGND 0.01159f $ **FLOATING
C4024 a_3601_8797# VGND 0.09506f $ **FLOATING
C4025 a_4362_8436# VGND 0.43557f $ **FLOATING
C4026 a_3695_8797# VGND 0.52826f $ **FLOATING
C4027 a_3952_8678# VGND 0.24226f $ **FLOATING
C4028 a_2955_8447# VGND 0.37587f $ **FLOATING
C4029 a_2724_8861# VGND 0.03619f $ **FLOATING
C4030 a_2853_8447# VGND 0.77041f $ **FLOATING
C4031 a_2436_8440# VGND 1.57553f $ **FLOATING
C4032 a_2410_8404# VGND 0.23891f $ **FLOATING
C4033 a_2150_8874# VGND 0.1744f $ **FLOATING
C4034 _218_.Y VGND 0.88418f $ **FLOATING
C4035 _122_.X VGND 0.29324f $ **FLOATING
C4036 a_17120_9318# VGND 0.08f
C4037 a_15985_9263# VGND 0.09501f $ **FLOATING
C4038 a_15108_9199# VGND 0.03599f $ **FLOATING
C4039 a_16746_9484# VGND 0.42273f $ **FLOATING
C4040 a_16336_9406# VGND 0.2425f $ **FLOATING
C4041 a_16079_9263# VGND 0.52625f $ **FLOATING
C4042 a_14056_9108# VGND 0.03076f $ **FLOATING
C4043 a_15339_9308# VGND 0.37408f $ **FLOATING
C4044 a_15237_9165# VGND 0.76964f $ **FLOATING
C4045 a_14820_9504# VGND 1.57459f $ **FLOATING
C4046 a_14534_9186# VGND 0.17385f $ **FLOATING
C4047 a_14794_9409# VGND 0.23791f $ **FLOATING
C4048 _213_.Y VGND 0.33652f $ **FLOATING
C4049 a_14056_9318# VGND 0.08851f
C4050 a_11185_9263# VGND 0.09496f $ **FLOATING
C4051 a_10308_9199# VGND 0.03599f $ **FLOATING
C4052 a_11946_9484# VGND 0.43205f $ **FLOATING
C4053 a_11536_9406# VGND 0.24569f $ **FLOATING
C4054 a_11279_9263# VGND 0.52777f $ **FLOATING
C4055 a_9269_9190# VGND 0.13904f $ **FLOATING
C4056 a_8705_9212# VGND 0.01137f $ **FLOATING
C4057 a_10539_9308# VGND 0.37167f $ **FLOATING
C4058 a_10437_9165# VGND 0.78729f $ **FLOATING
C4059 a_10020_9504# VGND 1.57784f $ **FLOATING
C4060 a_9734_9186# VGND 0.17375f $ **FLOATING
C4061 _228_.Y VGND 0.94184f $ **FLOATING
C4062 a_9994_9409# VGND 0.23778f $ **FLOATING
C4063 _172_.Y VGND 0.28772f $ **FLOATING
C4064 a_7841_9212# VGND 0.01135f $ **FLOATING
C4065 a_7336_9108# VGND 0.01872f $ **FLOATING
C4066 a_7520_9318# VGND 0.03786f
C4067 a_7336_9318# VGND 0.0771f
C4068 a_6962_9194# VGND 0.01187f $ **FLOATING
C4069 a_6483_9212# VGND 0.01139f $ **FLOATING
C4070 a_6106_9190# VGND 0.01019f $ **FLOATING
C4071 a_5800_9108# VGND 0.03043f $ **FLOATING
C4072 a_9120_9501# VGND 0.427f $ **FLOATING
C4073 _180_.X VGND 0.67257f $ **FLOATING
C4074 _170_.B VGND 0.99057f $ **FLOATING
C4075 _165_.Y VGND 0.77977f $ **FLOATING
C4076 _168_.Y VGND 0.87308f $ **FLOATING
C4077 a_5800_9318# VGND 0.08623f
C4078 a_4928_9108# VGND 0.01062f $ **FLOATING
C4079 a_4744_9108# VGND 0.02169f $ **FLOATING
C4080 a_4928_9318# VGND 0.0448f
C4081 a_4744_9318# VGND 0.08447f
C4082 a_3601_9263# VGND 0.09505f $ **FLOATING
C4083 a_2724_9199# VGND 0.03599f $ **FLOATING
C4084 _168_.A VGND 1.49894f $ **FLOATING
C4085 _168_.B VGND 1.18718f $ **FLOATING
C4086 a_5201_9240# VGND 0.36907f $ **FLOATING
C4087 _136_.A VGND 5.35431f $ **FLOATING
C4088 a_4362_9484# VGND 0.42423f $ **FLOATING
C4089 a_3952_9406# VGND 0.2437f $ **FLOATING
C4090 a_3695_9263# VGND 0.52792f $ **FLOATING
C4091 _243_.CLK VGND 4.07971f $ **FLOATING
C4092 a_2955_9308# VGND 0.3741f $ **FLOATING
C4093 a_2853_9165# VGND 0.76917f $ **FLOATING
C4094 a_2436_9504# VGND 1.57465f $ **FLOATING
C4095 a_2150_9186# VGND 0.17261f $ **FLOATING
C4096 a_2410_9409# VGND 0.23759f $ **FLOATING
C4097 _219_.Y VGND 0.8799f $ **FLOATING
C4098 a_17120_10034# VGND 0.09612f
C4099 _260_.RESET_B VGND 0.87714f $ **FLOATING
C4100 _171_.Y VGND 1.31533f $ **FLOATING
C4101 a_8050_10326# VGND 0.21816f $ **FLOATING
C4102 a_7808_10034# VGND 0.03893f
C4103 a_7624_10034# VGND 0.07413f
C4104 _164_.Y VGND 1.65675f $ **FLOATING
C4105 _183_.Y VGND 0.37113f $ **FLOATING
C4106 a_7624_10378# VGND 0.02172f $ **FLOATING
C4107 _185_.Y VGND 0.40773f $ **FLOATING
C4108 a_7251_10296# VGND 0.01118f $ **FLOATING
C4109 _171_.A VGND 1.09603f $ **FLOATING
C4110 _184_.Y VGND 0.41009f $ **FLOATING
C4111 _178_.Y VGND 0.73795f $ **FLOATING
C4112 _177_.X VGND 0.47799f $ **FLOATING
C4113 a_6124_9945# VGND 0.28557f $ **FLOATING
C4114 _174_.Y VGND 0.95411f $ **FLOATING
C4115 _173_.Y VGND 1.54338f $ **FLOATING
C4116 a_1864_10034# VGND 0.10236f
C4117 _246_.D VGND 0.29168f $ **FLOATING
C4118 _122_.A0 VGND 2.46916f $ **FLOATING
C4119 a_2232_10210# VGND 0.3614f $ **FLOATING
C4120 a_2126_10214# VGND 0.69488f $ **FLOATING
C4121 a_1864_10378# VGND 0.02468f $ **FLOATING
C4122 a_17032_10620# VGND 0.02267f $ **FLOATING
C4123 a_17032_10830# VGND 0.12439f
C4124 a_14753_10724# VGND 0.01118f $ **FLOATING
C4125 a_14432_10830# VGND 0.04722f
C4126 a_8501_10702# VGND 0.13916f $ **FLOATING
C4127 a_3592_10620# VGND 0.03149f $ **FLOATING
C4128 a_8352_11013# VGND 0.44981f $ **FLOATING
C4129 _181_.Y VGND 0.66657f $ **FLOATING
C4130 _179_.Y VGND 1.4418f $ **FLOATING
C4131 a_3592_10830# VGND 0.08873f
C4132 a_3886_10702# VGND 4.49273f $ **FLOATING
C4133 a_17120_11546# VGND 0.08024f
C4134 a_15985_11821# VGND 0.09504f $ **FLOATING
C4135 a_16746_11460# VGND 0.42387f $ **FLOATING
C4136 a_16079_11821# VGND 0.52753f $ **FLOATING
C4137 a_16336_11702# VGND 0.24231f $ **FLOATING
C4138 a_15339_11471# VGND 0.3741f $ **FLOATING
C4139 a_15108_11885# VGND 0.03599f $ **FLOATING
C4140 a_15237_11471# VGND 0.77728f $ **FLOATING
C4141 a_14820_11464# VGND 1.57576f $ **FLOATING
C4142 a_14794_11428# VGND 0.23777f $ **FLOATING
C4143 a_14534_11898# VGND 0.17261f $ **FLOATING
C4144 a_13985_11808# VGND 0.01118f $ **FLOATING
C4145 _236_.Y VGND 0.89171f $ **FLOATING
C4146 _131_.Y VGND 0.28712f $ **FLOATING
C4147 a_13025_11808# VGND 0.01118f $ **FLOATING
C4148 a_12704_11546# VGND 0.04708f
C4149 _132_.Y VGND 0.53557f $ **FLOATING
C4150 _178_.B1 VGND 1.19796f $ **FLOATING
C4151 a_6485_11830# VGND 0.14012f $ **FLOATING
C4152 a_6336_11499# VGND 0.44122f $ **FLOATING
C4153 a_6080_11546# VGND 0.04981f
C4154 a_6080_11890# VGND 0.01052f $ **FLOATING
C4155 a_1952_11546# VGND 0.049f
C4156 _173_.A VGND 2.47845f $ **FLOATING
C4157 a_2232_11722# VGND 0.36533f $ **FLOATING
C4158 a_2126_11726# VGND 0.69139f $ **FLOATING
C4159 a_1192_11460# VGND 0.4162f $ **FLOATING
C4160 a_17032_12132# VGND 0.01528f $ **FLOATING
C4161 a_17032_12342# VGND 0.12133f
C4162 a_15889_12287# VGND 0.09497f $ **FLOATING
C4163 a_15012_12223# VGND 0.03599f $ **FLOATING
C4164 a_16650_12508# VGND 0.42204f $ **FLOATING
C4165 a_16240_12430# VGND 0.2451f $ **FLOATING
C4166 a_15983_12287# VGND 0.52764f $ **FLOATING
C4167 a_15243_12332# VGND 0.37298f $ **FLOATING
C4168 a_15141_12189# VGND 0.77919f $ **FLOATING
C4169 a_14724_12528# VGND 1.57407f $ **FLOATING
C4170 a_14438_12210# VGND 0.17167f $ **FLOATING
C4171 _129_.Y VGND 0.35535f $ **FLOATING
C4172 _235_.Y VGND 0.90927f $ **FLOATING
C4173 a_14698_12433# VGND 0.23794f $ **FLOATING
C4174 a_13297_12287# VGND 0.09496f $ **FLOATING
C4175 a_12420_12223# VGND 0.03599f $ **FLOATING
C4176 a_14058_12508# VGND 0.4191f $ **FLOATING
C4177 a_13648_12430# VGND 0.24387f $ **FLOATING
C4178 a_13391_12287# VGND 0.52429f $ **FLOATING
C4179 a_12651_12332# VGND 0.37135f $ **FLOATING
C4180 a_12549_12189# VGND 0.79013f $ **FLOATING
C4181 a_12132_12528# VGND 1.57494f $ **FLOATING
C4182 a_11846_12210# VGND 0.17493f $ **FLOATING
C4183 _126_.Y VGND 0.61459f $ **FLOATING
C4184 a_12106_12433# VGND 0.2376f $ **FLOATING
C4185 _234_.Y VGND 0.90992f $ **FLOATING
C4186 a_11456_12342# VGND 0.04163f
C4187 a_10321_12287# VGND 0.09501f $ **FLOATING
C4188 a_9444_12223# VGND 0.03599f $ **FLOATING
C4189 a_11082_12508# VGND 0.42128f $ **FLOATING
C4190 a_10672_12430# VGND 0.24359f $ **FLOATING
C4191 a_10415_12287# VGND 0.52905f $ **FLOATING
C4192 _251_.CLK VGND 5.30401f $ **FLOATING
C4193 a_9675_12332# VGND 0.37278f $ **FLOATING
C4194 a_9573_12189# VGND 0.78603f $ **FLOATING
C4195 a_9156_12528# VGND 1.57435f $ **FLOATING
C4196 a_8870_12210# VGND 0.17432f $ **FLOATING
C4197 _182_.Y VGND 0.5356f $ **FLOATING
C4198 a_9130_12433# VGND 0.23823f $ **FLOATING
C4199 _229_.Y VGND 0.89173f $ **FLOATING
C4200 a_6482_12218# VGND 0.01261f $ **FLOATING
C4201 a_6272_12132# VGND 0.01055f $ **FLOATING
C4202 _176_.A VGND 1.82886f $ **FLOATING
C4203 a_6272_12342# VGND 0.04626f
C4204 a_4858_12214# VGND 0.0112f $ **FLOATING
C4205 a_4552_12132# VGND 0.01808f $ **FLOATING
C4206 _176_.B VGND 1.49846f $ **FLOATING
C4207 a_4552_12342# VGND 0.0836f
C4208 a_3409_12287# VGND 0.09495f $ **FLOATING
C4209 a_2532_12223# VGND 0.03599f $ **FLOATING
C4210 a_5297_12264# VGND 0.37317f $ **FLOATING
C4211 a_4170_12508# VGND 0.42346f $ **FLOATING
C4212 a_3760_12430# VGND 0.24196f $ **FLOATING
C4213 a_3503_12287# VGND 0.52263f $ **FLOATING
C4214 a_1568_12132# VGND 0.01015f $ **FLOATING
C4215 a_2763_12332# VGND 0.37181f $ **FLOATING
C4216 a_2661_12189# VGND 0.78473f $ **FLOATING
C4217 a_2244_12528# VGND 1.57578f $ **FLOATING
C4218 a_1958_12210# VGND 0.17276f $ **FLOATING
C4219 _120_.X VGND 0.39629f $ **FLOATING
C4220 a_2218_12433# VGND 0.23747f $ **FLOATING
C4221 _220_.Y VGND 0.84848f $ **FLOATING
C4222 a_1568_12342# VGND 0.04662f
C4223 _131_.B1 VGND 0.49204f $ **FLOATING
C4224 a_14451_13320# VGND 0.01118f $ **FLOATING
C4225 a_14240_13058# VGND 0.04039f
C4226 _260_.CLK VGND 2.70626f $ **FLOATING
C4227 _129_.B1 VGND 0.44472f $ **FLOATING
C4228 a_13366_13350# VGND 0.21694f $ **FLOATING
C4229 a_5084_12972# VGND 0.01122f $ **FLOATING
C4230 a_6881_13320# VGND 0.01161f $ **FLOATING
C4231 a_12886_13350# VGND 0.27546f $ **FLOATING
C4232 _126_.B1 VGND 1.81427f $ **FLOATING
C4233 _131_.A2 VGND 2.49595f $ **FLOATING
C4234 _133_.Y VGND 0.72784f $ **FLOATING
C4235 _128_.B1 VGND 0.67678f $ **FLOATING
C4236 _192_.B VGND 0.75846f $ **FLOATING
C4237 _187_.Y VGND 0.91291f $ **FLOATING
C4238 _192_.C VGND 0.68701f $ **FLOATING
C4239 a_6197_13342# VGND 0.14008f $ **FLOATING
C4240 a_6048_13011# VGND 0.42964f $ **FLOATING
C4241 a_5178_13330# VGND 0.01131f $ **FLOATING
C4242 a_4640_13058# VGND 0.03938f
C4243 a_4456_13058# VGND 0.08019f
C4244 a_4913_13330# VGND 0.38448f $ **FLOATING
C4245 a_4456_13402# VGND 0.02131f
C4246 a_3313_13333# VGND 0.09499f $ **FLOATING
C4247 a_4074_12972# VGND 0.42211f $ **FLOATING
C4248 a_3407_13333# VGND 0.52301f $ **FLOATING
C4249 a_3664_13214# VGND 0.24074f $ **FLOATING
C4250 a_2667_12983# VGND 0.36985f $ **FLOATING
C4251 a_2436_13397# VGND 0.03599f $ **FLOATING
C4252 a_2565_12983# VGND 0.78617f $ **FLOATING
C4253 a_2148_12976# VGND 1.57573f $ **FLOATING
C4254 a_2122_12940# VGND 0.23709f $ **FLOATING
C4255 a_1862_13410# VGND 0.18429f $ **FLOATING
C4256 _221_.Y VGND 1.06055f $ **FLOATING
C4257 a_1580_12936# VGND 0.3502f $ **FLOATING
C4258 _215_.A VGND 4.74213f $ **FLOATING
C4259 a_17120_13854# VGND 0.08486f
C4260 a_12808_13644# VGND 0.02464f $ **FLOATING
C4261 a_12808_13854# VGND 0.10543f
C4262 a_13100_13686# VGND 0.38702f $ **FLOATING
C4263 a_10321_13799# VGND 0.09501f $ **FLOATING
C4264 a_9444_13735# VGND 0.03599f $ **FLOATING
C4265 a_11082_14020# VGND 0.43062f $ **FLOATING
C4266 a_10672_13942# VGND 0.24358f $ **FLOATING
C4267 a_10415_13799# VGND 0.52561f $ **FLOATING
C4268 a_6760_13644# VGND 0.02665f $ **FLOATING
C4269 a_9675_13844# VGND 0.37477f $ **FLOATING
C4270 a_9573_13701# VGND 0.78499f $ **FLOATING
C4271 a_9156_14040# VGND 1.57617f $ **FLOATING
C4272 a_8870_13722# VGND 0.17432f $ **FLOATING
C4273 a_9130_13945# VGND 0.23828f $ **FLOATING
C4274 _230_.Y VGND 0.8966f $ **FLOATING
C4275 _194_.X VGND 0.52271f $ **FLOATING
C4276 a_6760_13854# VGND 0.08907f
C4277 a_6106_13726# VGND 0.01021f $ **FLOATING
C4278 a_5704_13644# VGND 0.02824f $ **FLOATING
C4279 _192_.Y VGND 0.47769f $ **FLOATING
C4280 a_5888_13854# VGND 0.03774f
C4281 a_5704_13854# VGND 0.08243f
C4282 a_1864_13644# VGND 0.02468f
C4283 a_7985_13776# VGND 0.35748f $ **FLOATING
C4284 a_6958_13764# VGND 0.36438f $ **FLOATING
C4285 _190_.A VGND 1.89586f $ **FLOATING
C4286 _189_.X VGND 1.29512f $ **FLOATING
C4287 clkbuf_1_0__f_sclk.A VGND 6.15152f $ **FLOATING
C4288 a_3380_13690# VGND 4.49787f $ **FLOATING
C4289 clkload0.Y VGND 0.13389f $ **FLOATING
C4290 _120_.A0 VGND 1.9611f $ **FLOATING
C4291 a_2232_13916# VGND 0.31609f $ **FLOATING
C4292 a_1864_13854# VGND 0.10386f
C4293 _119_.X VGND 0.41949f $ **FLOATING
C4294 a_2126_13912# VGND 0.69229f $ **FLOATING
C4295 a_7553_14832# VGND 0.01135f $ **FLOATING
C4296 a_7232_14570# VGND 0.05838f
C4297 a_7232_14914# VGND 0.01009f $ **FLOATING
C4298 a_17032_15156# VGND 0.02267f $ **FLOATING
C4299 a_17032_15366# VGND 0.12221f
C4300 _133_.B VGND 2.15146f $ **FLOATING
C4301 a_15505_15311# VGND 0.09507f $ **FLOATING
C4302 a_14628_15247# VGND 0.03599f $ **FLOATING
C4303 a_16266_15532# VGND 0.43367f $ **FLOATING
C4304 a_15856_15454# VGND 0.24674f $ **FLOATING
C4305 a_15599_15311# VGND 0.52326f $ **FLOATING
C4306 a_12424_15156# VGND 0.03076f $ **FLOATING
C4307 a_14859_15356# VGND 0.37228f $ **FLOATING
C4308 a_14757_15213# VGND 0.77938f $ **FLOATING
C4309 a_14340_15552# VGND 1.57413f $ **FLOATING
C4310 a_14054_15234# VGND 0.17262f $ **FLOATING
C4311 a_14314_15457# VGND 0.23709f $ **FLOATING
C4312 _239_.Y VGND 0.8547f $ **FLOATING
C4313 _134_.Y VGND 0.57815f $ **FLOATING
C4314 a_12992_15437# VGND 0.30199f $ **FLOATING
C4315 a_12424_15366# VGND 0.08847f
C4316 a_5906_15242# VGND 0.01205f $ **FLOATING
C4317 a_5427_15260# VGND 0.01169f $ **FLOATING
C4318 a_5050_15238# VGND 0.01381f $ **FLOATING
C4319 a_4744_15156# VGND 0.02498f $ **FLOATING
C4320 _193_.Y VGND 1.89826f $ **FLOATING
C4321 a_7616_15437# VGND 0.30215f $ **FLOATING
C4322 _186_.Y VGND 2.15369f $ **FLOATING
C4323 _204_.X VGND 0.39918f $ **FLOATING
C4324 _191_.Y VGND 1.42159f $ **FLOATING
C4325 a_6286_15276# VGND 0.35575f $ **FLOATING
C4326 _200_.Y VGND 0.59926f $ **FLOATING
C4327 _199_.Y VGND 0.98543f $ **FLOATING
C4328 a_4744_15366# VGND 0.08702f
C4329 a_1864_15156# VGND 0.02468f $ **FLOATING
C4330 _195_.Y VGND 0.76663f $ **FLOATING
C4331 _196_.Y VGND 1.04762f $ **FLOATING
C4332 _148_.B VGND 5.86569f $ **FLOATING
C4333 _119_.A0 VGND 2.48851f $ **FLOATING
C4334 a_2232_15428# VGND 0.36075f $ **FLOATING
C4335 a_1864_15366# VGND 0.1018f
C4336 a_2126_15424# VGND 0.6952f $ **FLOATING
C4337 a_17032_16082# VGND 0.13614f
C4338 a_17032_16426# VGND 0.0229f $ **FLOATING
C4339 _264_.Q VGND 0.56823f $ **FLOATING
C4340 a_13969_16357# VGND 0.09499f $ **FLOATING
C4341 a_14730_15996# VGND 0.42017f $ **FLOATING
C4342 a_14063_16357# VGND 0.52108f $ **FLOATING
C4343 a_14320_16238# VGND 0.24075f $ **FLOATING
C4344 a_13323_16007# VGND 0.37311f $ **FLOATING
C4345 a_13092_16421# VGND 0.03599f $ **FLOATING
C4346 a_12416_16082# VGND 0.03904f
C4347 a_13221_16007# VGND 0.79069f $ **FLOATING
C4348 a_12804_16000# VGND 1.57478f $ **FLOATING
C4349 a_12778_15964# VGND 0.23786f $ **FLOATING
C4350 a_12518_16434# VGND 0.1862f $ **FLOATING
C4351 _237_.Y VGND 0.81118f $ **FLOATING
C4352 _135_.X VGND 0.38095f $ **FLOATING
C4353 a_11944_16082# VGND 0.08676f
C4354 a_11944_16426# VGND 0.02484f $ **FLOATING
C4355 a_11168_16082# VGND 0.0414f
C4356 a_9073_16357# VGND 0.09496f $ **FLOATING
C4357 a_9834_15996# VGND 0.42951f $ **FLOATING
C4358 a_9167_16357# VGND 0.52731f $ **FLOATING
C4359 a_9424_16238# VGND 0.24295f $ **FLOATING
C4360 a_8427_16007# VGND 0.37231f $ **FLOATING
C4361 a_8196_16421# VGND 0.03599f $ **FLOATING
C4362 a_8325_16007# VGND 0.77689f $ **FLOATING
C4363 a_7908_16000# VGND 1.57345f $ **FLOATING
C4364 a_7882_15964# VGND 0.23734f $ **FLOATING
C4365 a_7622_16434# VGND 0.17205f $ **FLOATING
C4366 _203_.Y VGND 0.24938f $ **FLOATING
C4367 a_7157_16366# VGND 0.13905f $ **FLOATING
C4368 a_7008_16035# VGND 0.43398f $ **FLOATING
C4369 a_5147_15996# VGND 0.01589f $ **FLOATING
C4370 _202_.Y VGND 0.65801f $ **FLOATING
C4371 a_5249_16344# VGND 0.01506f $ **FLOATING
C4372 a_4928_16082# VGND 0.045f
C4373 _201_.Y VGND 1.03856f $ **FLOATING
C4374 a_4928_16426# VGND 0.01271f $ **FLOATING
C4375 _206_.Y VGND 0.5426f $ **FLOATING
C4376 a_4462_16052# VGND 0.35277f $ **FLOATING
C4377 a_3313_16357# VGND 0.09498f $ **FLOATING
C4378 a_4074_15996# VGND 0.4233f $ **FLOATING
C4379 a_3407_16357# VGND 0.52701f $ **FLOATING
C4380 a_3664_16238# VGND 0.24082f $ **FLOATING
C4381 a_2667_16007# VGND 0.37231f $ **FLOATING
C4382 a_2436_16421# VGND 0.03599f $ **FLOATING
C4383 a_2565_16007# VGND 0.77032f $ **FLOATING
C4384 a_2148_16000# VGND 1.57487f $ **FLOATING
C4385 a_2122_15964# VGND 0.23693f $ **FLOATING
C4386 a_1862_16434# VGND 0.17261f $ **FLOATING
C4387 a_17120_16878# VGND 0.08404f
C4388 a_14830_16746# VGND 0.09497f $ **FLOATING
C4389 a_15722_16904# VGND 0.03599f $ **FLOATING
C4390 _211_.Y VGND 0.79786f $ **FLOATING
C4391 a_15861_16904# VGND 0.23884f $ **FLOATING
C4392 a_15767_17137# VGND 0.20744f $ **FLOATING
C4393 a_14940_16710# VGND 1.57455f $ **FLOATING
C4394 a_14919_16964# VGND 0.37225f $ **FLOATING
C4395 a_14572_16746# VGND 0.242f $ **FLOATING
C4396 a_15071_17016# VGND 0.78778f $ **FLOATING
C4397 _238_.Y VGND 1.16452f $ **FLOATING
C4398 a_14048_16878# VGND 0.04892f
C4399 _135_.A VGND 1.1722f $ **FLOATING
C4400 _266_.CLK VGND 1.80125f $ **FLOATING
C4401 a_12529_16823# VGND 0.095f $ **FLOATING
C4402 a_11652_16759# VGND 0.03599f $ **FLOATING
C4403 a_14359_16710# VGND 0.52641f $ **FLOATING
C4404 a_14240_16921# VGND 0.42231f $ **FLOATING
C4405 a_13290_17044# VGND 0.43026f $ **FLOATING
C4406 a_12880_16966# VGND 0.24177f $ **FLOATING
C4407 a_12623_16823# VGND 0.52573f $ **FLOATING
C4408 a_10888_16668# VGND 0.02298f $ **FLOATING
C4409 a_11883_16868# VGND 0.37109f $ **FLOATING
C4410 a_11781_16725# VGND 0.78975f $ **FLOATING
C4411 a_11364_17064# VGND 1.57423f $ **FLOATING
C4412 a_11078_16746# VGND 0.1824f $ **FLOATING
C4413 _212_.Y VGND 0.60417f $ **FLOATING
C4414 a_10888_16878# VGND 0.07974f
C4415 _241_.Y VGND 1.0153f $ **FLOATING
C4416 a_11338_16969# VGND 0.2372f $ **FLOATING
C4417 a_9457_16823# VGND 0.09498f $ **FLOATING
C4418 a_8580_16759# VGND 0.03599f $ **FLOATING
C4419 a_10218_17044# VGND 0.41833f $ **FLOATING
C4420 a_9808_16966# VGND 0.24364f $ **FLOATING
C4421 a_9551_16823# VGND 0.52349f $ **FLOATING
C4422 fanout7.A VGND 4.52331f $ **FLOATING
C4423 a_8811_16868# VGND 0.37043f $ **FLOATING
C4424 a_8709_16725# VGND 0.78396f $ **FLOATING
C4425 a_8292_17064# VGND 1.57463f $ **FLOATING
C4426 a_8006_16746# VGND 0.17365f $ **FLOATING
C4427 a_8266_16969# VGND 0.24011f $ **FLOATING
C4428 _232_.Y VGND 0.89942f $ **FLOATING
C4429 _258_.RESET_B VGND 1.06291f $ **FLOATING
C4430 a_7328_16878# VGND 0.042f
C4431 a_6869_16750# VGND 0.13929f $ **FLOATING
C4432 a_6376_16668# VGND 0.03162f $ **FLOATING
C4433 _209_.Y VGND 0.33563f $ **FLOATING
C4434 a_6376_16878# VGND 0.09255f
C4435 a_5525_16750# VGND 0.13989f $ **FLOATING
C4436 _199_.B1 VGND 0.93183f $ **FLOATING
C4437 a_3313_16823# VGND 0.09498f $ **FLOATING
C4438 a_2436_16759# VGND 0.03599f $ **FLOATING
C4439 a_6720_17061# VGND 0.42432f $ **FLOATING
C4440 _208_.X VGND 0.76728f $ **FLOATING
C4441 _205_.Y VGND 1.38485f $ **FLOATING
C4442 a_5376_17061# VGND 0.44032f $ **FLOATING
C4443 _207_.A1 VGND 1.51323f $ **FLOATING
C4444 a_4625_16800# VGND 0.36443f $ **FLOATING
C4445 _207_.Y VGND 1.15687f $ **FLOATING
C4446 a_4074_17044# VGND 0.42411f $ **FLOATING
C4447 a_3664_16966# VGND 0.24248f $ **FLOATING
C4448 a_3407_16823# VGND 0.52688f $ **FLOATING
C4449 _247_.CLK VGND 3.59784f $ **FLOATING
C4450 a_2667_16868# VGND 0.37243f $ **FLOATING
C4451 a_2565_16725# VGND 0.76912f $ **FLOATING
C4452 a_2148_17064# VGND 1.57486f $ **FLOATING
C4453 a_1862_16746# VGND 0.18417f $ **FLOATING
C4454 _118_.X VGND 0.39754f $ **FLOATING
C4455 _222_.Y VGND 0.86647f $ **FLOATING
C4456 a_2122_16969# VGND 0.23693f $ **FLOATING
C4457 a_1580_16710# VGND 0.35399f $ **FLOATING
C4458 _250_.RESET_B VGND 1.15448f $ **FLOATING
C4459 _222_.A VGND 2.27888f $ **FLOATING
C4460 a_17032_17594# VGND 0.13785f
C4461 a_17032_17938# VGND 0.0229f $ **FLOATING
C4462 _214_.A VGND 0.91169f $ **FLOATING
C4463 a_11185_17869# VGND 0.09495f $ **FLOATING
C4464 a_11946_17508# VGND 0.43022f $ **FLOATING
C4465 a_11279_17869# VGND 0.5235f $ **FLOATING
C4466 a_11536_17750# VGND 0.23957f $ **FLOATING
C4467 a_10539_17519# VGND 0.36894f $ **FLOATING
C4468 a_10308_17933# VGND 0.03599f $ **FLOATING
C4469 a_10437_17519# VGND 0.78254f $ **FLOATING
C4470 a_10020_17512# VGND 1.57691f $ **FLOATING
C4471 a_9994_17476# VGND 0.2369f $ **FLOATING
C4472 a_9734_17946# VGND 0.17188f $ **FLOATING
C4473 a_9160_17594# VGND 0.10422f
C4474 _240_.Y VGND 0.83608f $ **FLOATING
C4475 _214_.Y VGND 0.60258f $ **FLOATING
C4476 a_9352_17508# VGND 0.36948f $ **FLOATING
C4477 a_9160_17938# VGND 0.02767f $ **FLOATING
C4478 _207_.A2 VGND 1.2007f $ **FLOATING
C4479 a_4661_17878# VGND 0.14301f $ **FLOATING
C4480 a_4512_17547# VGND 0.45843f $ **FLOATING
C4481 fanout6.A VGND 2.50217f $ **FLOATING
C4482 a_1952_17594# VGND 0.04782f
C4483 _250_.D VGND 0.39f $ **FLOATING
C4484 _124_.S VGND 5.78887f $ **FLOATING
C4485 _118_.A0 VGND 1.77538f $ **FLOATING
C4486 _250_.Q VGND 1.23748f $ **FLOATING
C4487 a_2232_17770# VGND 0.36075f $ **FLOATING
C4488 a_2126_17774# VGND 0.69385f $ **FLOATING
C4489 fanout8.A VGND 2.94829f $ **FLOATING
C4490 a_1192_17508# VGND 0.41327f $ **FLOATING
C4491 a_9928_18180# VGND 0.02464f $ **FLOATING
C4492 a_9928_18390# VGND 0.10516f
C4493 _236_.A VGND 4.78192f $ **FLOATING
C4494 _225_.A VGND 6.15739f $ **FLOATING
C4495 a_10220_18222# VGND 0.38703f $ **FLOATING
.ends
