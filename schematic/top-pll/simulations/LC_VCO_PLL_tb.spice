** sch_path: /foss/designs/frac-n-pll-vco-unic_cass/schematic/top-pll/LC_VCO_PLL_tb.sch
**.subckt LC_VCO_PLL_tb
V1 VDD GND 1.2
I0 VDD Vbias2 50u
Vfref CLK_IN GND 0 pulse(0 1.2 0n 1n 1n 50n 100n)
I1 Vbias1 GND 50u
x1 VDD CLK_IN CLK_OUT Vbias2 OUTn Vbias1 GND LC_VCO_PLL
**** begin user architecture code

*****************************************************
* PLL + DSM Frequency Divider Testbench (Optimized)
*****************************************************

.option temp=27
.param VDD=1.2

* ==============================
* Include Models & Stimuli
* ==============================
.include ./IHP_4nH_Inductor.spice
.include stimuli_test.cir

* ==============================
* Simulation Options (Optimized for Speed & Stability)
* ==============================
* gear method improves stability for long oscillator runs
* reltol=1e-3 prevents the simulator from bogging down on microscopic errors
.options reltol=1e-3 abstol=1e-9 vntol=1e-6 method=gear

* ==============================
* Initial Conditions (Speed Hack)
* ==============================
* Uncomment the line below to pre-charge the loop filter to your expected
* V_tune voltage (e.g., 0.6V). This skips the massive initial frequency jump.
.ic v(x2.vctrl)=0.606
.ic v(x2.x1.ctrl1)=0.606
.ic v(x2.x1.ctrl2)=0.606
.op
*.nodeset v(x2.vctrl)=0.606
*.nodeset v(x2.x1.ctrl1)=0.606
*.nodeset v(x2.x1.ctrl2)=0.606

.control
  * CRITICAL: Save ONLY essential low-frequency signals.
  * Saving 2.4GHz nodes for 100us will crash your memory.
  save x2.vctrl x2.up x2.dn x2.dsm_out clk_out clk_in vbias1 vbias2
  *save all

  * 20p defines the step to resolve the 2.4 GHz edges without forcing a maxstep.
  tran 30p 50n uic

  remzerovec
  write pll_top.raw
.endc

.lib cornerMOSlv.lib mos_tt
.lib cornerHBT.lib hbt_typ
.lib cornerRES.lib res_typ
.lib cornerCAP.lib cap_typ_stat
.include /foss/pdks/ihp-sg13g2/libs.ref/sg13g2_stdcell/spice/sg13g2_stdcell.spice
.global VDD GND

.param CP_N_L = 1u
.param CP_N_W = 3u
.param CP_P_M = 1
.param CP_P_L = 1u
.param CP_P_W = 10u
.param CP_N_M = 1

**** end user architecture code
**.ends

* expanding   symbol:  LC_VCO_PLL.sym # of pins=7
** sym_path: /foss/designs/frac-n-pll-vco-unic_cass/schematic/top-pll/LC_VCO_PLL.sym
** sch_path: /foss/designs/frac-n-pll-vco-unic_cass/schematic/top-pll/LC_VCO_PLL.sch
.subckt LC_VCO_PLL VDD CLK_IN CLK_OUT IbiasVCO OUTn Ibias GND
*.iopin GND
*.iopin VDD
*.ipin CLK_IN
*.ipin IbiasVCO
*.ipin Ibias
*.opin OUTn
*.opin CLK_OUT
x5 CLK_OUT net7 VDD GND sg13g2_inv_2
* noconn rst
* noconn sclk
* noconn sdata
* noconn en
x4 VDD UP VCTRL DN GND Ibias CP
x6 VDD UP CLK_IN DSM_OUT DN GND PFD
x1 VDD net7 OUTn IbiasVCO VCTRL GND LC_VCO
adut [ net1 net2 net3 net4 net5 ] [ net6 ] null dut
.model dut d_cosim simulation=./../dsm_and_freq_divider.so
A1 [ CLK_OUT ] [ net1 ] adc1
.model adc1 adc_bridge in_low=0.4 in_high=0.6
A2 [ rst ] [ net2 ] adc1
.model adc1 adc_bridge in_low=0.4 in_high=0.6
A3 [ sclk ] [ net3 ] adc1
.model adc1 adc_bridge in_low=0.4 in_high=0.6
A4 [ sdata ] [ net4 ] adc1
.model adc1 adc_bridge in_low=0.4 in_high=0.6
A5 [ en ] [ net5 ] adc1
.model adc1 adc_bridge in_low=0.4 in_high=0.6
A6 [ net6 ] [ DSM_OUT ] dac1
.model dac1 dac_bridge out_low=0 out_high=1.2
.ends

* expanding   symbol:  /foss/designs/frac-n-pll-vco-unic_cass/schematic/charge-pump/CP.sym # of pins=6
** sym_path: /foss/designs/frac-n-pll-vco-unic_cass/schematic/charge-pump/CP.sym
** sch_path: /foss/designs/frac-n-pll-vco-unic_cass/schematic/charge-pump/CP.sch
.subckt CP VDD UP CTRL DN GND Ibias
*.opin CTRL
*.ipin UP
*.ipin VDD
*.ipin Ibias
*.ipin DN
*.ipin GND
XM2 Vbn Vbn net2 GND sg13_lv_nmos w=3u l=2u ng=1
XM8 net5 GND VDD VDD sg13_lv_pmos w=10u l=2u ng=1
XR3 CTRL CTRL1 sub! rsil w=0.5e-6 l=1000e-6 m=1 b=0
XR2 CTRL2 CTRL1 sub! rsil w=0.5e-6 l=2500e-6 m=1 b=0
XC4 CTRL GND cap_cmim w=60.0e-6 l=60.0e-6
XC1 CTRL2 GND cap_cmim w=40.0e-6 l=40.0e-6 m=4
XC2 CTRL1 GND cap_cmim w=15.0e-6 l=20.0e-6 m=4
XM11 Ibias Ibias net5 VDD sg13_lv_pmos w=10u l=2u ng=1
XM3 Vbn Ibias net1 VDD sg13_lv_pmos w=10u l=2u ng=1
XM4 net1 GND VDD VDD sg13_lv_pmos w=10u l=2u ng=1
XM7 net4 UP VDD VDD sg13_lv_pmos w=10u l=2u ng=1
XM9 CTRL1 Ibias net4 VDD sg13_lv_pmos w=10u l=2u ng=1
XM10 net2 VDD GND GND sg13_lv_nmos w=3u l=2u ng=1
XM1 net3 DN GND GND sg13_lv_nmos w=3u l=2u ng=1
XM5 CTRL1 Vbn net3 GND sg13_lv_nmos w=3u l=2u ng=1
.ends

* expanding   symbol:  /foss/designs/frac-n-pll-vco-unic_cass/schematic/phase-freq-detector/PFD.sym # of pins=6
** sym_path: /foss/designs/frac-n-pll-vco-unic_cass/schematic/phase-freq-detector/PFD.sym
** sch_path: /foss/designs/frac-n-pll-vco-unic_cass/schematic/phase-freq-detector/PFD.sch
.subckt PFD VDD UP F_REF F_VCO DN GND
*.opin UP
*.ipin F_REF
*.ipin VDD
*.ipin GND
*.opin DN
*.ipin F_VCO
x1 net1 net2 F_REF VDD RST_N VDD GND sg13g2_dfrbp_2
x2 DN net3 F_VCO VDD RST_N VDD GND sg13g2_dfrbp_2
x3 RST_N net1 DN VDD GND sg13g2_nand2_2
x4 UP net1 VDD GND sg13g2_inv_2
.ends

* expanding   symbol:  /foss/designs/frac-n-pll-vco-unic_cass/schematic/lc-vco/LC_VCO.sym # of pins=6
** sym_path: /foss/designs/frac-n-pll-vco-unic_cass/schematic/lc-vco/LC_VCO.sym
** sch_path: /foss/designs/frac-n-pll-vco-unic_cass/schematic/lc-vco/LC_VCO.sch
.subckt LC_VCO VDD OUTp OUTn Ibias VCTRL GND
*.iopin VDD
*.opin OUTp
*.opin OUTn
*.iopin GND
*.iopin VCTRL
*.iopin Ibias
XM6 net1 Ibias GND GND sg13_lv_nmos w=1u l=0.15u ng=1 m=60
XM5 Ibias Ibias GND GND sg13_lv_nmos w=1u l=0.15u ng=1
XM4 OUTp OUTn VDD VDD sg13_lv_pmos w=8.5u l=0.5u ng=1 m=13
X5M3 OUTn OUTp VDD VDD sg13_lv_pmos w=8.5u l=0.5u ng=1 m=13
XM2 OUTp OUTn net1 GND sg13_lv_nmos w=2u l=0.5u ng=1 m=12
XM1 OUTn OUTp net1 GND sg13_lv_nmos w=2u l=0.5u ng=1 m=12
XC3 OUTp OUTn cap_cmim w=4.26e-6 l=4.26e-6 m=12
XMv2 OUTp VCTRL OUTp VDD sg13_lv_pmos w=4u l=4u ng=1 m=22
XMv1 OUTn VCTRL OUTn VDD sg13_lv_pmos w=4u l=4u ng=1 m=22
XR1 OUTp OUTn sub! rhigh w=1e-6 l=0.79e-6 m=1 b=0
*  x1 -  ihp_4nh_inductor  IS MISSING !!!!
.ends

.GLOBAL GND
.GLOBAL VDD
.end
