** sch_path: /foss/designs/frac-n-pll-vco-unic_cass/schematic/charge-pump/CP.sch
**.subckt CP VDD UP CTRL DN GND Ibias
*.opin CTRL
*.ipin UP
*.ipin VDD
*.ipin Ibias
*.ipin DN
*.ipin GND
*.ipin VBGR
XM2 Vbn Vbn net2 GND sg13_lv_nmos w=3u l=2u ng=1
XM8 net5 GND VDD VDD sg13_lv_pmos w=10u l=2u ng=1
XR2 CTRL CTRL1 sub! rsil w=0.5e-6 l=3848e-6 m=1 b=0
XR1 CTRL2 CTRL1 sub! rsil w=0.5e-6 l=3848e-6 m=1 b=0
XC3 CTRL GND cap_cmim w=41.7e-6 l=41.7e-6 m=8
XC2 CTRL2 GND cap_cmim w=55.85e-6 l=55.85e-6 m=12
XM11 Ibias Ibias net5 VDD sg13_lv_pmos w=10u l=2u ng=1
XM3 Vbn Ibias net1 VDD sg13_lv_pmos w=10u l=2u ng=1
XM4 net1 GND VDD VDD sg13_lv_pmos w=10u l=2u ng=1
XM7 net4 UP VDD VDD sg13_lv_pmos w=10u l=2u ng=1
XM9 CTRL1 Ibias net4 VDD sg13_lv_pmos w=10u l=2u ng=1
XM10 net2 VDD GND GND sg13_lv_nmos w=3u l=2u ng=1
XM1 net3 DN GND GND sg13_lv_nmos w=3u l=2u ng=1
XM5 CTRL1 Vbn net3 GND sg13_lv_nmos w=3u l=2u ng=1
XM6 Ibias Vgs GND GND sg13_lv_nmos w=70.29u l=0.5u ng=20
XM12 Vgs Vgs GND GND sg13_lv_nmos w=17.95u l=0.5u ng=6
XM13 Vgs VBGR VDD VDD sg13_lv_pmos w=16.72u l=0.5u ng=6
**.ends
.GLOBAL GND
.GLOBAL VDD
.end
