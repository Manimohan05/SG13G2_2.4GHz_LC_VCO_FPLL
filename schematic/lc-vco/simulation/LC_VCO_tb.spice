** sch_path: /home/designer/shared/frac-n-pll-vco-smacd_2026/schematic/lc-vco/LC_VCO_tb.sch
**.subckt LC_VCO_tb
V1 VDD GND 1.2
I0 VDD Ibias 80u
x2 VDD OUTp OUTn Ibias VCTRL GND LC_VCO
Vdn VCTRL GND PULSE(0.5 0.4 10n 1n 90n 1s 2s)
**** begin user architecture code

.include ../ihp_4nh_inductor.spice
.param temp = 27
.options method=gear, rshunt=1.0e12

.control

* Save required signals
save v(OUTp) v(VCTRL)

* Long transient simulation
tran 10p 10.1u 100n

* Save raw waveform
write LC_VCO_tb.raw

* Plot transient waveform
let vout = v(OUTp)
plot vout v(Vctrl)

* Plot steady-state waveform
plot vout xlimit 200n 205n

* FFT analysis
setplot tran1
linearize vout
set specwindow=blackman
fft vout

* Plot FFT spectrum
let vout_db = db(vout)
plot vout_db xlimit 2.30G 2.50G ylimit -160 0

* Find the maximum magnitude value between 2G and 3G
meas sp max_vout_db max vout_db FROM=2G TO=3G

* Save FFT data
wrdata fft_output.txt frequency vout_db

* Save waveform for external processing
wrdata vco_waveform.txt vout_db

.endc

.lib cornerMOSlv.lib mos_tt
.lib cornerMOShv.lib mos_tt
.lib cornerRES.lib res_typ
.lib cornerCAP.lib cap_typ

**** end user architecture code
**.ends

* expanding   symbol:  /home/designer/shared/frac-n-pll-vco-smacd_2026/schematic/lc-vco/LC_VCO.sym # of pins=6
** sym_path: /home/designer/shared/frac-n-pll-vco-smacd_2026/schematic/lc-vco/LC_VCO.sym
** sch_path: /home/designer/shared/frac-n-pll-vco-smacd_2026/schematic/lc-vco/LC_VCO.sch
.subckt LC_VCO VDD OUTp OUTn Ibias VCTRL GND
*.opin OUTp
*.opin OUTn
*.iopin VCTRL
*.iopin Ibias
*.iopin GND
*.iopin VDD
XM6 net5 Vgs GND GND sg13_lv_nmos w=70.29u l=0.5u ng=20 m=1
XM4 net1 net4 VDD VDD sg13_lv_pmos w=34.52u l=0.13u ng=10 m=1
X5M3 net4 net1 VDD VDD sg13_lv_pmos w=34.52u l=0.13u ng=10 m=1
XM2 OUTp OUTn Vx GND sg13_lv_nmos w=25.11u l=0.13u ng=8 m=1
XM1 OUTn OUTp Vx GND sg13_lv_nmos w=25.11u l=0.13u ng=8 m=1
Vpmos_p net1 net3 0
.save i(vpmos_p)
Vnmos_p net3 OUTp 0
.save i(vnmos_p)
Vtail Vx net5 0
.save i(vtail)
XM5 Vgs Vgs GND GND sg13_lv_nmos w=17.95u l=0.5u ng=6 m=1
Vpmos_n net4 net2 0
.save i(vpmos_n)
Vnmos_n net2 OUTn 0
.save i(vnmos_n)
x1 net2 net3 ihp_4nh_inductor
XC1 net2 net3 GND cap_rfcmim w=22.15e-6 l=22.15e-6 wfeed=10.0e-6
XC3 OUTp VCTRL OUTn GND sg13_hv_svaricap w=9.74u l=0.8u Nx=7
XC2 OUTp VCTRL OUTn GND sg13_hv_svaricap w=9.74u l=0.8u Nx=7
Vbias Ibias Vgs 0
.save i(vbias)
.ends

.GLOBAL GND
.GLOBAL VDD
.GLOBAL Ibias
.GLOBAL VCTRL
.end
