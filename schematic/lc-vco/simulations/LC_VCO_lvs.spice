.SUBCKT LC_VCO VDD OUTp OUTn Ibias VCTRL GND
M6 net1 Ibias GND GND sg13_lv_nmos w=1u l=0.15u m=60
M5 Ibias Ibias GND GND sg13_lv_nmos w=1u l=0.15u m=1
M4 OUTp OUTn VDD VDD sg13_lv_pmos w=8.5u l=0.5u m=13
M3 OUTn OUTp VDD VDD sg13_lv_pmos w=8.5u l=0.5u m=13
M2 OUTp OUTn net1 GND sg13_lv_nmos w=2u l=0.5u m=12
M1 OUTn OUTp net1 GND sg13_lv_nmos w=2u l=0.5u m=12
C3 OUTp OUTn cap_cmim w=4.26e-6 l=4.26e-6 m=12
Mv2 OUTp VCTRL OUTp VDD sg13_lv_pmos w=4u l=4u m=22
Mv1 OUTn VCTRL OUTn VDD sg13_lv_pmos w=4u l=4u m=22
R1 OUTn OUTp rhigh w=1e-6 l=0.79e-6 m=1
.ENDS
.GLOBAL VDD
.GLOBAL GND
