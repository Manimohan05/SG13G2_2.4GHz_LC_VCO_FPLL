** sch_path: /foss/designs/frac-n-pll-vco-unic_cass/schematic/lc-vco/LC_VCO_tb.sch
**.subckt LC_VCO_tb
V1 VDD GND 1.2
V2 VCTRL GND 0.6
I0 VDD Ibias 50u
x2 VDD OUTp OUTn Ibias VCTRL GND LC_VCO
**** begin user architecture code

.include ./IHP_4nH_Inductor.spice
.param temp = 27

.control

* Initial condition
.ic v(OUTp)=0.6

* Simulation accuracy
.options reltol=1e-4 abstol=1e-9 maxstep=5p method=gear

* Save required signals
save time v(OUTp) v(CTRL)

* Long transient for ~10 kHz FFT resolution
tran 0.01n 0.5u UIC

* Save raw waveform
write LC_VCO_tb.raw

* Plot steady-state waveform
plot v(OUTp) xlimit 5n 60n

* FFT analysis
linearize v(OUTp)
fft v(OUTp)

let vmag = db(mag(v(OUTp)))

* Plot FFT spectrum
plot vmag vs frequency xlimit 0 5G

* Save FFT data
wrdata fft_output.txt frequency vmag

* Save waveform for external processing
wrdata vco_waveform.txt time v(OUTp)

.endc

 .lib cornerMOSlv.lib mos_tt
.lib cornerRES.lib res_typ
.lib /foss/pdks/ihp-sg13g2/libs.tech/ngspice/models/cornerCAP.lib cap_typ_stat

**** end user architecture code
**.ends

* expanding   symbol:  LC_VCO.sym # of pins=6
** sym_path: /foss/designs/frac-n-pll-vco-unic_cass/schematic/lc-vco/LC_VCO.sym
** sch_path: /foss/designs/frac-n-pll-vco-unic_cass/schematic/lc-vco/LC_VCO.sch
.subckt LC_VCO VDD OUTp OUTn Ibias VCTRL GND
*.iopin VDD
*.opin OUTp
*.opin OUTn
*.iopin GND
*.iopin VCTRL
*.iopin Ibias
XM6 net1 Ibias GND GND sg13_lv_nmos w=1u l=0.15u ng=1 m=60
XM5 Ibias Ibias GND GND sg13_lv_nmos w=1u l=0.15u ng=1
XM4 OUTp OUTn VDD VDD sg13_lv_pmos w=8.5u l=0.5u ng=1 m=13
X5M3 OUTn OUTp VDD VDD sg13_lv_pmos w=8.5u l=0.5u ng=1 m=13
XM2 OUTp OUTn net1 GND sg13_lv_nmos w=2u l=0.5u ng=1 m=12
XM1 OUTn OUTp net1 GND sg13_lv_nmos w=2u l=0.5u ng=1 m=12
XC3 OUTp OUTn cap_cmim w=4.26e-6 l=4.26e-6 m=12
XMv2 OUTp VCTRL OUTp VDD sg13_lv_pmos w=4u l=4u ng=1 m=22
XMv1 OUTn VCTRL OUTn VDD sg13_lv_pmos w=4u l=4u ng=1 m=22
XR1 OUTp OUTn sub! rhigh w=1e-6 l=0.79e-6 m=1 b=0
x1 OUTn OUTp ihp_4nh_inductor
.ends

.GLOBAL GND
.GLOBAL VDD
.GLOBAL VCTRL
.GLOBAL Ibias
.end
