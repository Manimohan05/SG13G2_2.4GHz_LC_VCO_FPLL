** sch_path: /foss/designs/iic_osic_tools/frac-n-pll-vco-unic_cass/schematic/blocks/lc-vco/LC_VCO_pex_tb.sch
**.subckt LC_VCO_pex_tb
V1 VDD GND 1.2
V2 VCTRL GND 0.6
I0 VDD Ibias 50u
x1 Ibias OUTp OUTn VCTRL GND VDD LC_VCO
**** begin user architecture code

.include ../simulations/LC_VCO.pex.spice
.include ./IHP_4nH_Inductor.spice
xind OUTp OUTn IHP_4nH_Inductor

.param temp = 27

.control

* Initial condition
.ic v(OUTp)=0.6

* Simulation accuracy
.options reltol=1e-4 abstol=1e-9 maxstep=5p method=gear

* Save required signals
save time v(OUTp) v(CTRL)

* Long transient for ~10 kHz FFT resolution
tran 0.01n 0.5u UIC

* Save raw waveform
write LC_VCO_tb.raw

* Plot steady-state waveform
plot v(OUTp) xlimit 5n 60n

* FFT analysis
linearize v(OUTp)
fft v(OUTp)

let vmag = db(mag(v(OUTp)))

* Plot FFT spectrum
plot vmag vs frequency xlimit 0 5G

* Save FFT data
wrdata fft_output.txt frequency vmag

* Save waveform for external processing
wrdata vco_waveform.txt time v(OUTp)

.endc

 .lib cornerMOSlv.lib mos_tt
.lib cornerRES.lib res_typ
.lib /foss/pdks/ihp-sg13g2/libs.tech/ngspice/models/cornerCAP.lib cap_typ_stat

**** end user architecture code
**.ends
.GLOBAL GND
.GLOBAL VDD
.GLOBAL VCTRL
.GLOBAL Ibias
.end
