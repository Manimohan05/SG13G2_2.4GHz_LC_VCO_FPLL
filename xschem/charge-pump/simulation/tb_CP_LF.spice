** sch_path: /foss/designs/uniccass-icdesign-tools/shared_xserver/frac-n-pll-vco-smacd_2026/schematic/charge-pump/tb_CP_LF.sch
**.subckt tb_CP_LF
V1 VDD GND 1.2
V2 DN GND PULSE(0 1.2 3.1u 1n 1n 49n 100n 29)
V3 UP GND PULSE(1.2 0 20n 1n 1n 49n 100n 29)
VBGR net1 GND 0.6
x1 UP VDD VCP net1 GND DN CHARGE_PUMP
x2 CTRL VCP GND LOOP_FILTER
**** begin user architecture code

.include tb_CP.save
.param temp=27
.option method=gear rshunt=1.0e12
.control
save all
op
write tb_CP_LF.raw
.endc

.lib cornerMOSlv.lib mos_tt
.lib cornerMOShv.lib mos_tt
.lib cornerRES.lib res_typ
.lib cornerCAP.lib cap_typ

.param temp = 27
.options method=gear rshunt=1.0e12

.control

* Save required signals
save v(UP) v(DN) v(VCP) v(CTRL)

* Long transient simulation
tran 1n 6u

* Plot transient waveform
plot v(UP) v(DN) v(VCP) v(CTRL)
plot v(CTRL)

.endc

**** end user architecture code
**.ends

* expanding   symbol:
*+  /foss/designs/uniccass-icdesign-tools/shared_xserver/frac-n-pll-vco-smacd_2026/schematic/charge-pump/CHARGE_PUMP.sym # of pins=6
** sym_path: /foss/designs/uniccass-icdesign-tools/shared_xserver/frac-n-pll-vco-smacd_2026/schematic/charge-pump/CHARGE_PUMP.sym
** sch_path: /foss/designs/uniccass-icdesign-tools/shared_xserver/frac-n-pll-vco-smacd_2026/schematic/charge-pump/CHARGE_PUMP.sch
.subckt CHARGE_PUMP UP VDD VCP VBGR GND DN
*.opin VCP
*.ipin UP
*.ipin DN
*.iopin GND
*.iopin VBGR
*.iopin VDD
XM2 Vbn Vbn net5 GND sg13_lv_nmos w=40.7u l=2u ng=5
XM8 net2 GND VDD VDD sg13_lv_pmos w=29.6u l=2u ng=5
XM11 Vbp Vbp net2 VDD sg13_lv_pmos w=163.6u l=2u ng=20
XM3 Vbn Vbp net1 VDD sg13_lv_pmos w=163.6u l=2u ng=20
XM4 net1 GND VDD VDD sg13_lv_pmos w=29.6u l=2u ng=5
XM7 net3 UP VDD VDD sg13_lv_pmos w=29.6u l=2u ng=5
XM9 VCP Vbp net3 VDD sg13_lv_pmos w=163.6u l=2u ng=20
XM10 net5 VDD GND GND sg13_lv_nmos w=6u l=2u ng=1
XM1 net4 DN GND GND sg13_lv_nmos w=6u l=2u ng=1
XM5 VCP Vbn net4 GND sg13_lv_nmos w=40.7u l=2u ng=5
XM6 Vbp VBGR GND GND sg13_lv_nmos w=3.9u l=2u ng=1
.ends

* expanding   symbol:
*+  /foss/designs/uniccass-icdesign-tools/shared_xserver/frac-n-pll-vco-smacd_2026/schematic/loop-filter/LOOP_FILTER.sym # of pins=3
** sym_path: /foss/designs/uniccass-icdesign-tools/shared_xserver/frac-n-pll-vco-smacd_2026/schematic/loop-filter/LOOP_FILTER.sym
** sch_path: /foss/designs/uniccass-icdesign-tools/shared_xserver/frac-n-pll-vco-smacd_2026/schematic/loop-filter/LOOP_FILTER.sch
.subckt LOOP_FILTER OUT IN GND
*.opin OUT
*.iopin GND
*.ipin IN
XC2 OUT GND cap_cmim w=18.63e-6 l=18.63e-6 m=4
XC1 net1 GND cap_cmim w=48.34e-6 l=48.34e-6 m=16
XR2 OUT IN sub! rppd w=2e-6 l=407.22e-6 m=1 b=0
XR1 net1 IN sub! rppd w=2e-6 l=407.22e-6 m=1 b=0
.ends

.GLOBAL VDD
.GLOBAL GND
.end
