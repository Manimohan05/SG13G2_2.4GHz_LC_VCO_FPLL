** sch_path: /foss/designs/frac-n-pll-vco-unic_cass/schematic/Test/PFD_CP_pex_tb.sch
**.subckt PFD_CP_pex_tb
Vdd VDD GND 'VDD'
Vfvco F_VCO GND 0 pulse(0 'VDD' 6n 1n 1n 5n 10n)
Vfref F_REF GND 0 pulse(0 'VDD' 0n 1n 1n 5n 10n)
I0 Ibias GND 1u
x1 VDD UP F_REF F_VCO DN GND PFD
x2 VDD UP CTRL DN GND Ibias CP
**** begin user architecture code

.lib cornerMOSlv.lib mos_tt
.lib cornerMOShv.lib mos_tt
.lib cornerHBT.lib hbt_typ
.lib cornerRES.lib res_typ
.include /foss/pdks/ihp-sg13g2/libs.ref/sg13g2_stdcell/spice/sg13g2_stdcell.spice
.global VDD GND

.param CP_N_L = 2u
.param CP_N_W = 3u
.param CP_P_M = 1
.param CP_P_L = 2u
.param CP_P_W = 10u
.param CP_N_M = 1
.param C_CP = 10p

.param RAW_TEMP = agauss(40, 30, 1)
.param TEMPGAUSS = max(20, min(RAW_TEMP, 80))
.option temp = 'TEMPGAUSS'
.param VDDGAUSS = agauss(1.2, 0.05, 1)
.include ../simulations/PFD_std.pex.spice
.include ../simulations/CP_lvs.pex.spice
.param VDD = 'VDDGAUSS'
* analysis

.control
save all
*op
remzerovec
write tb_CP.raw
*set appendwrite
let i = 0
dowhile i < 1

  tran 100p 1u uic
  write PFD_CP_tb.raw
  let i = i + 1
end
quit 0
.endc

.lib /foss/pdks/ihp-sg13g2/libs.tech/ngspice/models/cornerCAP.lib cap_typ

**** end user architecture code
**.ends

* expanding   symbol:  /foss/designs/frac-n-pll-vco-unic_cass/schematic/phase-freq-detector/PFD.sym # of pins=6
** sym_path: /foss/designs/frac-n-pll-vco-unic_cass/schematic/phase-freq-detector/PFD.sym
** sch_path: /foss/designs/frac-n-pll-vco-unic_cass/schematic/phase-freq-detector/PFD.sch
.subckt PFD VDD UP F_REF F_VCO DN GND
*.opin UP
*.ipin F_REF
*.ipin VDD
*.ipin GND
*.opin DN
*.ipin F_VCO
x1 net1 net2 F_REF VDD RST_N VDD GND sg13g2_dfrbp_2
x2 DN net3 F_VCO VDD RST_N VDD GND sg13g2_dfrbp_2
x3 RST_N net1 DN VDD GND sg13g2_nand2_2
x4 UP net1 VDD GND sg13g2_inv_2
.ends

* expanding   symbol:  /foss/designs/frac-n-pll-vco-unic_cass/schematic/charge-pump/CP.sym # of pins=6
** sym_path: /foss/designs/frac-n-pll-vco-unic_cass/schematic/charge-pump/CP.sym
** sch_path: /foss/designs/frac-n-pll-vco-unic_cass/schematic/charge-pump/CP.sch
.subckt CP VDD UP CTRL DN GND Ibias
*.opin CTRL
*.ipin UP
*.ipin VDD
*.ipin Ibias
*.ipin DN
*.ipin GND
XM2 Vbn Vbn net2 GND sg13_lv_nmos w=3u l=2u ng=1
XM8 net5 GND VDD VDD sg13_lv_pmos w=10u l=2u ng=1
XR3 CTRL CTRL1 sub! rsil w=0.5e-6 l=1000e-6 m=1 b=0
XR2 CTRL2 CTRL1 sub! rsil w=0.5e-6 l=2500e-6 m=1 b=0
XC4 CTRL GND cap_cmim w=60.0e-6 l=60.0e-6
XC1 CTRL2 GND cap_cmim w=40.0e-6 l=40.0e-6 m=4
XC2 CTRL1 GND cap_cmim w=15.0e-6 l=20.0e-6 m=4
XM11 Ibias Ibias net5 VDD sg13_lv_pmos w=10u l=2u ng=1
XM3 Vbn Ibias net1 VDD sg13_lv_pmos w=10u l=2u ng=1
XM4 net1 GND VDD VDD sg13_lv_pmos w=10u l=2u ng=1
XM7 net4 UP VDD VDD sg13_lv_pmos w=10u l=2u ng=1
XM9 CTRL1 Ibias net4 VDD sg13_lv_pmos w=10u l=2u ng=1
XM10 net2 VDD GND GND sg13_lv_nmos w=3u l=2u ng=1
XM1 net3 DN GND GND sg13_lv_nmos w=3u l=2u ng=1
XM5 CTRL1 Vbn net3 GND sg13_lv_nmos w=3u l=2u ng=1
.ends

.GLOBAL GND
.GLOBAL VDD
.end
