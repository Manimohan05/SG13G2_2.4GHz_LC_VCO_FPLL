** sch_path: /home/designer/shared/frac-n-pll-vco-smacd_2026/schematic/lc-vco/LC_VCO_standalone_tb.sch
**.subckt LC_VCO_standalone_tb OUT VCTRL VDD GND
*.opin OUT
*.ipin VCTRL
*.iopin VDD
*.iopin GND
XM5 Vx Vgs GND GND sg13_lv_nmos w=384u l=1u ng=48 m=1
XM4 net1 net5 VDD VDD sg13_lv_pmos w=36u l=0.13u ng=5 m=1
XM3 net5 net1 VDD VDD sg13_lv_pmos w=36u l=0.13u ng=5 m=1
XM2 OUTp OUTn net4 GND sg13_lv_nmos w=22u l=0.13u ng=3 m=1
XM1 OUTn OUTp net4 GND sg13_lv_nmos w=22u l=0.13u ng=3 m=1
Vpmos_p net1 net3 0
.save i(vpmos_p)
Vnmos_p net3 OUTp 0
.save i(vnmos_p)
Vtail net4 Vx 0
.save i(vtail)
XM6 Vgs Vgs GND GND sg13_lv_nmos w=64u l=1u ng=8 m=1
Vpmos_n net5 net2 0
.save i(vpmos_n)
Vnmos_n net2 OUTn 0
.save i(vnmos_n)
x1 net2 net3 ihp_4nh_inductor
XC1 net2 net3 GND cap_rfcmim w=21.9e-6 l=21.9e-6 wfeed=10.0e-6
XC3 OUTp VCTRL OUTn GND sg13_hv_svaricap w=9.74u l=0.8u Nx=7
XC2 OUTp VCTRL OUTn GND sg13_hv_svaricap w=9.74u l=0.8u Nx=7
XM7 Vgs VBGR VDD VDD sg13_lv_pmos w=38u l=1u ng=5 m=1
XM8 OUT net3 VDD VDD sg13_lv_pmos w=15u l=0.13u ng=10 m=1
XM9 OUT net3 GND GND sg13_lv_nmos w=1.5u l=0.13u ng=1 m=1
XM10 net6 net2 VDD VDD sg13_lv_pmos w=15u l=0.13u ng=10 m=1
XM11 net6 net2 GND GND sg13_lv_nmos w=1.5u l=0.13u ng=1 m=1
V1 VDD GND 1.2
Vup VCTRL GND PULSE(0.4 0.8 10n 90n 1n 1s 2s)
VBGR VBGR GND 0.6
**** begin user architecture code

.param temp=27
.control
save all
op
write LC_VCO_standalone_tb.raw
.endc

.lib cornerMOSlv.lib mos_tt
.lib cornerMOShv.lib mos_tt
.lib cornerRES.lib res_typ
.lib cornerCAP.lib cap_typ

.include ../ihp_4nh_inductor.spice

.param temp = 27
.options method=gear
.options savecurrents
.options noacct

.control

* Save required signals
save v(OUTp) v(Vx) v(OUT)

* Long transient simulation
tran 10p 500n 100n

* Find average power dissipation
let tot_power = abs(v(vdd)*i(v1))
meas tran avg_power AVG tot_power FROM=400n TO=450n

* Plot steady-state waveform
let vout = v(OUT)
meas tran vout_pp PP vout FROM=400n TO=450n
plot v(OUTp) v(OUT) xlimit 400n 405n

* FFT analysis
setplot tran1
linearize vout
set specwindow=blackman
fft vout

* Plot FFT spectrum
let power_db = db(vout)
plot power_db xlimit 2.34G 2.54G ylimit -200 0

* Find the maximum magnitude value between 2G and 3G
meas sp max_power_db max power_db FROM=2G TO=3G

.endc

.param temp = 27
.options method=gear
.options savecurrents
.options noacct

.control

* Save required signals
save v(OUTp) v(Vx)

* Long transient simulation
tran 10p 50n

* Plot transient waveform
plot v(OUTp) v(Vctrl) v(Vx) v(OUT)

* Find average power dissipation
let tot_power = abs(v(vdd)*i(v1))
plot tot_power xlimit 20n 35n

.endc

**** end user architecture code
**.ends
.GLOBAL GND
.GLOBAL VDD
.end
