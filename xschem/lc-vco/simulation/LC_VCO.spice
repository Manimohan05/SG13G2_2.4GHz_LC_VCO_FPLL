** sch_path: /home/designer/shared/frac-n-pll-vco-smacd_2026/schematic/lc-vco/LC_VCO.sch
**.subckt LC_VCO VDD VCTRL GND OUT VBGR
*.opin OUT
*.ipin VCTRL
*.ipin VBGR
*.iopin VDD
*.iopin GND
XM5 Vx Vgs GND GND sg13_lv_nmos w=384u l=1u ng=48 m=1
XM4 net1 net5 VDD VDD sg13_lv_pmos w=36u l=0.13u ng=5 m=1
XM3 net5 net1 VDD VDD sg13_lv_pmos w=36u l=0.13u ng=5 m=1
XM2 OUTp OUTn net4 GND sg13_lv_nmos w=22u l=0.13u ng=3 m=1
XM1 OUTn OUTp net4 GND sg13_lv_nmos w=22u l=0.13u ng=3 m=1
Vpmos_p net1 net3 0
.save i(vpmos_p)
Vnmos_p net3 OUTp 0
.save i(vnmos_p)
Vtail net4 Vx 0
.save i(vtail)
XM6 Vgs Vgs GND GND sg13_lv_nmos w=64u l=1u ng=8 m=1
Vpmos_n net5 net2 0
.save i(vpmos_n)
Vnmos_n net2 OUTn 0
.save i(vnmos_n)
x1 net2 net3 ihp_4nh_inductor
XC1 net2 net3 GND cap_rfcmim w=21.8e-6 l=21.8e-6 wfeed=10.0e-6
XC3 OUTp VCTRL OUTn GND sg13_hv_svaricap w=9.74u l=0.8u Nx=7
XC2 OUTp VCTRL OUTn GND sg13_hv_svaricap w=9.74u l=0.8u Nx=7
XM7 Vgs VBGR VDD VDD sg13_lv_pmos w=38u l=1u ng=5 m=1
XM8 OUT net3 VDD VDD sg13_lv_pmos w=15u l=0.13u ng=10 m=1
XM9 OUT net3 GND GND sg13_lv_nmos w=1.5u l=0.13u ng=1 m=1
XM10 net6 net2 VDD VDD sg13_lv_pmos w=15u l=0.13u ng=10 m=1
XM11 net6 net2 GND GND sg13_lv_nmos w=1.5u l=0.13u ng=1 m=1
**.ends
.GLOBAL GND
.GLOBAL VDD
.end
