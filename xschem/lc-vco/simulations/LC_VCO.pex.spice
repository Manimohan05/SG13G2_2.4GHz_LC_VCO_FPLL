* NGSPICE file created from LC_VCO.ext - technology: ihp-sg13g2

.subckt LC_VCO IBIAS OUTp OUTn VCTRL GND VDD
X0 OUTn OUTp a_n11430_n13770# GND sg13_lv_nmos ad=0.38p pd=2.38u as=0.68p ps=4.68u w=2u l=0.5u
X1 OUTp OUTn cap_cmim l=4.26u w=4.26u
X2 OUTp OUTn sub! rhigh l=0.79u w=1u
X3 a_n11430_n13770# IBIAS GND GND sg13_lv_nmos ad=0.19p pd=1.38u as=0.19p ps=1.38u w=1u l=0.15u
X4 OUTn VCTRL OUTn VDD sg13_lv_pmos ad=0.76p pd=4.38u as=87.38535p ps=0.73027m w=4u l=4u
X5 VDD OUTn OUTp VDD sg13_lv_pmos ad=1.615p pd=8.88u as=1.615p ps=8.88u w=8.5u l=0.5u
X6 GND IBIAS a_n11430_n13770# GND sg13_lv_nmos ad=0.19p pd=1.38u as=0.19p ps=1.38u w=1u l=0.15u
X7 OUTn VCTRL OUTn VDD sg13_lv_pmos ad=0.76p pd=4.38u as=0 ps=0 w=4u l=4u
X8 OUTn OUTp a_n11430_n13770# GND sg13_lv_nmos ad=0.38p pd=2.38u as=0.38p ps=2.38u w=2u l=0.5u
X9 a_n11430_n13770# IBIAS GND GND sg13_lv_nmos ad=0.19p pd=1.38u as=0.19p ps=1.38u w=1u l=0.15u
X10 a_n11430_n13770# IBIAS GND GND sg13_lv_nmos ad=0.19p pd=1.38u as=0.19p ps=1.38u w=1u l=0.15u
X11 OUTp OUTn a_n11430_n13770# GND sg13_lv_nmos ad=0.38p pd=2.38u as=0.38p ps=2.38u w=2u l=0.5u
X12 GND IBIAS a_n11430_n13770# GND sg13_lv_nmos ad=0.19p pd=1.38u as=0.19p ps=1.38u w=1u l=0.15u
X13 OUTp VCTRL OUTp VDD sg13_lv_pmos ad=0.76p pd=4.38u as=87.38047p ps=0.73022m w=4u l=4u
X14 OUTp VCTRL OUTp VDD sg13_lv_pmos ad=0.76p pd=4.38u as=0 ps=0 w=4u l=4u
X15 GND IBIAS a_n11430_n13770# GND sg13_lv_nmos ad=0.19p pd=1.38u as=0.19p ps=1.38u w=1u l=0.15u
X16 OUTp OUTn VDD VDD sg13_lv_pmos ad=2.89p pd=17.68u as=1.615p ps=8.88u w=8.5u l=0.5u
X17 a_n11430_n13770# IBIAS GND GND sg13_lv_nmos ad=0.19p pd=1.38u as=0.19p ps=1.38u w=1u l=0.15u
X18 OUTp OUTn cap_cmim l=4.26u w=4.26u
X19 OUTn VCTRL OUTn VDD sg13_lv_pmos ad=0.76p pd=4.38u as=0 ps=0 w=4u l=4u
X20 a_n11430_n13770# IBIAS GND GND sg13_lv_nmos ad=0.19p pd=1.38u as=0.19p ps=1.38u w=1u l=0.15u
X21 OUTp OUTn cap_cmim l=4.26u w=4.26u
X22 OUTp OUTn a_n11430_n13770# GND sg13_lv_nmos ad=0.38p pd=2.38u as=0.68p ps=4.68u w=2u l=0.5u
X23 a_n11430_n13770# IBIAS GND GND sg13_lv_nmos ad=0.19p pd=1.38u as=0.19p ps=1.38u w=1u l=0.15u
X24 OUTn VCTRL OUTn VDD sg13_lv_pmos ad=0.76p pd=4.38u as=0 ps=0 w=4u l=4u
X25 OUTn OUTp VDD VDD sg13_lv_pmos ad=1.615p pd=8.88u as=1.615p ps=8.88u w=8.5u l=0.5u
X26 OUTn OUTp VDD VDD sg13_lv_pmos ad=1.615p pd=8.88u as=1.615p ps=8.88u w=8.5u l=0.5u
X27 OUTn VCTRL OUTn VDD sg13_lv_pmos ad=0.76p pd=4.38u as=0 ps=0 w=4u l=4u
X28 GND IBIAS a_n11430_n13770# GND sg13_lv_nmos ad=0.19p pd=1.38u as=0.19p ps=1.38u w=1u l=0.15u
X29 OUTp OUTn a_n11430_n13770# GND sg13_lv_nmos ad=0.38p pd=2.38u as=0.38p ps=2.38u w=2u l=0.5u
X30 OUTp OUTn a_n11430_n13770# GND sg13_lv_nmos ad=0.38p pd=2.38u as=0.38p ps=2.38u w=2u l=0.5u
X31 OUTn VCTRL OUTn VDD sg13_lv_pmos ad=0.76p pd=4.38u as=0 ps=0 w=4u l=4u
X32 a_n11430_n13770# IBIAS GND GND sg13_lv_nmos ad=0.19p pd=1.38u as=0.19p ps=1.38u w=1u l=0.15u
X33 a_n11430_n13770# IBIAS GND GND sg13_lv_nmos ad=0.19p pd=1.38u as=0.34p ps=2.68u w=1u l=0.15u
X34 OUTn OUTp VDD VDD sg13_lv_pmos ad=1.615p pd=8.88u as=1.615p ps=8.88u w=8.5u l=0.5u
X35 OUTn VCTRL OUTn VDD sg13_lv_pmos ad=1.36p pd=8.68u as=0 ps=0 w=4u l=4u
X36 VDD OUTn OUTp VDD sg13_lv_pmos ad=1.615p pd=8.88u as=1.615p ps=8.88u w=8.5u l=0.5u
X37 VDD OUTn OUTp VDD sg13_lv_pmos ad=1.615p pd=8.88u as=1.615p ps=8.88u w=8.5u l=0.5u
X38 GND IBIAS a_n11430_n13770# GND sg13_lv_nmos ad=0.19p pd=1.38u as=0.19p ps=1.38u w=1u l=0.15u
X39 OUTp OUTn a_n11430_n13770# GND sg13_lv_nmos ad=0.38p pd=2.38u as=0.38p ps=2.38u w=2u l=0.5u
X40 OUTp OUTn cap_cmim l=4.26u w=4.26u
X41 OUTp OUTn cap_cmim l=4.26u w=4.26u
X42 a_n11430_n13770# IBIAS GND GND sg13_lv_nmos ad=0.19p pd=1.38u as=0.19p ps=1.38u w=1u l=0.15u
X43 GND IBIAS a_n11430_n13770# GND sg13_lv_nmos ad=0.19p pd=1.38u as=0.19p ps=1.38u w=1u l=0.15u
X44 OUTn VCTRL OUTn VDD sg13_lv_pmos ad=0.76p pd=4.38u as=0 ps=0 w=4u l=4u
X45 OUTn OUTp VDD VDD sg13_lv_pmos ad=1.615p pd=8.88u as=1.615p ps=8.88u w=8.5u l=0.5u
X46 a_n11430_n13770# OUTp OUTn GND sg13_lv_nmos ad=0.38p pd=2.38u as=0.38p ps=2.38u w=2u l=0.5u
X47 a_n11430_n13770# IBIAS GND GND sg13_lv_nmos ad=0.19p pd=1.38u as=0.19p ps=1.38u w=1u l=0.15u
X48 GND IBIAS a_n11430_n13770# GND sg13_lv_nmos ad=0.19p pd=1.38u as=0.19p ps=1.38u w=1u l=0.15u
X49 OUTn OUTp VDD VDD sg13_lv_pmos ad=1.615p pd=8.88u as=1.615p ps=8.88u w=8.5u l=0.5u
X50 GND IBIAS a_n11430_n13770# GND sg13_lv_nmos ad=0.19p pd=1.38u as=0.19p ps=1.38u w=1u l=0.15u
X51 a_n11430_n13770# IBIAS GND GND sg13_lv_nmos ad=0.19p pd=1.38u as=0.19p ps=1.38u w=1u l=0.15u
X52 a_n11430_n13770# IBIAS GND GND sg13_lv_nmos ad=0.19p pd=1.38u as=0.19p ps=1.38u w=1u l=0.15u
X53 GND IBIAS a_n11430_n13770# GND sg13_lv_nmos ad=0.19p pd=1.38u as=0.19p ps=1.38u w=1u l=0.15u
X54 OUTp VCTRL OUTp VDD sg13_lv_pmos ad=0.76p pd=4.38u as=0 ps=0 w=4u l=4u
X55 GND IBIAS a_n11430_n13770# GND sg13_lv_nmos ad=0.19p pd=1.38u as=0.19p ps=1.38u w=1u l=0.15u
X56 OUTp VCTRL OUTp VDD sg13_lv_pmos ad=0.76p pd=4.38u as=0 ps=0 w=4u l=4u
X57 OUTn OUTp a_n11430_n13770# GND sg13_lv_nmos ad=0.38p pd=2.38u as=0.38p ps=2.38u w=2u l=0.5u
X58 OUTn VCTRL OUTn VDD sg13_lv_pmos ad=0.76p pd=4.38u as=0 ps=0 w=4u l=4u
X59 OUTn OUTp a_n11430_n13770# GND sg13_lv_nmos ad=0.38p pd=2.38u as=0.38p ps=2.38u w=2u l=0.5u
X60 OUTp OUTn a_n11430_n13770# GND sg13_lv_nmos ad=0.38p pd=2.38u as=0.38p ps=2.38u w=2u l=0.5u
X61 OUTp OUTn cap_cmim l=4.26u w=4.26u
X62 OUTp VCTRL OUTp VDD sg13_lv_pmos ad=0.76p pd=4.38u as=0 ps=0 w=4u l=4u
X63 OUTp VCTRL OUTp VDD sg13_lv_pmos ad=0.76p pd=4.38u as=0 ps=0 w=4u l=4u
X64 a_n11430_n13770# OUTp OUTn GND sg13_lv_nmos ad=0.38p pd=2.38u as=0.38p ps=2.38u w=2u l=0.5u
X65 a_n11430_n13770# IBIAS GND GND sg13_lv_nmos ad=0.19p pd=1.38u as=0.19p ps=1.38u w=1u l=0.15u
X66 VDD OUTn OUTp VDD sg13_lv_pmos ad=1.615p pd=8.88u as=1.615p ps=8.88u w=8.5u l=0.5u
X67 OUTp VCTRL OUTp VDD sg13_lv_pmos ad=0.76p pd=4.38u as=0 ps=0 w=4u l=4u
X68 GND IBIAS a_n11430_n13770# GND sg13_lv_nmos ad=0.19p pd=1.38u as=0.19p ps=1.38u w=1u l=0.15u
X69 a_n11430_n13770# IBIAS GND GND sg13_lv_nmos ad=0.19p pd=1.38u as=0.19p ps=1.38u w=1u l=0.15u
X70 GND IBIAS a_n11430_n13770# GND sg13_lv_nmos ad=0.19p pd=1.38u as=0.19p ps=1.38u w=1u l=0.15u
X71 a_n11430_n13770# IBIAS GND GND sg13_lv_nmos ad=0.19p pd=1.38u as=0.19p ps=1.38u w=1u l=0.15u
X72 OUTn VCTRL OUTn VDD sg13_lv_pmos ad=0.76p pd=4.38u as=0 ps=0 w=4u l=4u
X73 OUTn OUTp VDD VDD sg13_lv_pmos ad=1.615p pd=8.88u as=1.615p ps=8.88u w=8.5u l=0.5u
X74 GND IBIAS a_n11430_n13770# GND sg13_lv_nmos ad=0.19p pd=1.38u as=0.19p ps=1.38u w=1u l=0.15u
X75 a_n11430_n13770# IBIAS GND GND sg13_lv_nmos ad=0.19p pd=1.38u as=0.19p ps=1.38u w=1u l=0.15u
X76 OUTn VCTRL OUTn VDD sg13_lv_pmos ad=0.76p pd=4.38u as=0 ps=0 w=4u l=4u
X77 GND IBIAS a_n11430_n13770# GND sg13_lv_nmos ad=0.19p pd=1.38u as=0.19p ps=1.38u w=1u l=0.15u
X78 OUTp OUTn cap_cmim l=4.26u w=4.26u
X79 OUTn OUTp a_n11430_n13770# GND sg13_lv_nmos ad=0.38p pd=2.38u as=0.38p ps=2.38u w=2u l=0.5u
X80 OUTp VCTRL OUTp VDD sg13_lv_pmos ad=0.76p pd=4.38u as=0 ps=0 w=4u l=4u
X81 VDD OUTn OUTp VDD sg13_lv_pmos ad=1.615p pd=8.88u as=1.615p ps=8.88u w=8.5u l=0.5u
X82 OUTn VCTRL OUTn VDD sg13_lv_pmos ad=1.36p pd=8.68u as=0 ps=0 w=4u l=4u
X83 VDD OUTn OUTp VDD sg13_lv_pmos ad=1.615p pd=8.88u as=1.615p ps=8.88u w=8.5u l=0.5u
X84 OUTp VCTRL OUTp VDD sg13_lv_pmos ad=0.76p pd=4.38u as=0 ps=0 w=4u l=4u
X85 GND IBIAS a_n11430_n13770# GND sg13_lv_nmos ad=0.19p pd=1.38u as=0.19p ps=1.38u w=1u l=0.15u
X86 OUTp VCTRL OUTp VDD sg13_lv_pmos ad=1.36p pd=8.68u as=0 ps=0 w=4u l=4u
X87 GND IBIAS a_n11430_n13770# GND sg13_lv_nmos ad=0.19p pd=1.38u as=0.19p ps=1.38u w=1u l=0.15u
X88 GND IBIAS a_n11430_n13770# GND sg13_lv_nmos ad=0.19p pd=1.38u as=0.19p ps=1.38u w=1u l=0.15u
X89 OUTn VCTRL OUTn VDD sg13_lv_pmos ad=0.76p pd=4.38u as=0 ps=0 w=4u l=4u
X90 a_n11430_n13770# IBIAS GND GND sg13_lv_nmos ad=0.19p pd=1.38u as=0.19p ps=1.38u w=1u l=0.15u
X91 a_n11430_n13770# IBIAS GND GND sg13_lv_nmos ad=0.19p pd=1.38u as=0.19p ps=1.38u w=1u l=0.15u
X92 a_n11430_n13770# OUTp OUTn GND sg13_lv_nmos ad=0.38p pd=2.38u as=0.38p ps=2.38u w=2u l=0.5u
X93 GND IBIAS a_n11430_n13770# GND sg13_lv_nmos ad=0.19p pd=1.38u as=0.19p ps=1.38u w=1u l=0.15u
X94 a_n11430_n13770# IBIAS GND GND sg13_lv_nmos ad=0.19p pd=1.38u as=0.19p ps=1.38u w=1u l=0.15u
X95 OUTp OUTn cap_cmim l=4.26u w=4.26u
X96 GND IBIAS a_n11430_n13770# GND sg13_lv_nmos ad=0.19p pd=1.38u as=0.19p ps=1.38u w=1u l=0.15u
X97 OUTp OUTn cap_cmim l=4.26u w=4.26u
X98 OUTp OUTn VDD VDD sg13_lv_pmos ad=1.615p pd=8.88u as=1.615p ps=8.88u w=8.5u l=0.5u
X99 OUTp VCTRL OUTp VDD sg13_lv_pmos ad=0.76p pd=4.38u as=0 ps=0 w=4u l=4u
X100 OUTp VCTRL OUTp VDD sg13_lv_pmos ad=0.76p pd=4.38u as=0 ps=0 w=4u l=4u
X101 a_n11430_n13770# OUTn OUTp GND sg13_lv_nmos ad=0.68p pd=4.68u as=0.38p ps=2.38u w=2u l=0.5u
X102 VDD OUTp OUTn VDD sg13_lv_pmos ad=1.615p pd=8.88u as=1.615p ps=8.88u w=8.5u l=0.5u
X103 OUTp OUTn cap_cmim l=4.26u w=4.26u
X104 OUTp OUTn VDD VDD sg13_lv_pmos ad=1.615p pd=8.88u as=1.615p ps=8.88u w=8.5u l=0.5u
X105 OUTn VCTRL OUTn VDD sg13_lv_pmos ad=0.76p pd=4.38u as=0 ps=0 w=4u l=4u
X106 OUTp VCTRL OUTp VDD sg13_lv_pmos ad=0.76p pd=4.38u as=0 ps=0 w=4u l=4u
X107 OUTp VCTRL OUTp VDD sg13_lv_pmos ad=0.76p pd=4.38u as=0 ps=0 w=4u l=4u
X108 VDD OUTp OUTn VDD sg13_lv_pmos ad=1.615p pd=8.88u as=1.615p ps=8.88u w=8.5u l=0.5u
X109 GND IBIAS a_n11430_n13770# GND sg13_lv_nmos ad=0.19p pd=1.38u as=0.19p ps=1.38u w=1u l=0.15u
X110 GND IBIAS a_n11430_n13770# GND sg13_lv_nmos ad=0.19p pd=1.38u as=0.19p ps=1.38u w=1u l=0.15u
X111 OUTn OUTp a_n11430_n13770# GND sg13_lv_nmos ad=0.38p pd=2.38u as=0.38p ps=2.38u w=2u l=0.5u
X112 OUTn VCTRL OUTn VDD sg13_lv_pmos ad=0.76p pd=4.38u as=0 ps=0 w=4u l=4u
X113 OUTn VCTRL OUTn VDD sg13_lv_pmos ad=0.76p pd=4.38u as=0 ps=0 w=4u l=4u
X114 a_n11430_n13770# OUTn OUTp GND sg13_lv_nmos ad=0.38p pd=2.38u as=0.38p ps=2.38u w=2u l=0.5u
X115 a_n11430_n13770# IBIAS GND GND sg13_lv_nmos ad=0.19p pd=1.38u as=0.19p ps=1.38u w=1u l=0.15u
X116 OUTp VCTRL OUTp VDD sg13_lv_pmos ad=0.76p pd=4.38u as=0 ps=0 w=4u l=4u
X117 OUTp VCTRL OUTp VDD sg13_lv_pmos ad=0.76p pd=4.38u as=0 ps=0 w=4u l=4u
X118 GND IBIAS a_n11430_n13770# GND sg13_lv_nmos ad=0.19p pd=1.38u as=0.19p ps=1.38u w=1u l=0.15u
X119 a_n11430_n13770# IBIAS GND GND sg13_lv_nmos ad=0.19p pd=1.38u as=0.19p ps=1.38u w=1u l=0.15u
X120 VDD OUTp OUTn VDD sg13_lv_pmos ad=1.615p pd=8.88u as=1.615p ps=8.88u w=8.5u l=0.5u
X121 a_n11430_n13770# IBIAS GND GND sg13_lv_nmos ad=0.19p pd=1.38u as=0.19p ps=1.38u w=1u l=0.15u
X122 VDD OUTp OUTn VDD sg13_lv_pmos ad=1.615p pd=8.88u as=1.615p ps=8.88u w=8.5u l=0.5u
X123 GND IBIAS a_n11430_n13770# GND sg13_lv_nmos ad=0.19p pd=1.38u as=0.19p ps=1.38u w=1u l=0.15u
X124 GND IBIAS a_n11430_n13770# GND sg13_lv_nmos ad=0.19p pd=1.38u as=0.19p ps=1.38u w=1u l=0.15u
X125 a_n11430_n13770# OUTn OUTp GND sg13_lv_nmos ad=0.38p pd=2.38u as=0.38p ps=2.38u w=2u l=0.5u
X126 OUTn VCTRL OUTn VDD sg13_lv_pmos ad=0.76p pd=4.38u as=0 ps=0 w=4u l=4u
X127 a_n11430_n13770# OUTn OUTp GND sg13_lv_nmos ad=0.38p pd=2.38u as=0.38p ps=2.38u w=2u l=0.5u
X128 VDD OUTp OUTn VDD sg13_lv_pmos ad=2.89p pd=17.68u as=1.615p ps=8.88u w=8.5u l=0.5u
X129 GND IBIAS IBIAS GND sg13_lv_nmos ad=0.34p pd=2.68u as=0.34p ps=2.68u w=1u l=0.15u
X130 a_n11430_n13770# OUTn OUTp GND sg13_lv_nmos ad=0.38p pd=2.38u as=0.38p ps=2.38u w=2u l=0.5u
X131 VDD OUTp OUTn VDD sg13_lv_pmos ad=1.615p pd=8.88u as=2.89p ps=17.68u w=8.5u l=0.5u
X132 OUTn VCTRL OUTn VDD sg13_lv_pmos ad=0.76p pd=4.38u as=0 ps=0 w=4u l=4u
X133 OUTp OUTn cap_cmim l=4.26u w=4.26u
X134 GND IBIAS a_n11430_n13770# GND sg13_lv_nmos ad=0.19p pd=1.38u as=0.19p ps=1.38u w=1u l=0.15u
X135 a_n11430_n13770# IBIAS GND GND sg13_lv_nmos ad=0.19p pd=1.38u as=0.19p ps=1.38u w=1u l=0.15u
X136 OUTp VCTRL OUTp VDD sg13_lv_pmos ad=0.76p pd=4.38u as=0 ps=0 w=4u l=4u
X137 a_n11430_n13770# IBIAS GND GND sg13_lv_nmos ad=0.19p pd=1.38u as=0.19p ps=1.38u w=1u l=0.15u
X138 GND IBIAS a_n11430_n13770# GND sg13_lv_nmos ad=0.34p pd=2.68u as=0.19p ps=1.38u w=1u l=0.15u
X139 OUTp VCTRL OUTp VDD sg13_lv_pmos ad=0.76p pd=4.38u as=0 ps=0 w=4u l=4u
X140 GND IBIAS a_n11430_n13770# GND sg13_lv_nmos ad=0.19p pd=1.38u as=0.19p ps=1.38u w=1u l=0.15u
X141 a_n11430_n13770# IBIAS GND GND sg13_lv_nmos ad=0.19p pd=1.38u as=0.19p ps=1.38u w=1u l=0.15u
X142 OUTn VCTRL OUTn VDD sg13_lv_pmos ad=0.76p pd=4.38u as=0 ps=0 w=4u l=4u
X143 OUTp VCTRL OUTp VDD sg13_lv_pmos ad=0.76p pd=4.38u as=0 ps=0 w=4u l=4u
X144 a_n11430_n13770# IBIAS GND GND sg13_lv_nmos ad=0.19p pd=1.38u as=0.19p ps=1.38u w=1u l=0.15u
X145 a_n11430_n13770# IBIAS GND GND sg13_lv_nmos ad=0.19p pd=1.38u as=0.19p ps=1.38u w=1u l=0.15u
X146 OUTp VCTRL OUTp VDD sg13_lv_pmos ad=1.36p pd=8.68u as=0 ps=0 w=4u l=4u
X147 GND IBIAS a_n11430_n13770# GND sg13_lv_nmos ad=0.19p pd=1.38u as=0.19p ps=1.38u w=1u l=0.15u
X148 OUTn VCTRL OUTn VDD sg13_lv_pmos ad=0.76p pd=4.38u as=0 ps=0 w=4u l=4u
X149 a_n11430_n13770# OUTp OUTn GND sg13_lv_nmos ad=0.38p pd=2.38u as=0.38p ps=2.38u w=2u l=0.5u
X150 a_n11430_n13770# IBIAS GND GND sg13_lv_nmos ad=0.19p pd=1.38u as=0.19p ps=1.38u w=1u l=0.15u
X151 a_n11430_n13770# OUTp OUTn GND sg13_lv_nmos ad=0.38p pd=2.38u as=0.38p ps=2.38u w=2u l=0.5u
X152 VDD OUTp OUTn VDD sg13_lv_pmos ad=1.615p pd=8.88u as=1.615p ps=8.88u w=8.5u l=0.5u
X153 GND IBIAS a_n11430_n13770# GND sg13_lv_nmos ad=0.19p pd=1.38u as=0.19p ps=1.38u w=1u l=0.15u
X154 OUTp OUTn VDD VDD sg13_lv_pmos ad=1.615p pd=8.88u as=2.89p ps=17.68u w=8.5u l=0.5u
X155 OUTp OUTn VDD VDD sg13_lv_pmos ad=1.615p pd=8.88u as=1.615p ps=8.88u w=8.5u l=0.5u
X156 a_n11430_n13770# IBIAS GND GND sg13_lv_nmos ad=0.19p pd=1.38u as=0.19p ps=1.38u w=1u l=0.15u
X157 OUTp VCTRL OUTp VDD sg13_lv_pmos ad=0.76p pd=4.38u as=0 ps=0 w=4u l=4u
X158 a_n11430_n13770# OUTn OUTp GND sg13_lv_nmos ad=0.38p pd=2.38u as=0.38p ps=2.38u w=2u l=0.5u
X159 a_n11430_n13770# IBIAS GND GND sg13_lv_nmos ad=0.19p pd=1.38u as=0.19p ps=1.38u w=1u l=0.15u
X160 OUTp VCTRL OUTp VDD sg13_lv_pmos ad=0.76p pd=4.38u as=0 ps=0 w=4u l=4u
X161 OUTn VCTRL OUTn VDD sg13_lv_pmos ad=0.76p pd=4.38u as=0 ps=0 w=4u l=4u
X162 a_n11430_n13770# OUTp OUTn GND sg13_lv_nmos ad=0.68p pd=4.68u as=0.38p ps=2.38u w=2u l=0.5u
X163 GND IBIAS a_n11430_n13770# GND sg13_lv_nmos ad=0.19p pd=1.38u as=0.19p ps=1.38u w=1u l=0.15u
X164 OUTp OUTn cap_cmim l=4.26u w=4.26u
X165 OUTn VCTRL OUTn VDD sg13_lv_pmos ad=0.76p pd=4.38u as=0 ps=0 w=4u l=4u
X166 OUTp OUTn VDD VDD sg13_lv_pmos ad=1.615p pd=8.88u as=1.615p ps=8.88u w=8.5u l=0.5u
X167 OUTp OUTn VDD VDD sg13_lv_pmos ad=1.615p pd=8.88u as=1.615p ps=8.88u w=8.5u l=0.5u
C0 VDD OUTn 34.6872f
C1 OUTp OUTn 22.7425f
C2 VDD OUTp 35.5897f
C3 VCTRL OUTn 7.49415f
C4 a_n2842_n10474# OUTn 0.03661f
C5 a_n11430_n13770# IBIAS 0.88362f
C6 VDD VCTRL 0.11371p
C7 VCTRL OUTp 8.69969f
C8 a_n11430_n13770# OUTn 5.36181f
C9 a_n2842_n10474# OUTp 0.0345f
C10 a_n11430_n13770# OUTp 2.83726f
R0 IBIAS.n2 IBIAS.n1 15.3132
R1 IBIAS.n2 IBIAS.n0 5.60402
R2 IBIAS IBIAS.n2 0.480361
R3 GND.n25 GND.n9 3.24343e+06
R4 GND.n33 GND.n32 2.67515e+06
R5 GND.n34 GND.n33 1.5764e+06
R6 GND.n33 GND.n9 18951.4
R7 GND.n23 GND.n9 3454.44
R8 GND.n32 GND.n31 1395.09
R9 GND.n32 GND.n10 1383.98
R10 GND.n35 GND.n7 1159.56
R11 GND.n7 GND.n6 273.729
R12 GND.n27 GND.n24 238.835
R13 GND.n20 GND.n12 198.18
R14 GND.n19 GND.n18 155.909
R15 GND.n14 GND.n13 138.99
R16 GND.n17 GND.n3 115.368
R17 GND.n27 GND.n23 106.578
R18 GND.n37 GND.n8 104.294
R19 GND.n44 GND.n43 100.897
R20 GND.n42 GND.n41 99.4221
R21 GND.n40 GND.n39 98.9181
R22 GND.n38 GND.n5 98.726
R23 GND.n39 GND.n38 94.6815
R24 GND.n41 GND.n40 91.8402
R25 GND.n8 GND.n5 87.4156
R26 GND.n44 GND.n42 82.2331
R27 GND.n35 GND.n34 80.3213
R28 GND.n26 GND.n16 72.8013
R29 GND.n34 GND.n1 69.9295
R30 GND.n27 GND.n26 66.7346
R31 GND.n29 GND.n25 66.0776
R32 GND.n37 GND.n36 65.656
R33 GND.n18 GND.n17 56.4055
R34 GND.n28 GND.n27 54.6011
R35 GND.n43 GND.n3 51.2645
R36 GND.n36 GND.n35 41.4058
R37 GND.n16 GND.n15 22.8722
R38 GND.n10 GND.n2 17.0005
R39 GND.n45 GND.n44 17.0005
R40 GND.n45 GND.n41 17.0005
R41 GND.n45 GND.n39 17.0005
R42 GND.n45 GND.n5 17.0005
R43 GND.n19 GND.n1 17.0005
R44 GND.n28 GND.n1 17.0005
R45 GND.n31 GND.n30 17.0005
R46 GND.n21 GND.n11 17.0005
R47 GND.n30 GND.n16 17.0005
R48 GND.n30 GND.n14 17.0005
R49 GND.n30 GND.n12 17.0005
R50 GND.n21 GND.n20 17.0005
R51 GND.n26 GND.n1 17.0005
R52 GND.n10 GND.n4 16.0347
R53 GND.n29 GND.n28 14.7118
R54 GND.n15 GND.n14 14.1331
R55 GND.n13 GND.n12 11.5891
R56 GND.n6 GND.n4 10.6338
R57 GND.n24 GND.n11 10.0691
R58 GND GND.n48 9.20182
R59 GND.n45 GND.n4 8.5005
R60 GND.n20 GND.n19 8.08948
R61 GND.n31 GND.n11 6.40733
R62 GND.n6 GND.n2 6.39142
R63 GND.n47 GND.n46 5.1641
R64 GND.n40 GND.n1 5.04852
R65 GND.n38 GND.n1 4.63899
R66 GND.n43 GND.n1 4.56494
R67 GND.n42 GND.n1 4.29093
R68 GND.n8 GND.n1 4.2275
R69 GND.n22 GND.n0 4.19872
R70 GND.n1 GND.n0 4.1456
R71 GND.n21 GND.n18 3.73636
R72 GND.n45 GND.n3 3.22702
R73 GND.n13 GND.n1 2.70697
R74 GND.n30 GND.n29 2.63005
R75 GND.n45 GND.n37 1.33179
R76 GND.n48 GND.n47 1.2105
R77 GND.n30 GND.n23 0.797623
R78 GND.n48 GND.n0 0.319573
R79 GND.n15 GND.n1 0.289125
R80 GND.n47 GND.n1 0.115637
R81 GND.n46 GND.n2 0.00418349
R82 GND.n22 GND.n21 0.00338574
R83 GND.n30 GND.n22 0.00161402
R84 GND.n46 GND.n45 0.00131634
R85 GND.n36 GND.n1 0.00115595
R86 GND.n30 GND.n24 0.0010475
R87 GND.n45 GND.n7 0.00103092
R88 GND.n17 GND.n1 0.00101635
R89 GND.n25 GND.n1 0.00100842
R90 VCTRL.n2 VCTRL.n1 78.4011
R91 VCTRL.n1 VCTRL.n0 49.6784
R92 VCTRL.n4 VCTRL.n2 25.1691
R93 VCTRL.n4 VCTRL.n3 24.4113
R94 VCTRL VCTRL.n4 0.32816
R95 VDD.n18 VDD.n14 17.0005
R96 VDD.n32 VDD.n31 17.0005
R97 VDD.n25 VDD.n24 14.9797
R98 VDD.n20 VDD.n3 10.3362
R99 VDD VDD.n32 9.27347
R100 VDD.n15 VDD.n8 8.501
R101 VDD.n7 VDD.n6 8.501
R102 VDD.n18 VDD.n13 8.5005
R103 VDD.n16 VDD.n8 5.66778
R104 VDD.n18 VDD.n17 5.66717
R105 VDD.n20 VDD.n19 4.45658
R106 VDD.n12 VDD.n8 4.251
R107 VDD.n11 VDD.n10 4.251
R108 VDD.n23 VDD.n7 2.83508
R109 VDD.n4 VDD.n3 2.67696
R110 VDD.n31 VDD.n1 2.6745
R111 VDD.n5 VDD.n2 2.66784
R112 VDD.n29 VDD.n2 2.59707
R113 VDD.n30 VDD.n0 2.39608
R114 VDD.n27 VDD.n26 2.30078
R115 VDD.n28 VDD.n27 2.15902
R116 VDD.n30 VDD.n29 2.01194
R117 VDD.n9 VDD.n8 1.54691
R118 VDD.n25 VDD.n4 1.13106
R119 VDD.n21 VDD.n9 0.855334
R120 VDD.n26 VDD.n25 0.798884
R121 VDD.n5 VDD.n1 0.727944
R122 VDD.n26 VDD.n5 0.586594
R123 VDD.n29 VDD.n28 0.577577
R124 VDD.n1 VDD.n0 0.470786
R125 VDD.n28 VDD.n3 0.435708
R126 VDD.n21 VDD.n20 0.322468
R127 VDD.n27 VDD.n4 0.215977
R128 VDD.n31 VDD.n2 0.16426
R129 VDD.n31 VDD.n30 0.105078
R130 VDD.n22 VDD.n21 0.00599958
R131 VDD.n32 VDD.n0 0.0058012
R132 VDD.n11 VDD.n9 0.00519254
R133 VDD.n24 VDD.n6 0.0038715
R134 VDD.n24 VDD.n23 0.00212831
R135 VDD.n23 VDD.n22 0.00199991
R136 VDD.n19 VDD.n6 0.00186037
R137 VDD.n17 VDD.n16 0.00166667
R138 VDD.n16 VDD.n14 0.00133332
R139 VDD.n14 VDD.n7 0.00124999
R140 VDD.n19 VDD.n18 0.0011396
R141 VDD.n22 VDD.n8 0.00100006
R142 VDD.n12 VDD.n11 0.001
R143 VDD.n17 VDD.n15 0.001
R144 VDD.n13 VDD.n12 0.001
R145 VDD.n15 VDD.n13 0.001
R146 VDD.n21 VDD.n10 0.001
R147 VDD.n18 VDD.n10 0.001
R148 OUTn.n2 OUTn.n0 27.5476
R149 OUTn.n2 OUTn.n1 24.8786
R150 OUTn OUTn.n2 4.73167
R151 OUTp.n10 OUTp.n9 29.2021
R152 OUTp.n2 OUTp.n0 27.6671
R153 OUTp.n2 OUTp.n1 24.8766
R154 OUTp OUTp.n10 2.14791
R155 OUTp.n10 OUTp.n2 1.16174
R156 OUTp.n9 OUTp.n8 0.0596857
R157 OUTp.n9 OUTp.n5 0.0252911
R158 OUTp.n5 OUTp.n4 0.0120043
R159 OUTp.n5 OUTp.n3 0.0120043
R160 OUTp.n8 OUTp.n7 0.0120043
R161 OUTp.n8 OUTp.n6 0.0120043
C11 OUTn GND 34.3726f
C12 IBIAS GND 13.8018f
C13 OUTp GND 34.5342f
C14 VCTRL GND 23.4512f
C15 VDD GND 17.8494f
C16 a_n2842_n10474# GND 0.13944f
C17 a_n11430_n13770# GND 15.0236f $ **FLOATING
.ends
