** sch_path: /foss/designs/unicasss-tools/SG13G2_2.4GHz_LC_VCO_FPLL/xschem/lc-vco/LC_VCO_PEX_tb.sch
**.subckt LC_VCO_PEX_tb FOUT VCTRL
*.opin FOUT
*.ipin VCTRL
VBGR VBGR GND 0.6
x1 OUTp OUTn FOUT VCTRL VBGR GND VDD LC_VCO_NOIND
V1 VDD GND 1.2
xind OUTp OUTn 4nH_INDUCTOR
Vup VCTRL GND PULSE(0.4 0.8 10n 90n 1n 1s 2s)
**** begin user architecture code

.param temp = 27
.options method=gear rshunt=1.0e12
* start-up kick: a noise-free run can stay at the unstable equilibrium
.ic v(OUTp)=0.4

.control

* Save required signals
save v(VCTRL) v(FOUT) v(OUTn) v(OUTp)

* Long transient simulation
tran 10p 500n 100n

* Save raw waveform
write tb_LC_VCO_PEX_tran.raw

* Plot transient waveform
let vout = v(FOUT)
plot v(VCTRL) v(OUTn) v(FOUT) v(OUTp)

* Plot steady-state waveform
plot v(VCTRL) v(OUTn) v(FOUT) v(OUTp) xlimit 400n 405n

* FFT analysis
setplot tran1
linearize vout
set specwindow=blackman
fft vout

* Plot FFT spectrum
let power_out_db = db(vout)
plot power_out_db xlimit 2.34G 2.54G ylimit -200 0

* Find the maximum magnitude value between 2G and 3G
meas sp max_power_out_db max power_out_db FROM=2G TO=3G

* Save FFT spectrum as raw file
write LC_VCO_PEX_fft.raw frequency power_out_db
shell python3 ../xschem/lc-vco/raw_spectrum_as_tran.py LC_VCO_PEX_fft.raw

* Save FFT data
wrdata fft_output_pex.txt frequency power_out_db

* Save waveform for external processing
wrdata vco_waveform_pex.txt power_out_db

.endc

.param temp=27
.control
save all
op
write LC_VCO_PEX_tb.raw
.endc

.include 4nH_INDUCTOR.spice
* Magic RC extraction of the VCO without its inductor (the inductor is the EM model above)
.include ../pex/LC_VCO_NOIND__LC_VCO_NOIND/magic_RC/LC_VCO_NOIND.pex_sim.spice

.lib cornerMOSlv.lib mos_tt
.lib cornerMOShv.lib mos_tt
.lib cornerRES.lib res_typ
.lib cornerCAP.lib cap_typ

**** end user architecture code
**.ends
.GLOBAL GND
.GLOBAL VDD
.end
