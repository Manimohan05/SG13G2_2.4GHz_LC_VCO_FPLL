** sch_path: /foss/designs/unicasss-tools/SG13G2_2.4GHz_LC_VCO_FPLL/xschem/dsm/xschem/tb_DSM_N_FREQ_DIV.sch
**.subckt tb_DSM_N_FREQ_DIV
V1 freq_in GND PULSE(0 1.2 0 20p 20p 187p 416.67p)
A2 [ en ] [ net2 ] adc1
.model adc1 adc_bridge in_low=0.4 in_high=1.2
A3 [ sdata ] [ net3 ] adc1
.model adc1 adc_bridge in_low=0.4 in_high=1.2
A4 [ sclk ] [ net4 ] adc1
.model adc1 adc_bridge in_low=0.4 in_high=1.2
A5 [ rst ] [ net5 ] adc1
.model adc1 adc_bridge in_low=0.4 in_high=1.2
A6 [ freq_in ] [ net6 ] adc1
.model adc1 adc_bridge in_low=0.4 in_high=1.2
* noconn rst
* noconn sclk
* noconn sdata
* noconn en
A10 [ net1 ] [ freq_out ] dac1
.model dac1 dac_bridge out_low=0 out_high=1.2
V2 VDD GND 1.2
adut [ net6 net5 net4 net3 net2 ] [ net1 ] null dut
.model dut d_cosim simulation=../simulations/dsm_and_freq_divider.so
**** begin user architecture code

* ngspice commands
.save v(dout) v(sdata) v(sclk) v(en) v(rst) v(dsm_clk) v(freq_in) v(freq_out)
.control
  tran 10p 250n
  meas tran fo_max max v(freq_out)
  meas tran fo_min min v(freq_out)
  meas tran t_r1 when v(freq_out)=0.6 rise=1
  meas tran t_f1 when v(freq_out)=0.6 fall=1
  meas tran half trig v(freq_out) val=0.6 rise=1 targ v(freq_out) val=0.6 fall=1
  meas tran per trig v(freq_out) val=0.6 rise=1 targ v(freq_out) val=0.6 rise=2
  remzerovec
  write tb_DSM_N_FREQ_DIV.raw
  plot v(freq_out)
.endc

* to generate following file copy stimuli.test
* to the simulation directory and run simulation -> Utile Stimuli Editor (GUI),
* and press 'Translate'
.include stimuli_test.cir

**** end user architecture code
**.ends
.GLOBAL VDD
.GLOBAL GND
.end
