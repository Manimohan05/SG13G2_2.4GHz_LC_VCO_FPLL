** sch_path: /foss/designs/unicasss-tools/frac-n-pll-vco-unic_cass/xschem/phase-freq-detector/tb_PHASE_FREQ_DET_PEX.sch
**.subckt tb_PHASE_FREQ_DET_PEX
Vdd VDD GND 'VDD'
Vfvco F_DIV GND 0 pulse(0 'VDD' 2n 1n 1n 5n 10n)
Vfref F_REF GND 0 pulse(0 'VDD' 0n 1n 1n 5n 10n)
x1 F_REF UP VDD GND F_DIV DN PHASE_FREQ_DET_PEX
**** begin user architecture code

.lib cornerMOSlv.lib mos_tt
.lib cornerMOShv.lib mos_tt
.lib cornerHBT.lib hbt_typ
.lib cornerRES.lib res_typ
.include /foss/pdks/ihp-sg13g2/libs.ref/sg13g2_stdcell/spice/sg13g2_stdcell.spice
.global VDD GND

.param RAW_TEMP = agauss(40, 30, 1)
.param TEMPGAUSS = max(20, min(RAW_TEMP, 80))
.option temp = 'TEMPGAUSS'
.param VDDGAUSS = agauss(1.2, 0.05, 1)
.include /foss/designs/unicasss-tools/frac-n-pll-vco-unic_cass/pex/PHASE_FREQ_DET__PHASE_FREQ_DET/magic_RC/PHASE_FREQ_DET.pex.spice
.param VDD = 'VDDGAUSS'
* analysis

.tran 100p 30n uic

.control
let i = 0
dowhile i < 10
  reset
  run
  write tb_PHASE_FREQ_DET_PEX.raw
  set appendwrite
  reset
  let i = i + 1
end
quit
.endc

**** end user architecture code
**.ends
.GLOBAL GND
.end
