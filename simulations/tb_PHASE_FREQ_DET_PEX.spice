** sch_path: /foss/designs/unicasss-tools/SG13G2_2.4GHz_LC_VCO_FPLL/xschem/phase-freq-detector/tb_PHASE_FREQ_DET_PEX.sch
**.subckt tb_PHASE_FREQ_DET_PEX
Vdd VDD GND 'VDD'
Vfvco F_DIV GND 0 pulse(0 'VDD' 2n 1n 1n 5n 10n)
Vfref F_REF GND 0 pulse(0 'VDD' 0n 1n 1n 5n 10n)
x1 F_REF UP VDD GND F_DIV DN PHASE_FREQ_DET_PEX
**** begin user architecture code

.lib cornerMOSlv.lib mos_tt
.lib cornerMOShv.lib mos_tt
.lib cornerHBT.lib hbt_typ
.lib cornerRES.lib res_typ
.include /foss/pdks/ihp-sg13g2/libs.ref/sg13g2_stdcell/spice/sg13g2_stdcell.spice
.global VDD GND

* Nominal conditions (27 C, 1.2 V). For the Monte Carlo spread of temperature and supply
* used in the paper, replace them by:
*   .param RAW_TEMP = agauss(40, 30, 1)
*   .param TEMPGAUSS = max(20, min(RAW_TEMP, 80))
*   .option temp = 'TEMPGAUSS'
*   .param VDDGAUSS = agauss(1.2, 0.05, 1)
*   .param VDD = 'VDDGAUSS'
.option temp = 27
.include /foss/designs/unicasss-tools/SG13G2_2.4GHz_LC_VCO_FPLL/pex/PHASE_FREQ_DET__PHASE_FREQ_DET/magic_RC/PHASE_FREQ_DET.pex.spice
.param VDD = 1.2
* analysis

.tran 100p 30n uic

.control
run
write tb_PHASE_FREQ_DET_PEX.raw
meas tran up_avg avg v(UP) from=10n to=30n
meas tran dn_avg avg v(DN) from=10n to=30n
meas tran up_r2 when v(UP)=0.6 rise=2
meas tran up_f2 when v(UP)=0.6 fall=2
meas tran dn_r2 when v(DN)=0.6 rise=2
meas tran dn_f2 when v(DN)=0.6 fall=2
* supply current (negative = drawn from the source), power = 1.2 V x |idd|
meas tran idd avg i(Vdd) from=10n to=30n
plot v(F_REF) v(F_DIV)
plot v(UP) v(DN)
.endc

**** end user architecture code
**.ends
.GLOBAL GND
.end
