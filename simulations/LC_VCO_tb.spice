** sch_path: /foss/designs/unicasss-tools/SG13G2_2.4GHz_LC_VCO_FPLL/xschem/lc-vco/LC_VCO_tb.sch
**.subckt LC_VCO_tb FOUT VCTRL
*.opin FOUT
*.ipin VCTRL
VBGR VBGR GND 0.6
x1 VDD VCTRL GND FOUT VBGR GND LC_VCO
V1 VDD GND 1.2
Vup VCTRL GND PULSE(0.4 0.8 10n 90n 1n 1s 2s)
**** begin user architecture code

.param temp = 27
.options method=gear rshunt=1.0e12

.control

* Save required signals
save v(VCTRL) v(FOUT) v(x1.Vx) v(x1.OUTp)

* Long transient simulation
tran 10p 500n 100n

* Save raw waveform
write tb_LC_VCO_tran.raw

* Plot transient waveform
let vout = v(FOUT)
plot v(VCTRL) v(x1.Vx) v(FOUT) v(x1.OUTp)

* Plot steady-state waveform
plot v(VCTRL) v(x1.Vx) v(FOUT) v(x1.OUTp) xlimit 400n 405n

* FFT analysis
setplot tran1
linearize vout
set specwindow=blackman
fft vout

* Plot FFT spectrum
let power_out_db = db(vout)
plot power_out_db xlimit 2.34G 2.54G ylimit -200 0

* Find the maximum magnitude value between 2G and 3G
meas sp max_power_out_db max power_out_db FROM=2G TO=3G

* Save FFT spectrum as raw file
write LC_VCO_fft.raw

* Save FFT data
wrdata fft_output_standalone.txt frequency power_out_db

* Save waveform for external processing
wrdata vco_waveform_standalone.txt power_out_db

.endc

.param temp=27
.control
save all
op
write LC_VCO_tb.raw
.endc

.include 4nH_INDUCTOR.spice

.lib cornerMOSlv.lib mos_tt
.lib cornerMOShv.lib mos_tt
.lib cornerRES.lib res_typ
.lib cornerCAP.lib cap_typ

**** end user architecture code
**.ends

* expanding   symbol:  xschem/lc-vco/LC_VCO.sym # of pins=6
** sym_path: /foss/designs/unicasss-tools/SG13G2_2.4GHz_LC_VCO_FPLL/xschem/lc-vco/LC_VCO.sym
** sch_path: /foss/designs/unicasss-tools/SG13G2_2.4GHz_LC_VCO_FPLL/xschem/lc-vco/LC_VCO.sch
.subckt LC_VCO VDD VCTRL GND FOUT VBGR SUB!
*.opin FOUT
*.ipin VCTRL
*.ipin VBGR
*.iopin VDD
*.iopin GND
*.iopin SUB!
x1 OUTn OUTp 4nH_INDUCTOR
XM5 Vx Vgs GND SUB! sg13_lv_nmos w=384u l=1u ng=48 m=1 mm_ok=1
XM4 OUTp OUTn VDD NW sg13_lv_pmos w=36u l=0.13u ng=5 m=1 mm_ok=1
XM3 OUTn OUTp VDD NW sg13_lv_pmos w=36u l=0.13u ng=5 m=1 mm_ok=1
XM2 OUTp OUTn Vx SUB! sg13_lv_nmos w=21.99u l=0.13u ng=3 m=1 mm_ok=1
XM1 OUTn OUTp Vx SUB! sg13_lv_nmos w=21.99u l=0.13u ng=3 m=1 mm_ok=1
XM6 Vgs Vgs GND SUB! sg13_lv_nmos w=64u l=1u ng=8 m=1 mm_ok=1
XC1 OUTn OUTp SUB! cap_rfcmim w=21.9e-6 l=21.9e-6 wfeed=10.0e-6 m=1 mm_ok=1
XC3 OUTp VCTRL OUTn sub! sg13_hv_svaricap w=9.74u l=0.8u Nx=7 mm_ok=1
XC2 OUTp VCTRL OUTn sub! sg13_hv_svaricap w=9.74u l=0.8u Nx=7 mm_ok=1
XM7 Vgs VBGR VDD NWa sg13_lv_pmos w=38u l=1u ng=5 m=1 mm_ok=1
XM8 FOUT OUTp VDD NW sg13_lv_pmos w=15u l=0.13u ng=10 m=1 mm_ok=1
XM9 FOUT OUTp GND SUB! sg13_lv_nmos w=1.5u l=0.13u ng=1 m=1 mm_ok=1
XM10 net1 OUTn VDD NW sg13_lv_pmos w=15u l=0.13u ng=10 m=1 mm_ok=1
XM11 net1 OUTn GND SUB! sg13_lv_nmos w=1.5u l=0.13u ng=1 m=1 mm_ok=1
XR1 VDD NW ntap1 R=7.357 w=10.22e-6 l=5.87e-6 rw=0.3e-6
XR2 VDD NW ntap1 R=7.357 w=10.22e-6 l=5.87e-6 rw=0.3e-6
XR3 GND SUB! ptap1 R=2.388 w=33.9e-6 l=14.41e-6 rw=0.3e-6
XR4 GND SUB! ptap1 R=8.306 w=10.09e-6 l=4.23e-6 rw=0.3e-6
XR5 GND SUB! ptap1 R=8.306 w=10.09e-6 l=4.23e-6 rw=0.3e-6
XR6 VDD NW ntap1 R=9.234 w=8.42e-6 l=4.52e-6 rw=0.3e-6
XR7 VDD NW ntap1 R=9.234 w=8.42e-6 l=4.52e-6 rw=0.3e-6
XR8 GND SUB! ptap1 R=16.59 w=3.21e-6 l=4.26e-6 rw=0.3e-6
XR9 GND SUB! ptap1 R=16.59 w=3.21e-6 l=4.26e-6 rw=0.3e-6
XR10 GND SUB! ptap1 R=4.768 w=10.76e-6 l=13.74e-6 rw=0.3e-6
XR11 GND SUB! ptap1 R=1.636 w=12.36e-6 l=57.9e-6 rw=0.3e-6
XR12 VDD NWa ntap1 R=5.63 w=10.62e-6 l=10.22e-6 rw=0.3e-6
.ends

.GLOBAL GND
.GLOBAL VDD
.end
