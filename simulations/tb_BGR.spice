** sch_path: /foss/designs/unicasss-tools/SG13G2_2.4GHz_LC_VCO_FPLL/xschem/bgr/tb_BGR.sch
**.subckt tb_BGR VBGR
*.opin VBGR
V1 VDD GND PULSE(0 1.2 0 10m 0 1 2)
x1 VDD GND VBGR GND BANDGAP_REF
**** begin user architecture code

.option rshunt=1.0e12
.control
save all
save VDD
alter V1 dc 1.2

op
print I(Vmeas)
print v(VBGR)
print -i(V1)

dc TEMP 100 -50 -5
print I(Vmeas)
print v(VBGR)
plot v(VBGR)

write tb_BGR_temp.raw
.endc

.control
save all
tran 100u 15m

print I(Vmeas)
meas tran vb_end find v(VBGR) at=15m
meas tran vb_max max v(VBGR) from=5m to=15m
meas tran vb_min min v(VBGR) from=5m to=15m
* supply current (negative = drawn from the source), power = 1.2 V x |idd|
meas tran idd avg i(V1) from=13m to=15m
plot v(VBGR)

write tb_BGR_transient.raw
.endc

.lib cornerMOSlv.lib mos_tt
.lib cornerMOShv.lib mos_tt
.lib cornerRES.lib res_typ
.lib cornerCAP.lib cap_typ

**** end user architecture code
**.ends

* expanding   symbol:  xschem/bgr/BANDGAP_REF.sym # of pins=4
** sym_path: /foss/designs/unicasss-tools/SG13G2_2.4GHz_LC_VCO_FPLL/xschem/bgr/BANDGAP_REF.sym
** sch_path: /foss/designs/unicasss-tools/SG13G2_2.4GHz_LC_VCO_FPLL/xschem/bgr/BANDGAP_REF.sch
.subckt BANDGAP_REF VDD GND VBGR SUB!
*.opin VBGR
*.iopin GND
*.iopin VDD
*.iopin SUB!
XM8 GND v- net1 SUB! sg13_lv_nmos w=150n l=10u ng=1 m=1 mm_ok=1
XM6 net1 net1 VDD bulk6 sg13_lv_pmos w=1u l=1u ng=1 m=1 mm_ok=1
XM7 net2 net1 VDD bulk6 sg13_lv_pmos w=1u l=1u ng=1 m=1 mm_ok=1
XM9 v- net2 VDD bulk5 sg13_lv_pmos w=200n l=4u ng=1 m=1 mm_ok=1
XM1 v- v+ GND SUB! sg13_lv_nmos w=7.14u l=5u ng=4 m=1 mm_ok=1
XM2 net3 net3 GND SUB! sg13_lv_nmos w=21u l=5u ng=8 m=1 mm_ok=1
XM3 v- Vo1 VDD bulk7 sg13_lv_pmos w=15u l=5u ng=8 m=1 mm_ok=1
XM4 v+ Vo1 VDD bulk7 sg13_lv_pmos w=15u l=5u ng=8 m=1 mm_ok=1
XM5 VBGR Vo1 VDD bulk7 sg13_lv_pmos w=16u l=5u ng=8 m=1 mm_ok=1
XR2 VBGR net11 sub! rppd w=0.710e-6 l=38.65e-6 m=1 b=0 mm_ok=1
XC1 net2 GND cap_cmim w=18.2e-6 l=18.2e-6 m=1 mm_ok=1
XM10 dn3 v- dn2 bulk sg13_lv_pmos w=3.64u l=3.7u ng=1 m=2 mm_ok=1
XM11 dn4 v+ dn2 bulk sg13_lv_pmos w=3.64u l=3.7u ng=1 m=2 mm_ok=1
XM12 dn4 VDD VDD bulk sg13_lv_pmos w=3.64u l=3.7u ng=1 m=2 mm_ok=1
XM13 dn3 VDD VDD bulk sg13_lv_pmos w=3.64u l=3.7u ng=1 m=2 mm_ok=1
XM15 dn2 VDD VDD bulk sg13_lv_pmos w=3.64u l=3.7u ng=1 m=2 mm_ok=1
XM16 dn2 VDD VDD bulk sg13_lv_pmos w=3.64u l=3.7u ng=1 m=2 mm_ok=1
XR4 VDD bulk ntap1 R=2.445 w=33.53e-6 l=13.15e-6 rw=0.36e-6
XM14 dn2 iout VDD bulk1 sg13_lv_pmos w=5.3u l=1.95u ng=1 m=1 mm_ok=1
XR5 GND SUB! ptap1 R=6.689 w=12.57e-6 l=4.39e-6 rw=0.72e-6
XR6 VDD bulk1 ntap1 R=7.319 w=6.765e-6 l=8.86e-6 rw=0.72e-6
XM17 GND dn3 dn3 SUB! sg13_lv_nmos w=720n l=9.75u ng=1 m=1 mm_ok=1
XM18 GND dn3 dn4 SUB! sg13_lv_nmos w=720n l=9.75u ng=1 m=1 mm_ok=1
XM19 Vo1 iout VDD bulk4 sg13_lv_pmos w=75u l=2.08u ng=8 m=1 mm_ok=1
XM20 GND dn4 Vo1 SUB! sg13_lv_nmos w=28.8u l=9.75u ng=4 m=1 mm_ok=1
XM21 iout iout VDD bulk4 sg13_lv_pmos w=75u l=2.08u ng=8 m=1 mm_ok=1
XC2 dn4 Vo1 cap_cmim w=22.29e-6 l=22.29e-6 m=1 mm_ok=1
XR8 VDD bulk4 ntap1 R=2.291 w=23.54e-6 l=23.22e-6 rw=0.72e-6
XR9 VDD bulk6 ntap1 R=7.123 w=5.76e-6 l=10.255e-6 rw=0.72e-6
XR12 v+ net7 sub! rppd w=0.5e-6 l=38.65e-6 m=1 b=0 mm_ok=1
XR3 net7 net6 sub! rppd w=0.5e-6 l=38.65e-6 m=1 b=0 mm_ok=1
XR13 net6 net5 sub! rppd w=0.5e-6 l=38.65e-6 m=1 b=0 mm_ok=1
XR14 net5 net4 sub! rppd w=0.5e-6 l=38.65e-6 m=1 b=0 mm_ok=1
XR15 net4 net3 sub! rppd w=0.5e-6 l=38.65e-6 m=1 b=0 mm_ok=1
XR16 net10 net9 sub! rppd w=0.5e-6 l=38.65e-6 m=1 b=0 mm_ok=1
XR17 net9 net8 sub! rppd w=0.5e-6 l=38.65e-6 m=1 b=0 mm_ok=1
XR18 net8 net17 sub! rppd w=0.5e-6 l=38.65e-6 m=1 b=0 mm_ok=1
XR19 net17 GND sub! rppd w=3e-6 l=38.65e-6 m=1 b=0 mm_ok=1
XR20 net11 net12 sub! rppd w=0.710e-6 l=38.65e-6 m=1 b=0 mm_ok=1
XR21 net12 net13 sub! rppd w=0.710e-6 l=38.65e-6 m=1 b=0 mm_ok=1
XR22 net13 net14 sub! rppd w=0.710e-6 l=38.65e-6 m=1 b=0 mm_ok=1
XR23 net14 net15 sub! rppd w=0.710e-6 l=38.65e-6 m=1 b=0 mm_ok=1
XR24 net15 net16 sub! rppd w=0.710e-6 l=38.65e-6 m=1 b=0 mm_ok=1
XR25 net16 GND sub! rppd w=0.710e-6 l=38.65e-6 m=1 b=0 mm_ok=1
XR26 VDD bulk5 ntap1 R=11.59 w=7.37e-6 l=3.03e-6 rw=0.72e-6
XR27 VDD bulk7 ntap1 R=1.868 w=46.185e-6 l=10.815e-6 rw=0.72e-6
XR7 GND SUB! ptap1 R=7.306 w=2.73e-6 l=12.92e-6 rw=0.72e-6
XR10 GND SUB! ptap1 R=2.076 w=46.215e-6 l=5.225e-6 rw=0.72e-6
XR11 GND SUB! ptap1 R=3.763 w=4.985e-6 l=24.045e-6 rw=0.72e-6
XR28 GND SUB! ptap1 R=2.219 w=9.24e-6 l=42.505e-6 rw=0.32e-6
XC3 VDD GND cap_cmim w=5e-6 l=5e-6 m=15 mm_ok=1
XR31 v+ net10 sub! rppd w=0.5e-6 l=38.65e-6 m=1 b=0 mm_ok=1
XR1 iout GND sub! rppd w=0.5e-6 l=15e-6 m=1 b=0 mm_ok=1
.ends

.GLOBAL GND
.GLOBAL VDD
.end
