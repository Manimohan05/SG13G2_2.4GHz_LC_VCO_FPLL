** sch_path: /foss/designs/unicasss-tools/SG13G2_2.4GHz_LC_VCO_FPLL/xschem/top-pll/LC_VCO_FPLL_tb.sch
**.subckt LC_VCO_FPLL_tb CLK_OUT
*.opin CLK_OUT
V1 VDD GND 1.2
Vfref CLK_IN GND 0 pulse(0 1.2 0n 1n 1n 50n 100n)
VBGR VBGR GND 0.6
xpll CLK_IN VDD CLK_OUT GND en rst sdata sclk LC_VCO_FPLL
* noconn en
* noconn rst
* noconn sdata
* noconn sclk
**** begin user architecture code

*****************************************************
* PLL + DSM Frequency Divider Testbench (Optimized)
*****************************************************

.option temp=27
.param VDD=1.2
.option rshunt = 1.0e12

* ==============================
* Include Models & Stimuli
* ==============================
.include 4nH_INDUCTOR.spice
.include ../simulations/stimuli_test.cir

* ==============================
* Simulation Options (Optimized for Speed & Stability)
* ==============================
* gear method improves stability for long oscillator runs
* reltol=1e-3 prevents the simulator from bogging down on microscopic errors
.options reltol=1e-3 abstol=1e-9 vntol=1e-6 method=gear

.control
  * CRITICAL: Save ONLY essential low-frequency signals.
  save xpll.vctrl xpll.up xpll.dn xpll.clk_fb clk_out clk_in vbgr xpll.vcp xpll.x4.outp sdata sclk en rst

  * 20p defines the step to resolve the 2.4 GHz edges without forcing a maxstep.
  tran 10p 40u

  remzerovec
  write tb_LC_VCO_FPLL_40u.raw
.endc

.lib cornerMOSlv.lib mos_tt
.lib cornerMOShv.lib mos_tt
.lib cornerHBT.lib hbt_typ
.lib cornerRES.lib res_typ
.lib cornerCAP.lib cap_typ
.include /foss/pdks/ihp-sg13g2/libs.ref/sg13g2_stdcell/spice/sg13g2_stdcell.spice
*.include /opt/pdks/ihp-sg13g2/libs.ref/sg13g2_stdcell/spice/sg13g2_stdcell.spice
.global VDD GND

**** end user architecture code
**.ends

* expanding   symbol:  xschem/top-pll/LC_VCO_FPLL.sym # of pins=8
** sym_path: /foss/designs/unicasss-tools/SG13G2_2.4GHz_LC_VCO_FPLL/xschem/top-pll/LC_VCO_FPLL.sym
** sch_path: /foss/designs/unicasss-tools/SG13G2_2.4GHz_LC_VCO_FPLL/xschem/top-pll/LC_VCO_FPLL.sch
.subckt LC_VCO_FPLL CLK_IN VDD CLK_OUT VSS EN RST SDATA SCLK
*.ipin CLK_IN
*.opin CLK_OUT
*.ipin EN
*.ipin SDATA
*.ipin SCLK
*.ipin RST
*.iopin VDD
*.iopin VSS
x1 CLK_IN UP VDD VSS CLK_FB DN PHASE_FREQ_DET
x2 UP VDD VCP VBGR VSS DN VSS CHARGE_PUMP
x3 VCTRL VCP VSS VSS LOOP_FILTER
x4 VDD VCTRL VSS CLK_OUT VBGR VSS LC_VCO
x5 CLK_OUT RST SCLK SDATA EN CLK_FB VDD VSS DSM_N_FREQ_DIV
x6 VDD VSS VBGR VSS BANDGAP_REF
**** begin user architecture code

* NGSPICE file created from DSM_N_FREQ_DIV.ext - technology: ihp-sg13g2

.subckt DSM_N_FREQ_DIV freq_in rst sclk sdata en freq_out VDD GND
XFILLER_13_111 VDD GND sg13g2_decap_8
XFILLER_9_159 VDD GND sg13g2_decap_8
XFILLER_3_67 VDD GND sg13g2_fill_1
XFILLER_10_147 VDD GND sg13g2_decap_8
X_200_ _200_/Y _200_/A _200_/B _200_/C VDD GND sg13g2_nand3_1
X_131_ _263_/D _263_/Q _262_/Q _130_/Y VDD GND sg13g2_a21oi_1
XFILLER_0_35 VDD GND sg13g2_decap_8
XFILLER_9_33 VDD GND sg13g2_decap_8
XFILLER_18_64 VDD GND sg13g2_fill_1
Xfanout7 _213_/A _260_/Q VDD GND sg13g2_buf_1
XFILLER_20_21 VDD GND sg13g2_decap_8
XFILLER_6_89 VDD GND sg13g2_decap_8
XFILLER_15_21 VDD GND sg13g2_decap_8
XFILLER_15_76 VDD GND sg13g2_decap_8
XFILLER_13_156 VDD GND sg13g2_decap_8
XFILLER_3_57 VDD GND sg13g2_fill_1
XFILLER_3_46 VDD GND sg13g2_decap_8
X_130_ _130_/Y _262_/Q _261_/Q _263_/Q VDD GND sg13g2_a21oi_1
XFILLER_0_14 VDD GND sg13g2_decap_8
X_259_ _259_/Q _260_/Q _259_/D _232_/Y VDD GND sg13g2_dfrbpq_1
XFILLER_9_67 VDD GND sg13g2_fill_2
XFILLER_2_144 VDD GND sg13g2_decap_8
XFILLER_18_54 VDD GND sg13g2_fill_2
XFILLER_15_7 VDD GND sg13g2_decap_8
Xfanout8 _224_/A input2/X VDD GND sg13g2_buf_1
XFILLER_20_77 VDD GND sg13g2_decap_8
XFILLER_6_68 VDD GND sg13g2_fill_1
XFILLER_19_151 VDD GND sg13g2_decap_8
XFILLER_16_165 VDD GND sg13g2_fill_2
XFILLER_9_128 VDD GND sg13g2_decap_8
XFILLER_10_116 VDD GND sg13g2_decap_8
XFILLER_10_138 VDD GND sg13g2_fill_1
XFILLER_5_164 VDD GND sg13g2_fill_2
X_189_ _196_/B _248_/Q _195_/B VDD GND sg13g2_xor2_1
X_258_ _258_/Q _260_/Q _258_/D _231_/Y VDD GND sg13g2_dfrbpq_1
XFILLER_9_79 VDD GND sg13g2_decap_8
Xfanout9 _232_/A input2/X VDD GND sg13g2_buf_1
XFILLER_1_0 VDD GND sg13g2_decap_8
XFILLER_20_56 VDD GND sg13g2_decap_8
XFILLER_6_47 VDD GND sg13g2_decap_8
XFILLER_19_130 VDD GND sg13g2_decap_8
XFILLER_15_56 VDD GND sg13g2_decap_8
XFILLER_13_136 VDD GND sg13g2_fill_1
XFILLER_9_107 VDD GND sg13g2_decap_8
XFILLER_12_35 VDD GND sg13g2_fill_2
XFILLER_5_7 VDD GND sg13g2_decap_8
XFILLER_5_143 VDD GND sg13g2_decap_8
XFILLER_0_49 VDD GND sg13g2_decap_8
X_188_ _192_/B _256_/Q _188_/B VDD GND sg13g2_nand2_1
X_257_ _257_/Q _260_/Q _257_/D _230_/Y VDD GND sg13g2_dfrbpq_1
XFILLER_9_69 VDD GND sg13g2_fill_1
XFILLER_9_47 VDD GND sg13g2_decap_4
XFILLER_6_26 VDD GND sg13g2_decap_8
XFILLER_20_35 VDD GND sg13g2_decap_8
XFILLER_20_7 VDD GND sg13g2_decap_8
XFILLER_15_35 VDD GND sg13g2_decap_8
XFILLER_13_104 VDD GND sg13g2_decap_8
XFILLER_7_91 VDD GND sg13g2_fill_2
XFILLER_7_80 VDD GND sg13g2_decap_8
XFILLER_8_130 VDD GND sg13g2_decap_4
XFILLER_5_122 VDD GND sg13g2_fill_2
XFILLER_5_166 VDD GND sg13g2_fill_1
XFILLER_2_158 VDD GND sg13g2_decap_4
XFILLER_2_136 VDD GND sg13g2_decap_4
XFILLER_2_114 VDD GND sg13g2_fill_1
XFILLER_0_28 VDD GND sg13g2_decap_8
XFILLER_13_90 VDD GND sg13g2_decap_8
X_256_ _256_/Q _213_/A _256_/D _229_/Y VDD GND sg13g2_dfrbpq_1
X_187_ _192_/A _247_/Q _195_/B VDD GND sg13g2_nand2_1
XFILLER_9_26 VDD GND sg13g2_decap_8
Xclkload0 clkload0/Y _250_/CLK VDD GND sg13g2_inv_1
X_239_ _239_/Y _239_/A VDD GND sg13g2_inv_1
XFILLER_20_14 VDD GND sg13g2_decap_8
XFILLER_19_165 VDD GND sg13g2_fill_2
XFILLER_15_14 VDD GND sg13g2_decap_8
XFILLER_15_69 VDD GND sg13g2_decap_8
XFILLER_16_113 VDD GND sg13g2_decap_4
XFILLER_11_4 VDD GND sg13g2_decap_4
XFILLER_13_149 VDD GND sg13g2_decap_8
XFILLER_4_93 VDD GND sg13g2_decap_8
X_255_ _255_/Q _213_/A _255_/D _228_/Y VDD GND sg13g2_dfrbpq_1
X_186_ _194_/A _172_/A _183_/Y _185_/Y VDD GND sg13g2_o21ai_1
X_238_ _238_/Y _239_/A VDD GND sg13g2_inv_1
X_169_ _171_/A _170_/A _170_/B _170_/C VDD GND sg13g2_a21oi_1
XFILLER_1_94 VDD GND sg13g2_decap_4
XFILLER_10_81 VDD GND sg13g2_decap_8
XFILLER_19_144 VDD GND sg13g2_decap_8
Xclkbuf_1_0__f_sclk _246_/CLK clkbuf_0_sclk/X VDD GND sg13g2_buf_16
XFILLER_10_109 VDD GND sg13g2_decap_8
XFILLER_12_49 VDD GND sg13g2_decap_4
XFILLER_5_157 VDD GND sg13g2_decap_8
XFILLER_5_102 VDD GND sg13g2_decap_8
XFILLER_4_72 VDD GND sg13g2_decap_8
X_254_ _254_/Q _213_/A _254_/D _227_/Y VDD GND sg13g2_dfrbpq_1
X_185_ _185_/Y _171_/A _184_/Y _179_/B VDD GND sg13g2_a21oi_1
XFILLER_3_7 VDD GND sg13g2_fill_2
XFILLER_2_127 VDD GND sg13g2_fill_1
XFILLER_1_160 VDD GND sg13g2_decap_8
X_237_ _237_/Y _241_/A VDD GND sg13g2_inv_1
X_168_ _170_/C _255_/Q _174_/B VDD GND sg13g2_xnor2_1
XFILLER_20_49 VDD GND sg13g2_decap_8
XFILLER_19_123 VDD GND sg13g2_decap_8
XFILLER_15_49 VDD GND sg13g2_decap_8
XFILLER_13_118 VDD GND sg13g2_decap_4
XFILLER_16_92 VDD GND sg13g2_decap_8
XFILLER_8_166 VDD GND sg13g2_fill_1
XFILLER_5_136 VDD GND sg13g2_decap_8
XFILLER_4_51 VDD GND sg13g2_decap_8
X_253_ _253_/Q _213_/A _253_/D _226_/Y VDD GND sg13g2_dfrbpq_1
X_184_ _184_/Y _184_/A _184_/B _184_/C VDD GND sg13g2_nand3_1
X_236_ _236_/Y _241_/A VDD GND sg13g2_inv_1
X_167_ _174_/B _246_/Q _173_/B VDD GND sg13g2_xor2_1
XFILLER_20_28 VDD GND sg13g2_decap_8
XFILLER_1_74 VDD GND sg13g2_fill_1
XFILLER_6_19 VDD GND sg13g2_decap_8
X_219_ _219_/Y _224_/A VDD GND sg13g2_inv_1
XFILLER_15_28 VDD GND sg13g2_decap_8
XFILLER_16_127 VDD GND sg13g2_decap_4
XFILLER_15_160 VDD GND sg13g2_decap_8
XFILLER_16_71 VDD GND sg13g2_decap_8
XFILLER_8_134 VDD GND sg13g2_fill_2
XFILLER_8_123 VDD GND sg13g2_decap_8
XFILLER_4_30 VDD GND sg13g2_decap_8
XFILLER_13_83 VDD GND sg13g2_decap_8
X_252_ _252_/Q _213_/A _252_/D _225_/Y VDD GND sg13g2_dfrbpq_1
X_183_ _183_/Y _183_/A _183_/B VDD GND sg13g2_nand2_1
XFILLER_9_19 VDD GND sg13g2_decap_8
X_235_ _235_/Y _241_/A VDD GND sg13g2_inv_1
X_166_ _170_/B _254_/Q _166_/B VDD GND sg13g2_nand2_1
XFILLER_10_95 VDD GND sg13g2_decap_8
X_218_ _218_/Y _224_/A VDD GND sg13g2_inv_1
X_149_ _157_/B _253_/Q _149_/B VDD GND sg13g2_xnor2_1
XFILLER_19_158 VDD GND sg13g2_decap_8
XFILLER_11_8 VDD GND sg13g2_fill_1
XFILLER_16_106 VDD GND sg13g2_decap_8
XFILLER_16_117 VDD GND sg13g2_fill_2
XFILLER_7_96 VDD GND sg13g2_decap_4
XFILLER_7_52 VDD GND sg13g2_fill_2
XFILLER_5_116 VDD GND sg13g2_fill_2
XFILLER_4_86 VDD GND sg13g2_decap_8
XFILLER_13_62 VDD GND sg13g2_decap_8
X_251_ _251_/Q _213_/A _251_/D _224_/Y VDD GND sg13g2_dfrbpq_1
X_182_ _256_/D _183_/B _182_/B VDD GND sg13g2_xnor2_1
XFILLER_8_0 VDD GND sg13g2_decap_8
XFILLER_1_7 VDD GND sg13g2_decap_4
X_234_ _234_/Y _241_/A VDD GND sg13g2_inv_1
X_165_ _170_/A _245_/Q _173_/B VDD GND sg13g2_nand2_1
XFILLER_1_87 VDD GND sg13g2_decap_8
XFILLER_10_52 VDD GND sg13g2_decap_8
X_217_ _217_/Y _224_/A VDD GND sg13g2_inv_1
X_148_ _149_/B _244_/Q _195_/B VDD GND sg13g2_xor2_1
XFILLER_19_83 VDD GND sg13g2_fill_2
XFILLER_19_137 VDD GND sg13g2_decap_8
XFILLER_12_165 VDD GND sg13g2_fill_2
XFILLER_4_65 VDD GND sg13g2_decap_8
X_250_ _250_/Q _250_/CLK _250_/D _223_/Y VDD GND sg13g2_dfrbpq_1
X_181_ _182_/B _180_/X _183_/A _171_/A VDD GND sg13g2_a21oi_1
XFILLER_1_153 VDD GND sg13g2_decap_8
X_233_ _233_/Y _239_/A VDD GND sg13g2_inv_1
X_164_ _172_/A _151_/A _160_/X _163_/X VDD GND sg13g2_a21oi_2
XFILLER_1_66 VDD GND sg13g2_decap_4
XFILLER_1_11 VDD GND sg13g2_fill_1
XFILLER_19_62 VDD GND sg13g2_decap_8
XFILLER_19_116 VDD GND sg13g2_decap_8
X_216_ _216_/Y _224_/A VDD GND sg13g2_inv_1
X_147_ _157_/A _252_/Q _140_/B _146_/X VDD GND sg13g2_a21oi_1
XFILLER_7_87 VDD GND sg13g2_decap_4
XFILLER_16_0 VDD GND sg13g2_decap_8
XFILLER_16_85 VDD GND sg13g2_decap_8
XFILLER_5_129 VDD GND sg13g2_decap_8
XFILLER_4_44 VDD GND sg13g2_decap_8
XFILLER_4_162 VDD GND sg13g2_decap_4
XFILLER_13_97 VDD GND sg13g2_decap_8
Xfanout10 _241_/A _239_/A VDD GND sg13g2_buf_1
X_180_ _180_/X _151_/A _160_/X _163_/X VDD GND sg13g2_a21o_1
XFILLER_1_132 VDD GND sg13g2_decap_8
X_232_ _232_/Y _232_/A VDD GND sg13g2_inv_1
X_163_ _163_/X _157_/Y _161_/Y _162_/Y VDD GND sg13g2_a21o_2
XFILLER_10_21 VDD GND sg13g2_decap_4
XFILLER_19_41 VDD GND sg13g2_decap_8
X_215_ _215_/Y _224_/A VDD GND sg13g2_inv_1
X_146_ _146_/X _243_/Q _173_/B VDD GND sg13g2_and2_1
XFILLER_15_153 VDD GND sg13g2_decap_8
X_129_ _262_/D _262_/Q _261_/Q _128_/Y VDD GND sg13g2_a21oi_1
XFILLER_8_116 VDD GND sg13g2_decap_8
XFILLER_4_23 VDD GND sg13g2_decap_8
XFILLER_4_141 VDD GND sg13g2_decap_8
Xfanout11 _239_/A input2/X VDD GND sg13g2_buf_1
XFILLER_13_76 VDD GND sg13g2_decap_8
XFILLER_1_111 VDD GND sg13g2_decap_8
X_231_ _231_/Y _232_/A VDD GND sg13g2_inv_1
X_162_ _162_/Y _162_/A _162_/B VDD GND sg13g2_nor2_1
XFILLER_1_46 VDD GND sg13g2_decap_4
XFILLER_10_66 VDD GND sg13g2_decap_8
XFILLER_10_88 VDD GND sg13g2_decap_8
Xinput1 _125_/S en VDD GND sg13g2_buf_1
X_214_ _267_/D _267_/Q VDD GND sg13g2_inv_1
X_145_ _151_/A _143_/Y _142_/B _144_/Y VDD GND sg13g2_a21o_2
XFILLER_18_162 VDD GND sg13g2_decap_4
XFILLER_15_132 VDD GND sg13g2_decap_8
X_128_ _128_/Y _262_/Q _261_/Q _127_/Y VDD GND sg13g2_o21ai_1
XFILLER_7_45 VDD GND sg13g2_decap_8
XFILLER_5_109 VDD GND sg13g2_decap_8
XFILLER_4_79 VDD GND sg13g2_decap_8
X_230_ _230_/Y _241_/A VDD GND sg13g2_inv_1
X_161_ _161_/Y _162_/A _162_/B VDD GND sg13g2_nand2_1
Xinput2 input2/X rst VDD GND sg13g2_buf_1
X_213_ _260_/D _213_/A VDD GND sg13g2_inv_1
X_144_ _144_/Y _144_/A _144_/B VDD GND sg13g2_nor2_1
XFILLER_19_76 VDD GND sg13g2_decap_8
XFILLER_18_130 VDD GND sg13g2_decap_4
XFILLER_15_111 VDD GND sg13g2_decap_8
X_127_ _127_/Y _263_/Q _262_/Q VDD GND sg13g2_nand2_1
XFILLER_16_33 VDD GND sg13g2_decap_4
XFILLER_16_99 VDD GND sg13g2_decap_8
XFILLER_14_0 VDD GND sg13g2_decap_8
XFILLER_4_58 VDD GND sg13g2_decap_8
XFILLER_4_121 VDD GND sg13g2_fill_1
XFILLER_13_34 VDD GND sg13g2_fill_2
XFILLER_13_45 VDD GND sg13g2_decap_4
XFILLER_1_146 VDD GND sg13g2_decap_8
X_160_ _160_/X _160_/A _160_/B VDD GND sg13g2_and2_1
Xinput3 input3/X sdata VDD GND sg13g2_buf_1
X_212_ _268_/D _268_/Q VDD GND sg13g2_inv_1
X_143_ _143_/Y _143_/A VDD GND sg13g2_inv_1
XFILLER_19_55 VDD GND sg13g2_decap_8
X_126_ _261_/D _263_/Q _262_/Q _261_/Q VDD GND sg13g2_a21oi_1
XFILLER_16_78 VDD GND sg13g2_decap_8
XFILLER_4_37 VDD GND sg13g2_decap_8
XFILLER_4_166 VDD GND sg13g2_fill_1
XFILLER_4_155 VDD GND sg13g2_decap_8
XFILLER_4_100 VDD GND sg13g2_decap_8
XFILLER_1_125 VDD GND sg13g2_decap_8
XFILLER_10_14 VDD GND sg13g2_decap_8
XFILLER_10_25 VDD GND sg13g2_fill_2
X_211_ _265_/D _264_/Q VDD GND sg13g2_inv_1
X_142_ _252_/D _143_/A _142_/B VDD GND sg13g2_xnor2_1
XFILLER_4_0 VDD GND sg13g2_decap_8
XFILLER_15_146 VDD GND sg13g2_decap_8
X_125_ _242_/D _242_/Q input3/X _125_/S VDD GND sg13g2_mux2_1
XFILLER_7_37 VDD GND sg13g2_decap_4
XFILLER_20_160 VDD GND sg13g2_decap_8
XFILLER_7_131 VDD GND sg13g2_decap_4
XFILLER_4_134 VDD GND sg13g2_decap_8
XFILLER_13_36 VDD GND sg13g2_fill_1
XFILLER_13_69 VDD GND sg13g2_decap_8
XFILLER_5_81 VDD GND sg13g2_decap_8
XFILLER_6_4 VDD GND sg13g2_decap_4
XFILLER_1_39 VDD GND sg13g2_decap_8
XFILLER_10_59 VDD GND sg13g2_decap_8
X_210_ _251_/D _242_/Q _210_/B VDD GND sg13g2_xnor2_1
X_141_ _142_/B _144_/A _144_/B VDD GND sg13g2_xor2_1
XFILLER_18_166 VDD GND sg13g2_fill_1
XFILLER_15_125 VDD GND sg13g2_decap_8
X_124_ _243_/D _243_/Q _242_/Q _125_/S VDD GND sg13g2_mux2_1
XFILLER_12_0 VDD GND sg13g2_decap_4
XFILLER_5_60 VDD GND sg13g2_decap_8
XFILLER_19_69 VDD GND sg13g2_decap_8
X_140_ _144_/B _252_/Q _140_/B VDD GND sg13g2_xnor2_1
XFILLER_18_134 VDD GND sg13g2_fill_1
XFILLER_18_101 VDD GND sg13g2_fill_2
XFILLER_15_104 VDD GND sg13g2_decap_8
XFILLER_11_81 VDD GND sg13g2_decap_8
XFILLER_16_7 VDD GND sg13g2_fill_2
X_123_ _244_/D _244_/Q _243_/Q _125_/S VDD GND sg13g2_mux2_1
XFILLER_12_107 VDD GND sg13g2_fill_1
XFILLER_16_26 VDD GND sg13g2_decap_8
XFILLER_16_37 VDD GND sg13g2_fill_2
XFILLER_7_166 VDD GND sg13g2_fill_1
XFILLER_7_100 VDD GND sg13g2_fill_1
XFILLER_4_114 VDD GND sg13g2_decap_8
XFILLER_1_139 VDD GND sg13g2_decap_8
XFILLER_19_48 VDD GND sg13g2_decap_8
XFILLER_19_26 VDD GND sg13g2_decap_8
X_199_ _201_/A _200_/A _200_/B _200_/C VDD GND sg13g2_a21oi_1
X_268_ _268_/Q _267_/Q _268_/D _241_/Y VDD GND sg13g2_dfrbpq_1
XFILLER_11_60 VDD GND sg13g2_decap_8
X_122_ _245_/D _245_/Q _244_/Q _125_/S VDD GND sg13g2_mux2_1
XFILLER_2_0 VDD GND sg13g2_fill_2
XFILLER_7_123 VDD GND sg13g2_fill_2
XFILLER_8_72 VDD GND sg13g2_decap_4
XFILLER_4_148 VDD GND sg13g2_decap_8
XFILLER_1_118 VDD GND sg13g2_decap_8
XFILLER_0_162 VDD GND sg13g2_decap_4
XFILLER_5_95 VDD GND sg13g2_decap_8
X_198_ _200_/C _258_/Q _198_/B VDD GND sg13g2_xnor2_1
X_267_ _267_/Q freq_in _267_/D _240_/Y VDD GND sg13g2_dfrbpq_1
XFILLER_15_139 VDD GND sg13g2_decap_8
X_121_ _246_/D _246_/Q _245_/Q _125_/S VDD GND sg13g2_mux2_1
XFILLER_20_153 VDD GND sg13g2_decap_8
XFILLER_11_120 VDD GND sg13g2_fill_1
XFILLER_7_135 VDD GND sg13g2_fill_1
XFILLER_4_127 VDD GND sg13g2_decap_8
XFILLER_0_141 VDD GND sg13g2_decap_8
XFILLER_10_0 VDD GND sg13g2_decap_8
XFILLER_5_74 VDD GND sg13g2_decap_8
XFILLER_6_8 VDD GND sg13g2_fill_1
X_197_ _198_/B _249_/Q _259_/Q VDD GND sg13g2_xnor2_1
X_266_ _266_/Q _268_/Q _266_/D _239_/Y VDD GND sg13g2_dfrbpq_1
XFILLER_11_40 VDD GND sg13g2_decap_8
XFILLER_11_51 VDD GND sg13g2_fill_1
XFILLER_11_95 VDD GND sg13g2_decap_8
XFILLER_15_118 VDD GND sg13g2_decap_8
X_120_ _247_/D _247_/Q _246_/Q _125_/S VDD GND sg13g2_mux2_1
XFILLER_2_2 VDD GND sg13g2_fill_1
XFILLER_14_162 VDD GND sg13g2_decap_4
X_249_ _249_/Q _250_/CLK _249_/D _222_/Y VDD GND sg13g2_dfrbpq_1
XFILLER_20_132 VDD GND sg13g2_decap_8
XFILLER_14_7 VDD GND sg13g2_fill_2
XFILLER_7_125 VDD GND sg13g2_fill_1
XFILLER_17_94 VDD GND sg13g2_decap_8
XFILLER_12_4 VDD GND sg13g2_fill_1
XFILLER_0_120 VDD GND sg13g2_decap_8
XFILLER_5_53 VDD GND sg13g2_decap_8
X_196_ _200_/B _257_/Q _196_/B VDD GND sg13g2_nand2_1
X_265_ _266_/D _268_/Q _265_/D _238_/Y VDD GND sg13g2_dfrbpq_1
XFILLER_11_74 VDD GND sg13g2_decap_8
XFILLER_14_141 VDD GND sg13g2_decap_8
X_248_ _248_/Q _250_/CLK _248_/D _221_/Y VDD GND sg13g2_dfrbpq_1
X_179_ _183_/B _179_/A _179_/B VDD GND sg13g2_nor2_1
XFILLER_16_19 VDD GND sg13g2_decap_8
XFILLER_20_111 VDD GND sg13g2_decap_8
XFILLER_0_0 VDD GND sg13g2_decap_8
XFILLER_11_166 VDD GND sg13g2_fill_1
XFILLER_8_64 VDD GND sg13g2_fill_2
XFILLER_4_107 VDD GND sg13g2_decap_8
XFILLER_5_21 VDD GND sg13g2_decap_8
XFILLER_19_19 VDD GND sg13g2_decap_8
XFILLER_4_7 VDD GND sg13g2_fill_2
X_195_ _200_/A _248_/Q _195_/B VDD GND sg13g2_nand2_1
X_264_ _264_/Q _268_/Q _264_/D _237_/Y VDD GND sg13g2_dfrbpq_1
X_247_ _247_/Q _250_/CLK _247_/D _220_/Y VDD GND sg13g2_dfrbpq_1
X_178_ _179_/B _184_/A _184_/B _184_/C VDD GND sg13g2_a21oi_1
XFILLER_7_116 VDD GND sg13g2_fill_2
XFILLER_17_52 VDD GND sg13g2_decap_8
XFILLER_0_155 VDD GND sg13g2_decap_8
XFILLER_0_166 VDD GND sg13g2_fill_1
XFILLER_5_88 VDD GND sg13g2_decap_8
X_194_ _257_/D _194_/A _204_/A VDD GND sg13g2_xor2_1
X_263_ _263_/Q _266_/Q _263_/D _236_/Y VDD GND sg13g2_dfrbpq_1
XFILLER_17_151 VDD GND sg13g2_decap_8
XFILLER_14_121 VDD GND sg13g2_fill_2
X_246_ _246_/Q _246_/CLK _246_/D _219_/Y VDD GND sg13g2_dfrbpq_1
X_177_ _179_/A _184_/A _184_/B _184_/C VDD GND sg13g2_and3_1
XFILLER_20_146 VDD GND sg13g2_decap_8
XFILLER_11_102 VDD GND sg13g2_decap_8
X_229_ _229_/Y _241_/A VDD GND sg13g2_inv_1
XFILLER_8_66 VDD GND sg13g2_fill_1
XFILLER_3_120 VDD GND sg13g2_fill_2
XFILLER_0_134 VDD GND sg13g2_decap_8
XFILLER_5_67 VDD GND sg13g2_decap_8
XFILLER_14_54 VDD GND sg13g2_decap_4
XFILLER_14_65 VDD GND sg13g2_decap_4
X_193_ _204_/A _193_/A _192_/Y VDD GND sg13g2_nor2b_1
X_262_ _262_/Q _266_/Q _262_/D _235_/Y VDD GND sg13g2_dfrbpq_1
XFILLER_4_9 VDD GND sg13g2_fill_1
XFILLER_2_46 VDD GND sg13g2_fill_2
XFILLER_11_33 VDD GND sg13g2_decap_8
XFILLER_11_88 VDD GND sg13g2_decap_8
XFILLER_14_155 VDD GND sg13g2_decap_8
XFILLER_14_166 VDD GND sg13g2_fill_1
X_245_ _245_/Q _246_/CLK _245_/D _218_/Y VDD GND sg13g2_dfrbpq_1
X_176_ _184_/C _256_/Q _188_/B VDD GND sg13g2_xnor2_1
XFILLER_20_125 VDD GND sg13g2_decap_8
XFILLER_7_118 VDD GND sg13g2_fill_1
X_228_ _228_/Y _239_/A VDD GND sg13g2_inv_1
X_159_ _254_/D _160_/B _159_/B VDD GND sg13g2_xnor2_1
Xclkbuf_0_sclk clkbuf_0_sclk/X sclk VDD GND sg13g2_buf_16
XFILLER_3_165 VDD GND sg13g2_fill_2
XFILLER_0_113 VDD GND sg13g2_decap_8
X_192_ _192_/Y _192_/A _192_/B _192_/C VDD GND sg13g2_nand3_1
X_261_ _261_/Q _266_/Q _261_/D _234_/Y VDD GND sg13g2_dfrbpq_1
XFILLER_9_0 VDD GND sg13g2_decap_8
XFILLER_11_67 VDD GND sg13g2_decap_8
XFILLER_14_134 VDD GND sg13g2_decap_8
X_244_ _244_/Q _246_/CLK _244_/D _217_/Y VDD GND sg13g2_dfrbpq_1
X_175_ _188_/B _247_/Q _195_/B VDD GND sg13g2_xor2_1
XFILLER_20_104 VDD GND sg13g2_decap_8
X_227_ _227_/Y _239_/A VDD GND sg13g2_inv_1
X_158_ _159_/B _151_/A _160_/A _157_/Y VDD GND sg13g2_a21oi_1
XFILLER_6_152 VDD GND sg13g2_fill_1
XFILLER_5_14 VDD GND sg13g2_decap_8
X_260_ _260_/Q _263_/Q _260_/D _233_/Y VDD GND sg13g2_dfrbpq_1
XFILLER_17_165 VDD GND sg13g2_fill_2
X_191_ _193_/A _192_/A _192_/B _192_/C VDD GND sg13g2_a21oi_1
XFILLER_2_48 VDD GND sg13g2_fill_1
X_243_ _243_/Q _246_/CLK _243_/D _216_/Y VDD GND sg13g2_dfrbpq_1
X_174_ _184_/B _255_/Q _174_/B VDD GND sg13g2_nand2_1
XFILLER_11_116 VDD GND sg13g2_decap_4
XFILLER_3_91 VDD GND sg13g2_decap_8
X_226_ _226_/Y _239_/A VDD GND sg13g2_inv_1
X_157_ _157_/Y _157_/A _157_/B VDD GND sg13g2_nor2_1
XFILLER_6_164 VDD GND sg13g2_fill_2
XFILLER_17_45 VDD GND sg13g2_decap_8
XFILLER_0_70 VDD GND sg13g2_decap_4
XFILLER_0_92 VDD GND sg13g2_decap_8
XFILLER_17_0 VDD GND sg13g2_decap_4
X_209_ _259_/D _209_/A _209_/B VDD GND sg13g2_xnor2_1
XFILLER_0_148 VDD GND sg13g2_decap_8
XFILLER_10_7 VDD GND sg13g2_decap_8
X_190_ _192_/C _257_/Q _196_/B VDD GND sg13g2_xnor2_1
XFILLER_11_47 VDD GND sg13g2_decap_4
XFILLER_14_114 VDD GND sg13g2_decap_8
X_242_ _242_/Q _246_/CLK _242_/D _215_/Y VDD GND sg13g2_dfrbpq_1
X_173_ _184_/A _246_/Q _173_/B VDD GND sg13g2_nand2_1
XFILLER_20_139 VDD GND sg13g2_decap_8
XFILLER_10_161 VDD GND sg13g2_decap_4
X_225_ _225_/Y _239_/A VDD GND sg13g2_inv_1
X_156_ _160_/B _162_/A _162_/B VDD GND sg13g2_xor2_1
XFILLER_8_48 VDD GND sg13g2_fill_2
XFILLER_8_37 VDD GND sg13g2_fill_2
XFILLER_19_4 VDD GND sg13g2_decap_4
X_208_ _209_/B _250_/Q _208_/B VDD GND sg13g2_xor2_1
X_139_ _140_/B _243_/Q _173_/B VDD GND sg13g2_xor2_1
XFILLER_0_127 VDD GND sg13g2_decap_8
XFILLER_14_47 VDD GND sg13g2_fill_2
XFILLER_14_58 VDD GND sg13g2_fill_2
XFILLER_17_112 VDD GND sg13g2_fill_2
XFILLER_15_90 VDD GND sg13g2_decap_8
XFILLER_11_26 VDD GND sg13g2_decap_8
XFILLER_14_148 VDD GND sg13g2_decap_8
X_241_ _241_/Y _241_/A VDD GND sg13g2_inv_1
X_172_ _255_/D _172_/A _183_/A VDD GND sg13g2_xnor2_1
XFILLER_9_152 VDD GND sg13g2_decap_8
XFILLER_7_0 VDD GND sg13g2_decap_8
XFILLER_20_118 VDD GND sg13g2_decap_8
XFILLER_0_7 VDD GND sg13g2_decap_8
X_224_ _224_/Y _224_/A VDD GND sg13g2_inv_1
X_155_ _162_/B _254_/Q _166_/B VDD GND sg13g2_xnor2_1
XFILLER_6_166 VDD GND sg13g2_fill_1
XFILLER_3_114 VDD GND sg13g2_fill_1
X_207_ _208_/B _258_/Q _198_/B _206_/Y VDD GND sg13g2_a21oi_1
X_138_ _144_/A _173_/B _251_/Q VDD GND sg13g2_nor2_1
XFILLER_0_106 VDD GND sg13g2_decap_8
XFILLER_20_91 VDD GND sg13g2_fill_2
XFILLER_14_127 VDD GND sg13g2_decap_8
X_240_ _240_/Y _241_/A VDD GND sg13g2_inv_1
X_171_ _183_/A _171_/A _170_/Y VDD GND sg13g2_nor2b_1
X_223_ _223_/Y _232_/A VDD GND sg13g2_inv_1
XFILLER_8_39 VDD GND sg13g2_fill_1
XFILLER_12_70 VDD GND sg13g2_decap_8
X_154_ _166_/B _245_/Q _173_/B VDD GND sg13g2_xor2_1
XFILLER_6_145 VDD GND sg13g2_decap_8
X_206_ _206_/Y _259_/Q _249_/Q VDD GND sg13g2_nor2b_1
X_137_ _143_/A _210_/B _242_/Q VDD GND sg13g2_nand2b_1
XFILLER_9_93 VDD GND sg13g2_decap_8
XFILLER_15_0 VDD GND sg13g2_decap_8
XFILLER_14_49 VDD GND sg13g2_fill_1
XFILLER_20_70 VDD GND sg13g2_decap_8
XFILLER_6_61 VDD GND sg13g2_decap_8
XFILLER_17_158 VDD GND sg13g2_decap_8
X_170_ _170_/Y _170_/A _170_/B _170_/C VDD GND sg13g2_nand3_1
XFILLER_9_121 VDD GND sg13g2_decap_8
XFILLER_3_84 VDD GND sg13g2_decap_8
XFILLER_11_109 VDD GND sg13g2_decap_8
X_222_ _222_/Y _232_/A VDD GND sg13g2_inv_1
X_153_ _162_/A _253_/Q _149_/B _152_/X VDD GND sg13g2_a21oi_1
XFILLER_6_157 VDD GND sg13g2_decap_8
XFILLER_6_113 VDD GND sg13g2_fill_1
X_205_ _209_/A _193_/A _200_/Y _204_/X _194_/A _201_/A VDD GND sg13g2_a221oi_1
X_136_ _210_/B _173_/B _251_/Q VDD GND sg13g2_xor2_1
XFILLER_0_63 VDD GND sg13g2_decap_8
XFILLER_0_74 VDD GND sg13g2_fill_1
XFILLER_0_85 VDD GND sg13g2_decap_8
X_119_ _248_/D _248_/Q _247_/Q _125_/S VDD GND sg13g2_mux2_1
XFILLER_6_84 VDD GND sg13g2_fill_1
XFILLER_6_40 VDD GND sg13g2_decap_8
XFILLER_17_104 VDD GND sg13g2_fill_1
XFILLER_14_107 VDD GND sg13g2_decap_8
XFILLER_9_166 VDD GND sg13g2_fill_1
XFILLER_9_100 VDD GND sg13g2_decap_8
XFILLER_3_63 VDD GND sg13g2_decap_4
XFILLER_10_154 VDD GND sg13g2_decap_8
XFILLER_10_165 VDD GND sg13g2_fill_2
X_221_ _221_/Y _224_/A VDD GND sg13g2_inv_1
X_152_ _152_/X _244_/Q _195_/B VDD GND sg13g2_and2_1
XFILLER_5_0 VDD GND sg13g2_decap_8
XFILLER_19_8 VDD GND sg13g2_fill_1
XFILLER_17_39 VDD GND sg13g2_fill_1
X_204_ _204_/X _204_/A _204_/B VDD GND sg13g2_and2_1
XFILLER_0_42 VDD GND sg13g2_decap_8
X_135_ _264_/D _266_/D _135_/B VDD GND sg13g2_and2_1
XFILLER_9_40 VDD GND sg13g2_decap_8
X_118_ _249_/D _249_/Q _248_/Q _125_/S VDD GND sg13g2_mux2_1
XFILLER_6_96 VDD GND sg13g2_fill_2
XFILLER_20_0 VDD GND sg13g2_decap_8
Xclkbuf_1_1__f_sclk _250_/CLK clkbuf_0_sclk/X VDD GND sg13g2_buf_16
XFILLER_9_7 VDD GND sg13g2_fill_2
XFILLER_15_83 VDD GND sg13g2_decap_8
XFILLER_11_19 VDD GND sg13g2_decap_8
XFILLER_13_163 VDD GND sg13g2_decap_4
XFILLER_9_145 VDD GND sg13g2_decap_8
XFILLER_3_53 VDD GND sg13g2_decap_4
X_220_ _220_/Y _224_/A VDD GND sg13g2_inv_1
X_151_ _253_/D _151_/A _160_/A VDD GND sg13g2_xor2_1
XFILLER_3_107 VDD GND sg13g2_decap_8
XFILLER_0_21 VDD GND sg13g2_decap_8
X_203_ _258_/D _204_/B _203_/B VDD GND sg13g2_xnor2_1
X_134_ _135_/B _195_/B _127_/Y _133_/Y VDD GND sg13g2_o21ai_1
XFILLER_2_162 VDD GND sg13g2_fill_1
XFILLER_2_151 VDD GND sg13g2_decap_8
XFILLER_2_140 VDD GND sg13g2_fill_1
X_117_ _250_/D _250_/Q _249_/Q _125_/S VDD GND sg13g2_mux2_1
XFILLER_18_50 VDD GND sg13g2_decap_4
XFILLER_20_84 VDD GND sg13g2_decap_8
XFILLER_17_117 VDD GND sg13g2_fill_1
Xoutput4 freq_out _213_/A VDD GND sg13g2_buf_1
XFILLER_16_161 VDD GND sg13g2_decap_4
XFILLER_13_142 VDD GND sg13g2_decap_8
XFILLER_9_135 VDD GND sg13g2_decap_8
XFILLER_3_98 VDD GND sg13g2_fill_1
XFILLER_10_123 VDD GND sg13g2_decap_8
XFILLER_10_134 VDD GND sg13g2_decap_4
XFILLER_12_63 VDD GND sg13g2_decap_8
X_150_ _160_/A _157_/A _157_/B VDD GND sg13g2_xor2_1
XFILLER_6_138 VDD GND sg13g2_decap_8
X_202_ _203_/B _194_/A _204_/A _193_/A VDD GND sg13g2_a21oi_1
X_133_ _133_/Y _261_/Q _266_/Q _133_/C VDD GND sg13g2_nor3_1
XFILLER_0_99 VDD GND sg13g2_decap_8
XFILLER_9_86 VDD GND sg13g2_decap_8
Xfanout5 _173_/B _195_/B VDD GND sg13g2_buf_1
XFILLER_6_54 VDD GND sg13g2_decap_8
XFILLER_20_63 VDD GND sg13g2_decap_8
XFILLER_15_63 VDD GND sg13g2_fill_1
XFILLER_9_114 VDD GND sg13g2_decap_8
XFILLER_10_102 VDD GND sg13g2_decap_8
XFILLER_6_106 VDD GND sg13g2_decap_8
XFILLER_12_53 VDD GND sg13g2_fill_1
XFILLER_5_150 VDD GND sg13g2_decap_8
X_201_ _204_/B _201_/A _200_/Y VDD GND sg13g2_nor2b_1
X_132_ _133_/C _263_/Q _262_/Q VDD GND sg13g2_nor2_1
XFILLER_3_0 VDD GND sg13g2_decap_8
XFILLER_0_56 VDD GND sg13g2_decap_8
XFILLER_0_78 VDD GND sg13g2_decap_8
Xfanout6 _195_/B _259_/Q VDD GND sg13g2_buf_1
XFILLER_20_97 VDD GND sg13g2_decap_8
XFILLER_20_42 VDD GND sg13g2_decap_8
XFILLER_6_77 VDD GND sg13g2_decap_8
XFILLER_6_33 VDD GND sg13g2_decap_8
XFILLER_15_42 VDD GND sg13g2_decap_8
XFILLER_15_97 VDD GND sg13g2_decap_8
XFILLER_17_108 VDD GND sg13g2_decap_4
.ends

**** end user architecture code
XC1 VDD VSS cap_cmim w=20.0e-6 l=20.0e-6 m=40 mm_ok=1
.ends

* expanding   symbol:  xschem/phase-freq-detector/PHASE_FREQ_DET.sym # of pins=6
** sym_path: /foss/designs/unicasss-tools/SG13G2_2.4GHz_LC_VCO_FPLL/xschem/phase-freq-detector/PHASE_FREQ_DET.sym
** sch_path: /foss/designs/unicasss-tools/SG13G2_2.4GHz_LC_VCO_FPLL/xschem/phase-freq-detector/PHASE_FREQ_DET.sch
.subckt PHASE_FREQ_DET FREF UP VDD GND FDIV DN
*.opin UP
*.ipin FREF
*.iopin VDD
*.iopin GND
*.opin DN
*.ipin FDIV
* noconn #net2
x1 net1 UP FREF VDD nRST VDD GND sg13g2_dfrbp_2
x2 DN net2 FDIV VDD nRST VDD GND sg13g2_dfrbp_2
x3 nRST net1 DN VDD GND sg13g2_nand2_2
.ends

* expanding   symbol:  xschem/charge-pump/CHARGE_PUMP.sym # of pins=7
** sym_path: /foss/designs/unicasss-tools/SG13G2_2.4GHz_LC_VCO_FPLL/xschem/charge-pump/CHARGE_PUMP.sym
** sch_path: /foss/designs/unicasss-tools/SG13G2_2.4GHz_LC_VCO_FPLL/xschem/charge-pump/CHARGE_PUMP.sch
.subckt CHARGE_PUMP UP VDD VCP VBGR GND DN SUB!
*.opin VCP
*.ipin UP
*.ipin DN
*.iopin GND
*.iopin VBGR
*.iopin VDD
*.iopin SUB!
XM2 Vbn Vbn net5 SUB! sg13_lv_nmos w=40.7u l=2u ng=5 m=1 mm_ok=1
XM8 net2 GND VDD NW sg13_lv_pmos w=29.6u l=2u ng=5 m=1 mm_ok=1
XM11 Vbp Vbp net2 NW sg13_lv_pmos w=163.6u l=2u ng=20 m=1 mm_ok=1
XM3 Vbn Vbp net1 NW sg13_lv_pmos w=163.6u l=2u ng=20 m=1 mm_ok=1
XM4 net1 GND VDD NW sg13_lv_pmos w=29.6u l=2u ng=5 m=1 mm_ok=1
XM7 net3 UP VDD NW sg13_lv_pmos w=29.6u l=2u ng=5 m=1 mm_ok=1
XM9 VCP Vbp net3 NW sg13_lv_pmos w=163.6u l=2u ng=20 m=1 mm_ok=1
XM10 net5 VDD GND SUB! sg13_lv_nmos w=6u l=2u ng=1 m=1 mm_ok=1
XM1 net4 DN GND SUB! sg13_lv_nmos w=6u l=2u ng=1 m=1 mm_ok=1
XM5 VCP Vbn net4 SUB! sg13_lv_nmos w=40.7u l=2u ng=5 m=1 mm_ok=1
XM6 Vbp VBGR GND SUB! sg13_lv_nmos w=3.9u l=2u ng=1 m=1 mm_ok=1
XR1 VDD NW ntap1 R=1.319 w=51e-6 l=36e-6 rw=0.3e-6
XR2 VDD NW ntap1 R=2.51 w=30.5e-6 l=15.5e-6 rw=0.3e-6
XR3 GND SUB! ptap1 R=9.234 w=5.68e-6 l=7.26e-6 rw=0.3e-6
XR4 GND SUB! ptap1 R=2.717 w=30e-6 l=12.54e-6 rw=0.3e-6
XR5 GND SUB! ptap1 R=4.486 w=20e-6 l=6e-6 rw=0.3e-6
.ends

* expanding   symbol:  xschem/loop-filter/LOOP_FILTER.sym # of pins=4
** sym_path: /foss/designs/unicasss-tools/SG13G2_2.4GHz_LC_VCO_FPLL/xschem/loop-filter/LOOP_FILTER.sym
** sch_path: /foss/designs/unicasss-tools/SG13G2_2.4GHz_LC_VCO_FPLL/xschem/loop-filter/LOOP_FILTER.sch
.subckt LOOP_FILTER OUT IN GND SUB!
*.opin OUT
*.iopin GND
*.ipin IN
*.iopin SUB!
XC2 OUT GND cap_cmim w=18.63e-6 l=18.63e-6 m=4 mm_ok=1
XC1 net1 GND cap_cmim w=48.34e-6 l=48.34e-6 m=16 mm_ok=1
XR2 OUT IN SUB! rppd w=2e-6 l=407.2e-6 m=1 b=0 mm_ok=1
XR1 net1 IN SUB! rppd w=2e-6 l=407.2e-6 m=1 b=0 mm_ok=1
XR3 GND SUB! ptap1 R=1.462 w=46.34e-6 l=32.18e-6 rw=0.3e-6
XR4 GND SUB! ptap1 R=1.462 w=46.34e-6 l=32.18e-6 rw=0.3e-6
.ends

* expanding   symbol:  xschem/lc-vco/LC_VCO.sym # of pins=6
** sym_path: /foss/designs/unicasss-tools/SG13G2_2.4GHz_LC_VCO_FPLL/xschem/lc-vco/LC_VCO.sym
** sch_path: /foss/designs/unicasss-tools/SG13G2_2.4GHz_LC_VCO_FPLL/xschem/lc-vco/LC_VCO.sch
.subckt LC_VCO VDD VCTRL GND FOUT VBGR SUB!
*.opin FOUT
*.ipin VCTRL
*.ipin VBGR
*.iopin VDD
*.iopin GND
*.iopin SUB!
x1 OUTn OUTp 4nH_INDUCTOR
XM5 Vx Vgs GND SUB! sg13_lv_nmos w=384u l=1u ng=48 m=1 mm_ok=1
XM4 OUTp OUTn VDD NW sg13_lv_pmos w=36u l=0.13u ng=5 m=1 mm_ok=1
XM3 OUTn OUTp VDD NW sg13_lv_pmos w=36u l=0.13u ng=5 m=1 mm_ok=1
XM2 OUTp OUTn Vx SUB! sg13_lv_nmos w=21.99u l=0.13u ng=3 m=1 mm_ok=1
XM1 OUTn OUTp Vx SUB! sg13_lv_nmos w=21.99u l=0.13u ng=3 m=1 mm_ok=1
XM6 Vgs Vgs GND SUB! sg13_lv_nmos w=64u l=1u ng=8 m=1 mm_ok=1
XC1 OUTn OUTp SUB! cap_rfcmim w=21.9e-6 l=21.9e-6 wfeed=10.0e-6 m=1 mm_ok=1
XC3 OUTp VCTRL OUTn sub! sg13_hv_svaricap w=9.74u l=0.8u Nx=7 mm_ok=1
XC2 OUTp VCTRL OUTn sub! sg13_hv_svaricap w=9.74u l=0.8u Nx=7 mm_ok=1
XM7 Vgs VBGR VDD NWa sg13_lv_pmos w=38u l=1u ng=5 m=1 mm_ok=1
XM8 FOUT OUTp VDD NW sg13_lv_pmos w=15u l=0.13u ng=10 m=1 mm_ok=1
XM9 FOUT OUTp GND SUB! sg13_lv_nmos w=1.5u l=0.13u ng=1 m=1 mm_ok=1
XM10 net1 OUTn VDD NW sg13_lv_pmos w=15u l=0.13u ng=10 m=1 mm_ok=1
XM11 net1 OUTn GND SUB! sg13_lv_nmos w=1.5u l=0.13u ng=1 m=1 mm_ok=1
XR1 VDD NW ntap1 R=7.357 w=10.22e-6 l=5.87e-6 rw=0.3e-6
XR2 VDD NW ntap1 R=7.357 w=10.22e-6 l=5.87e-6 rw=0.3e-6
XR3 GND SUB! ptap1 R=2.388 w=33.9e-6 l=14.41e-6 rw=0.3e-6
XR4 GND SUB! ptap1 R=8.306 w=10.09e-6 l=4.23e-6 rw=0.3e-6
XR5 GND SUB! ptap1 R=8.306 w=10.09e-6 l=4.23e-6 rw=0.3e-6
XR6 VDD NW ntap1 R=9.234 w=8.42e-6 l=4.52e-6 rw=0.3e-6
XR7 VDD NW ntap1 R=9.234 w=8.42e-6 l=4.52e-6 rw=0.3e-6
XR8 GND SUB! ptap1 R=16.59 w=3.21e-6 l=4.26e-6 rw=0.3e-6
XR9 GND SUB! ptap1 R=16.59 w=3.21e-6 l=4.26e-6 rw=0.3e-6
XR10 GND SUB! ptap1 R=4.768 w=10.76e-6 l=13.74e-6 rw=0.3e-6
XR11 GND SUB! ptap1 R=1.636 w=12.36e-6 l=57.9e-6 rw=0.3e-6
XR12 VDD NWa ntap1 R=5.63 w=10.62e-6 l=10.22e-6 rw=0.3e-6
.ends

* expanding   symbol:  xschem/bgr/BANDGAP_REF.sym # of pins=4
** sym_path: /foss/designs/unicasss-tools/SG13G2_2.4GHz_LC_VCO_FPLL/xschem/bgr/BANDGAP_REF.sym
** sch_path: /foss/designs/unicasss-tools/SG13G2_2.4GHz_LC_VCO_FPLL/xschem/bgr/BANDGAP_REF.sch
.subckt BANDGAP_REF VDD GND VBGR SUB!
*.opin VBGR
*.iopin GND
*.iopin VDD
*.iopin SUB!
XM8 GND v- net1 SUB! sg13_lv_nmos w=150n l=10u ng=1 m=1 mm_ok=1
XM6 net1 net1 VDD bulk6 sg13_lv_pmos w=1u l=1u ng=1 m=1 mm_ok=1
XM7 net2 net1 VDD bulk6 sg13_lv_pmos w=1u l=1u ng=1 m=1 mm_ok=1
XM9 v- net2 VDD bulk5 sg13_lv_pmos w=200n l=4u ng=1 m=1 mm_ok=1
XM1 v- v+ GND SUB! sg13_lv_nmos w=7.14u l=5u ng=4 m=1 mm_ok=1
XM2 net3 net3 GND SUB! sg13_lv_nmos w=21u l=5u ng=8 m=1 mm_ok=1
XM3 v- Vo1 VDD bulk7 sg13_lv_pmos w=15u l=5u ng=8 m=1 mm_ok=1
XM4 v+ Vo1 VDD bulk7 sg13_lv_pmos w=15u l=5u ng=8 m=1 mm_ok=1
XM5 VBGR Vo1 VDD bulk7 sg13_lv_pmos w=16u l=5u ng=8 m=1 mm_ok=1
XR2 VBGR net11 sub! rppd w=0.710e-6 l=38.65e-6 m=1 b=0 mm_ok=1
XC1 net2 GND cap_cmim w=18.2e-6 l=18.2e-6 m=1 mm_ok=1
XM10 dn3 v- dn2 bulk sg13_lv_pmos w=3.64u l=3.7u ng=1 m=2 mm_ok=1
XM11 dn4 v+ dn2 bulk sg13_lv_pmos w=3.64u l=3.7u ng=1 m=2 mm_ok=1
XM12 dn4 VDD VDD bulk sg13_lv_pmos w=3.64u l=3.7u ng=1 m=2 mm_ok=1
XM13 dn3 VDD VDD bulk sg13_lv_pmos w=3.64u l=3.7u ng=1 m=2 mm_ok=1
XM15 dn2 VDD VDD bulk sg13_lv_pmos w=3.64u l=3.7u ng=1 m=2 mm_ok=1
XM16 dn2 VDD VDD bulk sg13_lv_pmos w=3.64u l=3.7u ng=1 m=2 mm_ok=1
XR4 VDD bulk ntap1 R=2.445 w=33.53e-6 l=13.15e-6 rw=0.36e-6
XM14 dn2 iout VDD bulk1 sg13_lv_pmos w=5.3u l=1.95u ng=1 m=1 mm_ok=1
XR5 GND SUB! ptap1 R=6.689 w=12.57e-6 l=4.39e-6 rw=0.72e-6
XR6 VDD bulk1 ntap1 R=7.319 w=6.765e-6 l=8.86e-6 rw=0.72e-6
XM17 GND dn3 dn3 SUB! sg13_lv_nmos w=720n l=9.75u ng=1 m=1 mm_ok=1
XM18 GND dn3 dn4 SUB! sg13_lv_nmos w=720n l=9.75u ng=1 m=1 mm_ok=1
XM19 Vo1 iout VDD bulk4 sg13_lv_pmos w=75u l=2.08u ng=8 m=1 mm_ok=1
XM20 GND dn4 Vo1 SUB! sg13_lv_nmos w=28.8u l=9.75u ng=4 m=1 mm_ok=1
XM21 iout iout VDD bulk4 sg13_lv_pmos w=75u l=2.08u ng=8 m=1 mm_ok=1
XC2 dn4 Vo1 cap_cmim w=22.29e-6 l=22.29e-6 m=1 mm_ok=1
XR8 VDD bulk4 ntap1 R=2.291 w=23.54e-6 l=23.22e-6 rw=0.72e-6
XR9 VDD bulk6 ntap1 R=7.123 w=5.76e-6 l=10.255e-6 rw=0.72e-6
XR12 v+ net7 sub! rppd w=0.5e-6 l=38.65e-6 m=1 b=0 mm_ok=1
XR3 net7 net6 sub! rppd w=0.5e-6 l=38.65e-6 m=1 b=0 mm_ok=1
XR13 net6 net5 sub! rppd w=0.5e-6 l=38.65e-6 m=1 b=0 mm_ok=1
XR14 net5 net4 sub! rppd w=0.5e-6 l=38.65e-6 m=1 b=0 mm_ok=1
XR15 net4 net3 sub! rppd w=0.5e-6 l=38.65e-6 m=1 b=0 mm_ok=1
XR16 net10 net9 sub! rppd w=0.5e-6 l=38.65e-6 m=1 b=0 mm_ok=1
XR17 net9 net8 sub! rppd w=0.5e-6 l=38.65e-6 m=1 b=0 mm_ok=1
XR18 net8 net17 sub! rppd w=0.5e-6 l=38.65e-6 m=1 b=0 mm_ok=1
XR19 net17 GND sub! rppd w=3e-6 l=38.65e-6 m=1 b=0 mm_ok=1
XR20 net11 net12 sub! rppd w=0.710e-6 l=38.65e-6 m=1 b=0 mm_ok=1
XR21 net12 net13 sub! rppd w=0.710e-6 l=38.65e-6 m=1 b=0 mm_ok=1
XR22 net13 net14 sub! rppd w=0.710e-6 l=38.65e-6 m=1 b=0 mm_ok=1
XR23 net14 net15 sub! rppd w=0.710e-6 l=38.65e-6 m=1 b=0 mm_ok=1
XR24 net15 net16 sub! rppd w=0.710e-6 l=38.65e-6 m=1 b=0 mm_ok=1
XR25 net16 GND sub! rppd w=0.710e-6 l=38.65e-6 m=1 b=0 mm_ok=1
XR26 VDD bulk5 ntap1 R=11.59 w=7.37e-6 l=3.03e-6 rw=0.72e-6
XR27 VDD bulk7 ntap1 R=1.868 w=46.185e-6 l=10.815e-6 rw=0.72e-6
XR7 GND SUB! ptap1 R=7.306 w=2.73e-6 l=12.92e-6 rw=0.72e-6
XR10 GND SUB! ptap1 R=2.076 w=46.215e-6 l=5.225e-6 rw=0.72e-6
XR11 GND SUB! ptap1 R=3.763 w=4.985e-6 l=24.045e-6 rw=0.72e-6
XR28 GND SUB! ptap1 R=2.219 w=9.24e-6 l=42.505e-6 rw=0.32e-6
XC3 VDD GND cap_cmim w=5e-6 l=5e-6 m=15 mm_ok=1
XR31 v+ net10 sub! rppd w=0.5e-6 l=38.65e-6 m=1 b=0 mm_ok=1
XR1 iout GND sub! rppd w=0.5e-6 l=15e-6 m=1 b=0 mm_ok=1
.ends

.GLOBAL GND
.GLOBAL VDD
.GLOBAL VBGR
.GLOBAL VSS
.end
