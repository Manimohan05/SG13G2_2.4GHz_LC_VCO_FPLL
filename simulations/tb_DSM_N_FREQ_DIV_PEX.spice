** sch_path: /foss/designs/unicasss-tools/frac-n-pll-vco-unic_cass/xschem/dsm/xschem/tb_DSM_N_FREQ_DIV_PEX.sch
**.subckt tb_DSM_N_FREQ_DIV_PEX
V1 freq_in GND PULSE(0 1.8 0 10ns 10ns 50ns 100ns)
* noconn rst
* noconn sclk
* noconn sdata
* noconn en
V2 VDD GND PULSE(0 1.2 0 1u 0 1s 2s)
x1 freq_in rst sclk sdata en freq_out VDD GND DSM_N_FREQ_DIV
**** begin user architecture code

* ngspice commands
.save v(dout) v(sdata) v(sclk) v(en) v(rst) v(dsm_clk) v(freq_in) v(freq_out)
.control
  tran 0.5n 1m
  remzerovec
  write tb_DSM_N_FREQ_DIV_PEX.raw
.endc

* to generate following file copy stimuli.test
* to the simulation directory and run simulation -> Utile Stimuli Editor (GUI),
* and press 'Translate'
.include stimuli_test.cir

.include /foss/designs/unicasss-tools/frac-n-pll-vco-unic_cass/pex/DSM_N_FREQ_DIV__DSM_N_FREQ_DIV/magic_RC/DSM_N_FREQ_DIV.pex.spice
.lib cornerMOSlv.lib mos_tt
.lib cornerMOShv.lib mos_tt
.lib cornerRES.lib res_typ
.lib cornerCAP.lib cap_typ

**** end user architecture code
**.ends
.GLOBAL GND
.GLOBAL VDD
.end
