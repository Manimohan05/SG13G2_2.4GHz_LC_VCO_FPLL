** sch_path: /foss/designs/unicasss-tools/SG13G2_2.4GHz_LC_VCO_FPLL/xschem/bgr/tb_BGR_PEX.sch
**.subckt tb_BGR_PEX VBGR
*.opin VBGR
V1 VDD GND PULSE(0 1.2 0 10m 0 1 2)
x1 VDD GND VBGR BANDGAP_REF_PEX
**** begin user architecture code

.option rshunt=1.0e12
.control
save all
save VDD
alter V1 dc 1.2

op
print I(Vmeas)
print v(VBGR)
print -i(V1)

dc TEMP 100 -50 -5
print I(Vmeas)
print v(VBGR)

write tb_BGR_PEX_temp.raw
.endc

.control
save all
tran 100u 15m

print I(Vmeas)
meas tran vb_end find v(VBGR) at=15m
meas tran vb_max max v(VBGR) from=5m to=15m
meas tran vb_min min v(VBGR) from=5m to=15m
* supply current (negative = drawn from the source), power = 1.2 V x |idd|
meas tran idd avg i(V1) from=13m to=15m

write tb_BGR_PEX_transient.raw
.endc

.include /foss/designs/unicasss-tools/SG13G2_2.4GHz_LC_VCO_FPLL/pex/BANDGAP_REF__BANDGAP_REF/magic_RC/BANDGAP_REF.pex.spice
.lib cornerMOSlv.lib mos_tt
.lib cornerMOShv.lib mos_tt
.lib cornerRES.lib res_typ
.lib cornerCAP.lib cap_typ

**** end user architecture code
**.ends
.GLOBAL GND
.end
