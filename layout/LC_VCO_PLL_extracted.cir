* Extracted by KLayout with SG13G2 LVS runset on : 22/03/2026 14:27

.SUBCKT LC_VCO_PLL 1 2 3 4 9 10 12 15 18 21 23 24 29 30 31 32 33 41 60 61 68 74
+ 81 82 84 85 96 97 98 102 104 105 109 118 132 148 151 162 165 166 167 168 201
+ 202 210 212 213 215 217 218 220 222 223 227 229 232 246 247 257 258 260 265
+ 267 268 270 272 274 275 278 289 290 291 292 320 327 328 335 345 346 347 348
+ 349 354 394 395 396 397 399 400 414 415 416 417 418 419 422 423 424 431 432
+ 434 437 439 440 457 458 459 460 461 462 463 489 491 492 524 525 527 529 550
+ 551 560 563 565 566 570 571 574 575 594 595 597 598 606 609 629 632 634 635
+ 636 637 638 639 646 648 650 651 653 671 681 682 683 684 685 686 687 694 696
+ 697 700 713 717 718 719 723 724 725 729 730 769 774 775 782 819 860 862 863
+ 870 872 877 879 888 890 891 894 903 904 906 909 912
M$1 1 4 2 1 sg13_lv_nmos L=0.13u W=0.74u AS=0.2516p AD=0.2516p PS=2.16u PD=2.16u
M$2 1 3 1 1 sg13_lv_nmos L=1u W=217.14u AS=58.8966p AD=58.8966p PS=615.2u
+ PD=615.2u
M$50 5 26 7 1 sg13_lv_nmos L=0.13u W=0.42u AS=0.1296p AD=0.0798p PS=1.52u
+ PD=0.8u
M$51 7 25 42 1 sg13_lv_nmos L=0.13u W=0.42u AS=0.0798p AD=0.2373p PS=0.8u
+ PD=1.97u
M$52 25 26 1 1 sg13_lv_nmos L=0.13u W=0.74u AS=0.2516p AD=0.317325p PS=2.16u
+ PD=1.805u
M$53 1 210 26 1 sg13_lv_nmos L=0.13u W=0.74u AS=0.317325p AD=0.2516p PS=1.805u
+ PD=2.16u
M$54 43 26 27 1 sg13_lv_nmos L=0.13u W=0.42u AS=0.1428p AD=0.12665p PS=1.52u
+ PD=1.145u
M$55 27 25 6 1 sg13_lv_nmos L=0.13u W=0.74u AS=0.12665p AD=0.3473p PS=1.145u
+ PD=2.71u
M$56 8 27 1 1 sg13_lv_nmos L=0.13u W=0.74u AS=0.2516p AD=0.1406p PS=2.16u
+ PD=1.12u
M$57 1 8 9 1 sg13_lv_nmos L=0.13u W=0.74u AS=0.1406p AD=0.2516p PS=1.12u
+ PD=2.16u
M$60 10 11 44 1 sg13_lv_nmos L=0.13u W=0.74u AS=0.2516p AD=0.1406p PS=2.16u
+ PD=1.12u
M$61 44 12 1 1 sg13_lv_nmos L=0.13u W=0.74u AS=0.1406p AD=0.1898p PS=1.12u
+ PD=1.36u
M$62 1 68 44 1 sg13_lv_nmos L=0.13u W=0.74u AS=0.1898p AD=0.2516p PS=1.36u
+ PD=2.16u
M$63 11 12 48 1 sg13_lv_nmos L=0.13u W=0.64u AS=0.2176p AD=0.0784p PS=1.96u
+ PD=0.885u
M$64 48 68 1 1 sg13_lv_nmos L=0.13u W=0.64u AS=0.0784p AD=0.2272p PS=0.885u
+ PD=1.99u
M$65 1 29 14 1 sg13_lv_nmos L=0.13u W=0.55u AS=0.15245p AD=0.174625p PS=1.17u
+ PD=1.185u
M$66 14 30 1 1 sg13_lv_nmos L=0.13u W=0.55u AS=0.174625p AD=0.374p PS=1.185u
+ PD=2.46u
M$67 1 14 12 1 sg13_lv_nmos L=0.13u W=0.74u AS=0.3108p AD=0.1628p PS=2.32u
+ PD=1.18u
M$68 12 29 49 1 sg13_lv_nmos L=0.13u W=0.74u AS=0.1628p AD=0.0888p PS=1.18u
+ PD=0.98u
M$69 49 30 1 1 sg13_lv_nmos L=0.13u W=0.74u AS=0.0888p AD=0.15245p PS=0.98u
+ PD=1.17u
M$70 1 30 15 1 sg13_lv_nmos L=0.13u W=0.74u AS=0.2516p AD=0.1406p PS=2.16u
+ PD=1.12u
M$71 15 29 1 1 sg13_lv_nmos L=0.13u W=0.74u AS=0.1406p AD=0.2516p PS=1.12u
+ PD=2.16u
M$72 1 165 50 1 sg13_lv_nmos L=0.13u W=0.74u AS=0.2516p AD=0.09435p PS=2.16u
+ PD=0.995u
M$73 50 2 17 1 sg13_lv_nmos L=0.13u W=0.74u AS=0.09435p AD=0.1406p PS=0.995u
+ PD=1.12u
M$74 17 31 1 1 sg13_lv_nmos L=0.13u W=0.74u AS=0.1406p AD=0.3811p PS=1.12u
+ PD=2.51u
M$75 1 17 18 1 sg13_lv_nmos L=0.13u W=1.48u AS=0.3922p AD=0.3922p PS=3.28u
+ PD=3.28u
M$77 1 15 31 1 sg13_lv_nmos L=0.13u W=0.74u AS=0.2516p AD=0.1406p PS=2.16u
+ PD=1.12u
M$78 31 166 1 1 sg13_lv_nmos L=0.13u W=0.74u AS=0.1406p AD=0.2516p PS=1.12u
+ PD=2.16u
M$81 1 9 19 1 sg13_lv_nmos L=0.13u W=0.55u AS=0.374p AD=0.174625p PS=2.46u
+ PD=1.185u
M$82 19 30 1 1 sg13_lv_nmos L=0.13u W=0.55u AS=0.174625p AD=0.15245p PS=1.185u
+ PD=1.17u
M$83 1 9 51 1 sg13_lv_nmos L=0.13u W=0.74u AS=0.15245p AD=0.0888p PS=1.17u
+ PD=0.98u
M$84 51 30 21 1 sg13_lv_nmos L=0.13u W=0.74u AS=0.0888p AD=0.1628p PS=0.98u
+ PD=1.18u
M$85 21 19 1 1 sg13_lv_nmos L=0.13u W=0.74u AS=0.1628p AD=0.3108p PS=1.18u
+ PD=2.32u
M$86 1 21 52 1 sg13_lv_nmos L=0.13u W=0.74u AS=0.2516p AD=0.1406p PS=2.16u
+ PD=1.12u
M$87 52 32 23 1 sg13_lv_nmos L=0.13u W=0.74u AS=0.1406p AD=0.1406p PS=1.12u
+ PD=1.12u
M$88 23 33 1 1 sg13_lv_nmos L=0.13u W=0.74u AS=0.1406p AD=0.2516p PS=1.12u
+ PD=2.16u
M$105 1 96 24 1 sg13_lv_nmos L=0.13u W=0.74u AS=0.2516p AD=0.2516p PS=2.16u
+ PD=2.16u
M$106 1 96 61 1 sg13_lv_nmos L=0.13u W=0.74u AS=0.2516p AD=0.2516p PS=2.16u
+ PD=2.16u
M$108 1 97 62 1 sg13_lv_nmos L=0.13u W=0.55u AS=0.18945p AD=0.187p PS=1.27u
+ PD=1.78u
M$109 1 97 110 1 sg13_lv_nmos L=0.13u W=0.74u AS=0.18945p AD=0.13135p PS=1.27u
+ PD=1.095u
M$110 110 68 53 1 sg13_lv_nmos L=0.13u W=0.74u AS=0.13135p AD=0.1628p PS=1.095u
+ PD=1.18u
M$111 53 9 111 1 sg13_lv_nmos L=0.13u W=0.74u AS=0.1628p AD=0.3367p PS=1.18u
+ PD=1.65u
M$112 111 62 1 1 sg13_lv_nmos L=0.13u W=0.74u AS=0.3367p AD=0.148p PS=1.65u
+ PD=1.14u
M$113 1 53 41 1 sg13_lv_nmos L=0.13u W=0.74u AS=0.148p AD=0.4033p PS=1.14u
+ PD=2.57u
M$114 1 7 6 1 sg13_lv_nmos L=0.13u W=0.74u AS=0.1626p AD=0.2516p PS=1.415u
+ PD=2.16u
M$115 5 41 45 1 sg13_lv_nmos L=0.13u W=0.42u AS=0.1428p AD=0.0609p PS=1.52u
+ PD=0.71u
M$116 1 24 45 1 sg13_lv_nmos L=0.13u W=0.42u AS=0.1626p AD=0.0609p PS=1.415u
+ PD=0.71u
M$117 1 24 46 1 sg13_lv_nmos L=0.13u W=0.42u AS=0.1701p AD=0.0378p PS=1.65u
+ PD=0.6u
M$118 46 6 42 1 sg13_lv_nmos L=0.13u W=0.42u AS=0.0378p AD=0.1428p PS=0.6u
+ PD=1.52u
M$119 63 98 87 1 sg13_lv_nmos L=0.13u W=0.42u AS=0.1428p AD=0.0609p PS=1.52u
+ PD=0.71u
M$120 87 61 1 1 sg13_lv_nmos L=0.13u W=0.42u AS=0.0609p AD=0.1626p PS=0.71u
+ PD=1.415u
M$121 1 99 54 1 sg13_lv_nmos L=0.13u W=0.74u AS=0.1626p AD=0.2516p PS=1.415u
+ PD=2.16u
M$122 1 61 88 1 sg13_lv_nmos L=0.13u W=0.42u AS=0.1701p AD=0.0378p PS=1.65u
+ PD=0.6u
M$123 88 54 64 1 sg13_lv_nmos L=0.13u W=0.42u AS=0.0378p AD=0.1428p PS=0.6u
+ PD=1.52u
M$124 43 28 1 1 sg13_lv_nmos L=0.13u W=0.42u AS=0.1428p AD=0.0798p PS=1.52u
+ PD=0.8u
M$125 1 24 47 1 sg13_lv_nmos L=0.13u W=0.42u AS=0.0798p AD=0.0378p PS=0.8u
+ PD=0.6u
M$126 47 27 28 1 sg13_lv_nmos L=0.13u W=0.42u AS=0.0378p AD=0.1428p PS=0.6u
+ PD=1.52u
M$127 100 55 65 1 sg13_lv_nmos L=0.13u W=0.42u AS=0.12665p AD=0.1428p PS=1.145u
+ PD=1.52u
M$128 54 115 100 1 sg13_lv_nmos L=0.13u W=0.74u AS=0.3473p AD=0.12665p PS=2.71u
+ PD=1.145u
M$129 65 66 1 1 sg13_lv_nmos L=0.13u W=0.42u AS=0.1428p AD=0.0798p PS=1.52u
+ PD=0.8u
M$130 1 61 91 1 sg13_lv_nmos L=0.13u W=0.42u AS=0.0798p AD=0.0378p PS=0.8u
+ PD=0.6u
M$131 91 100 66 1 sg13_lv_nmos L=0.13u W=0.42u AS=0.0378p AD=0.1428p PS=0.6u
+ PD=1.52u
M$132 67 100 1 1 sg13_lv_nmos L=0.13u W=0.74u AS=0.2516p AD=0.1406p PS=2.16u
+ PD=1.12u
M$133 1 67 68 1 sg13_lv_nmos L=0.13u W=0.74u AS=0.1406p AD=0.2516p PS=1.12u
+ PD=2.16u
M$135 1 96 102 1 sg13_lv_nmos L=0.13u W=0.74u AS=0.2516p AD=0.2516p PS=2.16u
+ PD=2.16u
M$136 69 10 94 1 sg13_lv_nmos L=0.13u W=0.42u AS=0.1428p AD=0.0609p PS=1.52u
+ PD=0.71u
M$137 94 102 1 1 sg13_lv_nmos L=0.13u W=0.42u AS=0.0609p AD=0.1626p PS=0.71u
+ PD=1.415u
M$138 1 101 56 1 sg13_lv_nmos L=0.13u W=0.74u AS=0.1626p AD=0.2516p PS=1.415u
+ PD=2.16u
M$139 1 102 95 1 sg13_lv_nmos L=0.13u W=0.42u AS=0.1701p AD=0.0378p PS=1.65u
+ PD=0.6u
M$140 95 56 70 1 sg13_lv_nmos L=0.13u W=0.42u AS=0.0378p AD=0.1428p PS=0.6u
+ PD=1.52u
M$142 103 57 71 1 sg13_lv_nmos L=0.13u W=0.42u AS=0.12665p AD=0.1428p PS=1.145u
+ PD=1.52u
M$143 56 116 103 1 sg13_lv_nmos L=0.13u W=0.74u AS=0.3473p AD=0.12665p PS=2.71u
+ PD=1.145u
M$144 71 72 1 1 sg13_lv_nmos L=0.13u W=0.42u AS=0.1428p AD=0.0798p PS=1.52u
+ PD=0.8u
M$145 1 102 93 1 sg13_lv_nmos L=0.13u W=0.42u AS=0.0798p AD=0.0378p PS=0.8u
+ PD=0.6u
M$146 93 103 72 1 sg13_lv_nmos L=0.13u W=0.42u AS=0.0378p AD=0.1428p PS=0.6u
+ PD=1.52u
M$147 73 103 1 1 sg13_lv_nmos L=0.13u W=0.74u AS=0.2516p AD=0.1406p PS=2.16u
+ PD=1.12u
M$148 1 73 29 1 sg13_lv_nmos L=0.13u W=0.74u AS=0.1406p AD=0.2516p PS=1.12u
+ PD=2.16u
M$149 74 104 1 1 sg13_lv_nmos L=0.13u W=0.74u AS=0.2516p AD=0.2516p PS=2.16u
+ PD=2.16u
M$150 75 105 92 1 sg13_lv_nmos L=0.13u W=0.42u AS=0.1428p AD=0.0609p PS=1.52u
+ PD=0.71u
M$151 92 74 1 1 sg13_lv_nmos L=0.13u W=0.42u AS=0.0609p AD=0.1626p PS=0.71u
+ PD=1.415u
M$152 1 106 58 1 sg13_lv_nmos L=0.13u W=0.74u AS=0.1626p AD=0.2516p PS=1.415u
+ PD=2.16u
M$153 1 74 90 1 sg13_lv_nmos L=0.13u W=0.42u AS=0.1701p AD=0.0378p PS=1.65u
+ PD=0.6u
M$154 90 58 76 1 sg13_lv_nmos L=0.13u W=0.42u AS=0.0378p AD=0.1428p PS=0.6u
+ PD=1.52u
M$156 107 59 77 1 sg13_lv_nmos L=0.13u W=0.42u AS=0.12665p AD=0.1428p PS=1.145u
+ PD=1.52u
M$157 58 117 107 1 sg13_lv_nmos L=0.13u W=0.74u AS=0.3473p AD=0.12665p PS=2.71u
+ PD=1.145u
M$158 77 78 1 1 sg13_lv_nmos L=0.13u W=0.42u AS=0.1428p AD=0.0798p PS=1.52u
+ PD=0.8u
M$159 1 74 89 1 sg13_lv_nmos L=0.13u W=0.42u AS=0.0798p AD=0.0378p PS=0.8u
+ PD=0.6u
M$160 89 107 78 1 sg13_lv_nmos L=0.13u W=0.42u AS=0.0378p AD=0.1428p PS=0.6u
+ PD=1.52u
M$161 79 107 1 1 sg13_lv_nmos L=0.13u W=0.74u AS=0.2516p AD=0.1406p PS=2.16u
+ PD=1.12u
M$162 1 79 32 1 sg13_lv_nmos L=0.13u W=0.74u AS=0.1406p AD=0.2516p PS=1.12u
+ PD=2.16u
M$163 1 23 82 1 sg13_lv_nmos L=0.13u W=0.74u AS=0.2516p AD=0.1406p PS=2.16u
+ PD=1.12u
M$164 82 167 1 1 sg13_lv_nmos L=0.13u W=0.74u AS=0.1406p AD=0.2516p PS=1.12u
+ PD=2.16u
M$165 1 104 85 1 sg13_lv_nmos L=0.13u W=0.74u AS=0.2516p AD=0.2516p PS=2.16u
+ PD=2.16u
M$166 1 118 86 1 sg13_lv_nmos L=0.13u W=0.55u AS=0.14875p AD=0.187p PS=1.16u
+ PD=1.78u
M$167 1 86 60 1 sg13_lv_nmos L=0.13u W=0.74u AS=0.14875p AD=0.2886p PS=1.16u
+ PD=2.26u
M$168 63 55 99 1 sg13_lv_nmos L=0.13u W=0.42u AS=0.1296p AD=0.0798p PS=1.52u
+ PD=0.8u
M$169 99 115 64 1 sg13_lv_nmos L=0.13u W=0.42u AS=0.0798p AD=0.2373p PS=0.8u
+ PD=1.97u
M$170 135 164 137 1 sg13_lv_nmos L=0.13u W=0.42u AS=0.1296p AD=0.0798p PS=1.52u
+ PD=0.8u
M$171 137 138 163 1 sg13_lv_nmos L=0.13u W=0.42u AS=0.0798p AD=0.2373p PS=0.8u
+ PD=1.97u
M$172 1 55 115 1 sg13_lv_nmos L=0.13u W=0.74u AS=0.317325p AD=0.2516p PS=1.805u
+ PD=2.16u
M$173 1 210 55 1 sg13_lv_nmos L=0.13u W=0.74u AS=0.317325p AD=0.2516p PS=1.805u
+ PD=2.16u
M$174 69 57 101 1 sg13_lv_nmos L=0.13u W=0.42u AS=0.1296p AD=0.0798p PS=1.52u
+ PD=0.8u
M$175 101 116 70 1 sg13_lv_nmos L=0.13u W=0.42u AS=0.0798p AD=0.2373p PS=0.8u
+ PD=1.97u
M$176 1 57 116 1 sg13_lv_nmos L=0.13u W=0.74u AS=0.317325p AD=0.2516p PS=1.805u
+ PD=2.16u
M$177 1 118 57 1 sg13_lv_nmos L=0.13u W=0.74u AS=0.317325p AD=0.2516p PS=1.805u
+ PD=2.16u
M$178 1 4 192 1 sg13_lv_nmos L=0.13u W=0.64u AS=0.2272p AD=0.0784p PS=1.99u
+ PD=0.885u
M$179 192 165 143 1 sg13_lv_nmos L=0.13u W=0.64u AS=0.0784p AD=0.2176p
+ PS=0.885u PD=1.96u
M$180 75 59 106 1 sg13_lv_nmos L=0.13u W=0.42u AS=0.1296p AD=0.0798p PS=1.52u
+ PD=0.8u
M$181 106 117 76 1 sg13_lv_nmos L=0.13u W=0.42u AS=0.0798p AD=0.2373p PS=0.8u
+ PD=1.97u
M$182 1 59 117 1 sg13_lv_nmos L=0.13u W=0.74u AS=0.317325p AD=0.2516p PS=1.805u
+ PD=2.16u
M$183 1 118 59 1 sg13_lv_nmos L=0.13u W=0.74u AS=0.317325p AD=0.2516p PS=1.805u
+ PD=2.16u
M$184 146 21 194 1 sg13_lv_nmos L=0.13u W=0.64u AS=0.2176p AD=0.0784p PS=1.96u
+ PD=0.885u
M$185 194 32 1 1 sg13_lv_nmos L=0.13u W=0.64u AS=0.0784p AD=0.2272p PS=0.885u
+ PD=1.99u
M$186 108 9 114 1 sg13_lv_nmos L=0.13u W=0.64u AS=0.2176p AD=0.1216p PS=1.96u
+ PD=1.02u
M$187 1 30 114 1 sg13_lv_nmos L=0.13u W=0.64u AS=0.1331p AD=0.1216p PS=1.12u
+ PD=1.02u
M$188 1 108 33 1 sg13_lv_nmos L=0.13u W=0.74u AS=0.1331p AD=0.2516p PS=1.12u
+ PD=2.16u
M$189 147 109 195 1 sg13_lv_nmos L=0.13u W=0.64u AS=0.2176p AD=0.1216p PS=1.96u
+ PD=1.02u
M$190 195 525 1 1 sg13_lv_nmos L=0.13u W=0.64u AS=0.1216p AD=0.1331p PS=1.02u
+ PD=1.12u
M$191 1 147 148 1 sg13_lv_nmos L=0.13u W=0.74u AS=0.1331p AD=0.2516p PS=1.12u
+ PD=2.16u
M$192 1 109 80 1 sg13_lv_nmos L=0.13u W=0.55u AS=0.374p AD=0.174625p PS=2.46u
+ PD=1.185u
M$193 1 525 80 1 sg13_lv_nmos L=0.13u W=0.55u AS=0.15245p AD=0.174625p PS=1.17u
+ PD=1.185u
M$194 1 109 113 1 sg13_lv_nmos L=0.13u W=0.74u AS=0.15245p AD=0.0888p PS=1.17u
+ PD=0.98u
M$195 113 525 81 1 sg13_lv_nmos L=0.13u W=0.74u AS=0.0888p AD=0.1628p PS=0.98u
+ PD=1.18u
M$196 81 80 1 1 sg13_lv_nmos L=0.13u W=0.74u AS=0.1628p AD=0.3108p PS=1.18u
+ PD=2.32u
M$197 1 18 83 1 sg13_lv_nmos L=0.13u W=0.55u AS=0.374p AD=0.174625p PS=2.46u
+ PD=1.185u
M$198 1 151 83 1 sg13_lv_nmos L=0.13u W=0.55u AS=0.15245p AD=0.174625p PS=1.17u
+ PD=1.185u
M$199 1 18 112 1 sg13_lv_nmos L=0.13u W=0.74u AS=0.15245p AD=0.0888p PS=1.17u
+ PD=0.98u
M$200 112 151 84 1 sg13_lv_nmos L=0.13u W=0.74u AS=0.0888p AD=0.1628p PS=0.98u
+ PD=1.18u
M$201 84 83 1 1 sg13_lv_nmos L=0.13u W=0.74u AS=0.1628p AD=0.3108p PS=1.18u
+ PD=2.32u
M$202 152 81 197 1 sg13_lv_nmos L=0.13u W=0.64u AS=0.2176p AD=0.0784p PS=1.96u
+ PD=0.885u
M$203 197 168 1 1 sg13_lv_nmos L=0.13u W=0.64u AS=0.0784p AD=0.2272p PS=0.885u
+ PD=1.99u
M$207 153 170 155 1 sg13_lv_nmos L=0.13u W=0.42u AS=0.1296p AD=0.0798p PS=1.52u
+ PD=0.8u
M$208 155 156 169 1 sg13_lv_nmos L=0.13u W=0.42u AS=0.0798p AD=0.2373p PS=0.8u
+ PD=1.97u
M$212 138 164 1 1 sg13_lv_nmos L=0.13u W=0.74u AS=0.2516p AD=0.317325p PS=2.16u
+ PD=1.805u
M$213 1 210 164 1 sg13_lv_nmos L=0.13u W=0.74u AS=0.317325p AD=0.2516p
+ PS=1.805u PD=2.16u
M$214 180 164 139 1 sg13_lv_nmos L=0.13u W=0.42u AS=0.1428p AD=0.12665p
+ PS=1.52u PD=1.145u
M$215 139 138 136 1 sg13_lv_nmos L=0.13u W=0.74u AS=0.12665p AD=0.3473p
+ PS=1.145u PD=2.71u
M$216 1 166 145 1 sg13_lv_nmos L=0.13u W=0.55u AS=0.15245p AD=0.174625p
+ PS=1.17u PD=1.185u
M$217 145 15 1 1 sg13_lv_nmos L=0.13u W=0.55u AS=0.174625p AD=0.374p PS=1.185u
+ PD=2.46u
M$218 1 145 165 1 sg13_lv_nmos L=0.13u W=0.74u AS=0.3108p AD=0.1628p PS=2.32u
+ PD=1.18u
M$219 165 166 193 1 sg13_lv_nmos L=0.13u W=0.74u AS=0.1628p AD=0.0888p PS=1.18u
+ PD=0.98u
M$220 193 15 1 1 sg13_lv_nmos L=0.13u W=0.74u AS=0.0888p AD=0.15245p PS=0.98u
+ PD=1.17u
M$221 1 23 149 1 sg13_lv_nmos L=0.13u W=0.55u AS=0.374p AD=0.174625p PS=2.46u
+ PD=1.185u
M$222 149 167 1 1 sg13_lv_nmos L=0.13u W=0.55u AS=0.174625p AD=0.15245p
+ PS=1.185u PD=1.17u
M$223 1 23 196 1 sg13_lv_nmos L=0.13u W=0.74u AS=0.15245p AD=0.0888p PS=1.17u
+ PD=0.98u
M$224 196 167 151 1 sg13_lv_nmos L=0.13u W=0.74u AS=0.0888p AD=0.1628p PS=0.98u
+ PD=1.18u
M$225 151 149 1 1 sg13_lv_nmos L=0.13u W=0.74u AS=0.1628p AD=0.3108p PS=1.18u
+ PD=2.32u
M$226 156 170 1 1 sg13_lv_nmos L=0.13u W=0.74u AS=0.2516p AD=0.317325p PS=2.16u
+ PD=1.805u
M$227 1 118 170 1 sg13_lv_nmos L=0.13u W=0.74u AS=0.317325p AD=0.2516p
+ PS=1.805u PD=2.16u
M$228 184 170 157 1 sg13_lv_nmos L=0.13u W=0.42u AS=0.1428p AD=0.12665p
+ PS=1.52u PD=1.145u
M$229 157 156 154 1 sg13_lv_nmos L=0.13u W=0.74u AS=0.12665p AD=0.3473p
+ PS=1.145u PD=2.71u
M$232 133 97 1 1 sg13_lv_nmos L=0.13u W=0.55u AS=0.187p AD=0.18945p PS=1.78u
+ PD=1.27u
M$233 1 97 185 1 sg13_lv_nmos L=0.13u W=0.74u AS=0.18945p AD=0.13135p PS=1.27u
+ PD=1.095u
M$234 185 162 134 1 sg13_lv_nmos L=0.13u W=0.74u AS=0.13135p AD=0.1628p
+ PS=1.095u PD=1.18u
M$235 134 68 186 1 sg13_lv_nmos L=0.13u W=0.74u AS=0.1628p AD=0.3367p PS=1.18u
+ PD=1.65u
M$236 186 133 1 1 sg13_lv_nmos L=0.13u W=0.74u AS=0.3367p AD=0.148p PS=1.65u
+ PD=1.14u
M$237 1 134 98 1 sg13_lv_nmos L=0.13u W=0.74u AS=0.148p AD=0.4033p PS=1.14u
+ PD=2.57u
M$238 141 139 1 1 sg13_lv_nmos L=0.13u W=0.74u AS=0.2516p AD=0.1406p PS=2.16u
+ PD=1.12u
M$239 1 141 109 1 sg13_lv_nmos L=0.13u W=0.74u AS=0.1406p AD=0.2516p PS=1.12u
+ PD=2.16u
M$243 142 12 1 1 sg13_lv_nmos L=0.13u W=0.55u AS=0.187p AD=0.14505p PS=1.78u
+ PD=1.15u
M$244 1 68 191 1 sg13_lv_nmos L=0.13u W=0.74u AS=0.14505p AD=0.1406p PS=1.15u
+ PD=1.12u
M$245 191 142 4 1 sg13_lv_nmos L=0.13u W=0.74u AS=0.1406p AD=0.333p PS=1.12u
+ PD=2.38u
M$247 181 4 1 1 sg13_lv_nmos L=0.13u W=0.74u AS=0.2516p AD=0.1898p PS=2.16u
+ PD=1.36u
M$248 1 165 181 1 sg13_lv_nmos L=0.13u W=0.74u AS=0.1898p AD=0.1406p PS=1.36u
+ PD=1.12u
M$249 181 143 105 1 sg13_lv_nmos L=0.13u W=0.74u AS=0.1406p AD=0.2516p PS=1.12u
+ PD=2.16u
M$254 166 146 182 1 sg13_lv_nmos L=0.13u W=0.74u AS=0.2516p AD=0.1406p PS=2.16u
+ PD=1.12u
M$255 182 21 1 1 sg13_lv_nmos L=0.13u W=0.74u AS=0.1406p AD=0.1898p PS=1.12u
+ PD=1.36u
M$256 1 32 182 1 sg13_lv_nmos L=0.13u W=0.74u AS=0.1898p AD=0.2516p PS=1.36u
+ PD=2.16u
M$259 167 152 183 1 sg13_lv_nmos L=0.13u W=0.74u AS=0.2516p AD=0.1406p PS=2.16u
+ PD=1.12u
M$260 183 81 1 1 sg13_lv_nmos L=0.13u W=0.74u AS=0.1406p AD=0.1898p PS=1.12u
+ PD=1.36u
M$261 1 168 183 1 sg13_lv_nmos L=0.13u W=0.74u AS=0.1898p AD=0.2516p PS=1.36u
+ PD=2.16u
M$262 159 157 1 1 sg13_lv_nmos L=0.13u W=0.74u AS=0.2516p AD=0.1406p PS=2.16u
+ PD=1.12u
M$263 1 159 168 1 sg13_lv_nmos L=0.13u W=0.74u AS=0.1406p AD=0.2516p PS=1.12u
+ PD=2.16u
M$266 1 97 203 1 sg13_lv_nmos L=0.13u W=0.55u AS=0.18945p AD=0.187p PS=1.27u
+ PD=1.78u
M$267 1 97 204 1 sg13_lv_nmos L=0.13u W=0.74u AS=0.18945p AD=0.13135p PS=1.27u
+ PD=1.095u
M$268 204 9 200 1 sg13_lv_nmos L=0.13u W=0.74u AS=0.13135p AD=0.1628p PS=1.095u
+ PD=1.18u
M$269 200 109 205 1 sg13_lv_nmos L=0.13u W=0.74u AS=0.1628p AD=0.3367p PS=1.18u
+ PD=1.65u
M$270 205 203 1 1 sg13_lv_nmos L=0.13u W=0.74u AS=0.3367p AD=0.148p PS=1.65u
+ PD=1.14u
M$271 1 200 201 1 sg13_lv_nmos L=0.13u W=0.74u AS=0.148p AD=0.4033p PS=1.14u
+ PD=2.57u
M$272 1 137 136 1 sg13_lv_nmos L=0.13u W=0.74u AS=0.1626p AD=0.2516p PS=1.415u
+ PD=2.16u
M$273 135 201 187 1 sg13_lv_nmos L=0.13u W=0.42u AS=0.1428p AD=0.0609p PS=1.52u
+ PD=0.71u
M$274 1 132 187 1 sg13_lv_nmos L=0.13u W=0.42u AS=0.1626p AD=0.0609p PS=1.415u
+ PD=0.71u
M$275 1 96 132 1 sg13_lv_nmos L=0.13u W=0.74u AS=0.2516p AD=0.2516p PS=2.16u
+ PD=2.16u
M$278 1 132 188 1 sg13_lv_nmos L=0.13u W=0.42u AS=0.1701p AD=0.0378p PS=1.65u
+ PD=0.6u
M$279 188 136 163 1 sg13_lv_nmos L=0.13u W=0.42u AS=0.0378p AD=0.1428p PS=0.6u
+ PD=1.52u
M$284 180 140 1 1 sg13_lv_nmos L=0.13u W=0.42u AS=0.1428p AD=0.0798p PS=1.52u
+ PD=0.8u
M$285 1 132 190 1 sg13_lv_nmos L=0.13u W=0.42u AS=0.0798p AD=0.0378p PS=0.8u
+ PD=0.6u
M$286 190 139 140 1 sg13_lv_nmos L=0.13u W=0.42u AS=0.0378p AD=0.1428p PS=0.6u
+ PD=1.52u
M$309 1 148 202 1 sg13_lv_nmos L=0.13u W=0.74u AS=0.2516p AD=0.1406p PS=2.16u
+ PD=1.12u
M$310 202 168 206 1 sg13_lv_nmos L=0.13u W=0.74u AS=0.1406p AD=0.1406p PS=1.12u
+ PD=1.12u
M$311 206 81 1 1 sg13_lv_nmos L=0.13u W=0.74u AS=0.1406p AD=0.2516p PS=1.12u
+ PD=2.16u
M$316 1 155 154 1 sg13_lv_nmos L=0.13u W=0.74u AS=0.1626p AD=0.2516p PS=1.415u
+ PD=2.16u
M$317 153 84 198 1 sg13_lv_nmos L=0.13u W=0.42u AS=0.1428p AD=0.0609p PS=1.52u
+ PD=0.71u
M$318 1 85 198 1 sg13_lv_nmos L=0.13u W=0.42u AS=0.1626p AD=0.0609p PS=1.415u
+ PD=0.71u
M$321 1 85 199 1 sg13_lv_nmos L=0.13u W=0.42u AS=0.1701p AD=0.0378p PS=1.65u
+ PD=0.6u
M$322 199 154 169 1 sg13_lv_nmos L=0.13u W=0.42u AS=0.0378p AD=0.1428p PS=0.6u
+ PD=1.52u
M$327 184 158 1 1 sg13_lv_nmos L=0.13u W=0.42u AS=0.1428p AD=0.0798p PS=1.52u
+ PD=0.8u
M$328 1 85 189 1 sg13_lv_nmos L=0.13u W=0.42u AS=0.0798p AD=0.0378p PS=0.8u
+ PD=0.6u
M$329 189 157 158 1 sg13_lv_nmos L=0.13u W=0.42u AS=0.0378p AD=0.1428p PS=0.6u
+ PD=1.52u
M$339 1 211 210 1 sg13_lv_nmos L=0.13u W=11.84u AS=2.3606p AD=2.2496p PS=18.96u
+ PD=17.92u
M$355 1 415 211 1 sg13_lv_nmos L=0.13u W=4.44u AS=0.8436p AD=0.9546p PS=6.72u
+ PD=7.76u
M$379 1 217 212 1 sg13_lv_nmos L=0.13u W=0.74u AS=0.2516p AD=0.1406p PS=2.16u
+ PD=1.12u
M$380 212 202 1 1 sg13_lv_nmos L=0.13u W=0.74u AS=0.1406p AD=0.2516p PS=1.12u
+ PD=2.16u
M$381 1 215 219 1 sg13_lv_nmos L=0.13u W=0.64u AS=0.1331p AD=0.1216p PS=1.12u
+ PD=1.02u
M$382 219 151 214 1 sg13_lv_nmos L=0.13u W=0.64u AS=0.1216p AD=0.2176p PS=1.02u
+ PD=1.96u
M$383 213 214 1 1 sg13_lv_nmos L=0.13u W=0.74u AS=0.2516p AD=0.1331p PS=2.16u
+ PD=1.12u
M$394 1 218 225 1 sg13_lv_nmos L=0.13u W=0.55u AS=0.14875p AD=0.187p PS=1.16u
+ PD=1.78u
M$395 1 225 162 1 sg13_lv_nmos L=0.13u W=0.74u AS=0.14875p AD=0.2886p PS=1.16u
+ PD=2.26u
M$397 220 221 1 1 sg13_lv_nmos L=0.13u W=0.74u AS=0.4033p AD=0.148p PS=2.57u
+ PD=1.14u
M$398 1 226 237 1 sg13_lv_nmos L=0.13u W=0.74u AS=0.148p AD=0.3367p PS=1.14u
+ PD=1.65u
M$399 237 227 221 1 sg13_lv_nmos L=0.13u W=0.74u AS=0.3367p AD=0.1628p PS=1.65u
+ PD=1.18u
M$400 221 109 238 1 sg13_lv_nmos L=0.13u W=0.74u AS=0.1628p AD=0.13135p
+ PS=1.18u PD=1.095u
M$401 238 97 1 1 sg13_lv_nmos L=0.13u W=0.74u AS=0.13135p AD=0.18945p PS=1.095u
+ PD=1.27u
M$402 1 97 226 1 sg13_lv_nmos L=0.13u W=0.55u AS=0.18945p AD=0.187p PS=1.27u
+ PD=1.78u
M$417 1 227 228 1 sg13_lv_nmos L=0.13u W=0.55u AS=0.374p AD=0.174625p PS=2.46u
+ PD=1.185u
M$418 1 30 228 1 sg13_lv_nmos L=0.13u W=0.55u AS=0.15245p AD=0.174625p PS=1.17u
+ PD=1.185u
M$419 1 227 239 1 sg13_lv_nmos L=0.13u W=0.74u AS=0.15245p AD=0.0888p PS=1.17u
+ PD=0.98u
M$420 239 30 222 1 sg13_lv_nmos L=0.13u W=0.74u AS=0.0888p AD=0.1628p PS=0.98u
+ PD=1.18u
M$421 222 228 1 1 sg13_lv_nmos L=0.13u W=0.74u AS=0.1628p AD=0.3108p PS=1.18u
+ PD=2.32u
M$424 1 222 240 1 sg13_lv_nmos L=0.13u W=0.74u AS=0.2516p AD=0.1406p PS=2.16u
+ PD=1.12u
M$425 240 229 292 1 sg13_lv_nmos L=0.13u W=0.74u AS=0.1406p AD=0.2516p PS=1.12u
+ PD=2.16u
M$428 1 229 242 1 sg13_lv_nmos L=0.13u W=0.64u AS=0.2272p AD=0.0784p PS=1.99u
+ PD=0.885u
M$429 242 222 230 1 sg13_lv_nmos L=0.13u W=0.64u AS=0.0784p AD=0.2176p
+ PS=0.885u PD=1.96u
M$430 1 229 231 1 sg13_lv_nmos L=0.13u W=0.74u AS=0.1898p AD=0.2516p PS=1.36u
+ PD=2.16u
M$431 1 222 231 1 sg13_lv_nmos L=0.13u W=0.74u AS=0.1898p AD=0.1406p PS=1.36u
+ PD=1.12u
M$432 231 230 217 1 sg13_lv_nmos L=0.13u W=0.74u AS=0.1406p AD=0.2516p PS=1.12u
+ PD=2.16u
M$435 1 224 223 1 sg13_lv_nmos L=0.13u W=1.48u AS=0.3922p AD=0.3922p PS=3.28u
+ PD=3.28u
M$437 1 212 224 1 sg13_lv_nmos L=0.13u W=0.74u AS=0.3811p AD=0.1406p PS=2.51u
+ PD=1.12u
M$438 224 82 243 1 sg13_lv_nmos L=0.13u W=0.74u AS=0.1406p AD=0.09435p PS=1.12u
+ PD=0.995u
M$439 243 232 1 1 sg13_lv_nmos L=0.13u W=0.74u AS=0.09435p AD=0.2516p PS=0.995u
+ PD=2.16u
M$440 1 202 233 1 sg13_lv_nmos L=0.13u W=0.55u AS=0.374p AD=0.174625p PS=2.46u
+ PD=1.185u
M$441 1 217 233 1 sg13_lv_nmos L=0.13u W=0.55u AS=0.15245p AD=0.174625p
+ PS=1.17u PD=1.185u
M$442 1 202 244 1 sg13_lv_nmos L=0.13u W=0.74u AS=0.15245p AD=0.0888p PS=1.17u
+ PD=0.98u
M$443 244 217 215 1 sg13_lv_nmos L=0.13u W=0.74u AS=0.0888p AD=0.1628p PS=0.98u
+ PD=1.18u
M$444 215 233 1 1 sg13_lv_nmos L=0.13u W=0.74u AS=0.1628p AD=0.3108p PS=1.18u
+ PD=2.32u
M$445 1 215 241 1 sg13_lv_nmos L=0.13u W=0.64u AS=0.2272p AD=0.0784p PS=1.99u
+ PD=0.885u
M$446 241 278 234 1 sg13_lv_nmos L=0.13u W=0.64u AS=0.0784p AD=0.2176p
+ PS=0.885u PD=1.96u
M$447 1 215 235 1 sg13_lv_nmos L=0.13u W=0.74u AS=0.1898p AD=0.2516p PS=1.36u
+ PD=2.16u
M$448 1 278 235 1 sg13_lv_nmos L=0.13u W=0.74u AS=0.1898p AD=0.1406p PS=1.36u
+ PD=1.12u
M$449 235 234 246 1 sg13_lv_nmos L=0.13u W=0.74u AS=0.1406p AD=0.2516p PS=1.12u
+ PD=2.16u
M$454 118 236 1 1 sg13_lv_nmos L=0.13u W=0.74u AS=0.2886p AD=0.14875p PS=2.26u
+ PD=1.16u
M$455 1 247 236 1 sg13_lv_nmos L=0.13u W=0.55u AS=0.14875p AD=0.187p PS=1.16u
+ PD=1.78u
M$460 1 96 257 1 sg13_lv_nmos L=0.13u W=0.74u AS=0.2516p AD=0.2516p PS=2.16u
+ PD=2.16u
M$461 256 286 262 1 sg13_lv_nmos L=0.13u W=0.42u AS=0.1296p AD=0.0798p PS=1.52u
+ PD=0.8u
M$462 262 263 300 1 sg13_lv_nmos L=0.13u W=0.42u AS=0.0798p AD=0.2373p PS=0.8u
+ PD=1.97u
M$463 263 286 1 1 sg13_lv_nmos L=0.13u W=0.74u AS=0.2516p AD=0.317325p PS=2.16u
+ PD=1.805u
M$464 1 210 286 1 sg13_lv_nmos L=0.13u W=0.74u AS=0.317325p AD=0.2516p
+ PS=1.805u PD=2.16u
M$465 301 286 287 1 sg13_lv_nmos L=0.13u W=0.42u AS=0.1428p AD=0.12665p
+ PS=1.52u PD=1.145u
M$466 287 263 261 1 sg13_lv_nmos L=0.13u W=0.74u AS=0.12665p AD=0.3473p
+ PS=1.145u PD=2.71u
M$467 264 287 1 1 sg13_lv_nmos L=0.13u W=0.74u AS=0.2516p AD=0.1406p PS=2.16u
+ PD=1.12u
M$468 1 264 227 1 sg13_lv_nmos L=0.13u W=0.74u AS=0.1406p AD=0.2516p PS=1.12u
+ PD=2.16u
M$470 265 289 313 1 sg13_lv_nmos L=0.13u W=0.74u AS=0.2516p AD=0.1406p PS=2.16u
+ PD=1.12u
M$471 313 30 1 1 sg13_lv_nmos L=0.13u W=0.74u AS=0.1406p AD=0.2516p PS=1.12u
+ PD=2.16u
M$474 1 291 316 1 sg13_lv_nmos L=0.13u W=0.64u AS=0.2272p AD=0.0784p PS=1.99u
+ PD=0.885u
M$475 316 290 266 1 sg13_lv_nmos L=0.13u W=0.64u AS=0.0784p AD=0.2176p
+ PS=0.885u PD=1.96u
M$476 302 291 1 1 sg13_lv_nmos L=0.13u W=0.74u AS=0.2516p AD=0.1898p PS=2.16u
+ PD=1.36u
M$477 1 290 302 1 sg13_lv_nmos L=0.13u W=0.74u AS=0.1898p AD=0.1406p PS=1.36u
+ PD=1.12u
M$478 302 266 267 1 sg13_lv_nmos L=0.13u W=0.74u AS=0.1406p AD=0.2516p PS=1.12u
+ PD=2.16u
M$479 1 30 317 1 sg13_lv_nmos L=0.13u W=0.74u AS=0.2516p AD=0.1406p PS=2.16u
+ PD=1.12u
M$480 317 227 268 1 sg13_lv_nmos L=0.13u W=0.74u AS=0.1406p AD=0.2516p PS=1.12u
+ PD=2.16u
M$481 1 267 318 1 sg13_lv_nmos L=0.13u W=0.74u AS=0.2886p AD=0.1406p PS=2.26u
+ PD=1.12u
M$482 318 292 319 1 sg13_lv_nmos L=0.13u W=0.74u AS=0.1406p AD=0.1406p PS=1.12u
+ PD=1.12u
M$483 319 268 258 1 sg13_lv_nmos L=0.13u W=0.74u AS=0.1406p AD=0.2516p PS=1.12u
+ PD=2.16u
M$484 269 258 1 1 sg13_lv_nmos L=0.13u W=0.55u AS=0.187p AD=0.17255p PS=1.78u
+ PD=1.25u
M$485 1 269 270 1 sg13_lv_nmos L=0.13u W=0.74u AS=0.17255p AD=0.1406p PS=1.25u
+ PD=1.12u
M$486 270 348 1 1 sg13_lv_nmos L=0.13u W=0.74u AS=0.1406p AD=0.2516p PS=1.12u
+ PD=2.16u
M$487 271 525 1 1 sg13_lv_nmos L=0.13u W=0.55u AS=0.187p AD=0.14875p PS=1.78u
+ PD=1.16u
M$488 1 271 30 1 sg13_lv_nmos L=0.13u W=0.74u AS=0.14875p AD=0.2886p PS=1.16u
+ PD=2.26u
M$492 272 104 1 1 sg13_lv_nmos L=0.13u W=0.74u AS=0.2516p AD=0.2516p PS=2.16u
+ PD=2.16u
M$494 1 213 303 1 sg13_lv_nmos L=0.13u W=1.48u AS=0.3922p AD=0.2812p PS=3.28u
+ PD=2.24u
M$495 303 18 274 1 sg13_lv_nmos L=0.13u W=1.48u AS=0.2812p AD=0.2812p PS=2.24u
+ PD=2.24u
M$498 1 223 274 1 sg13_lv_nmos L=0.13u W=1.48u AS=0.2812p AD=0.3922p PS=2.24u
+ PD=3.28u
M$500 1 223 276 1 sg13_lv_nmos L=0.13u W=0.64u AS=0.15745p AD=0.1216p PS=1.175u
+ PD=1.02u
M$501 276 18 315 1 sg13_lv_nmos L=0.13u W=0.64u AS=0.1216p AD=0.0816p PS=1.02u
+ PD=0.895u
M$502 315 213 1 1 sg13_lv_nmos L=0.13u W=0.64u AS=0.0816p AD=0.2176p PS=0.895u
+ PD=1.96u
M$503 275 276 1 1 sg13_lv_nmos L=0.13u W=0.74u AS=0.2351p AD=0.15745p PS=2.16u
+ PD=1.175u
M$504 1 217 314 1 sg13_lv_nmos L=0.13u W=0.74u AS=0.2516p AD=0.1406p PS=2.16u
+ PD=1.12u
M$505 314 202 232 1 sg13_lv_nmos L=0.13u W=0.74u AS=0.1406p AD=0.2516p PS=1.12u
+ PD=2.16u
M$506 1 82 278 1 sg13_lv_nmos L=0.13u W=0.74u AS=0.2516p AD=0.1406p PS=2.16u
+ PD=1.12u
M$507 278 18 312 1 sg13_lv_nmos L=0.13u W=0.74u AS=0.1406p AD=0.1406p PS=1.12u
+ PD=1.12u
M$508 312 151 1 1 sg13_lv_nmos L=0.13u W=0.74u AS=0.1406p AD=0.2516p PS=1.12u
+ PD=2.16u
M$510 1 104 260 1 sg13_lv_nmos L=0.13u W=0.74u AS=0.2516p AD=0.2516p PS=2.16u
+ PD=2.16u
M$511 259 293 281 1 sg13_lv_nmos L=0.13u W=0.42u AS=0.1296p AD=0.0798p PS=1.52u
+ PD=0.8u
M$512 281 282 304 1 sg13_lv_nmos L=0.13u W=0.42u AS=0.0798p AD=0.2373p PS=0.8u
+ PD=1.97u
M$513 282 293 1 1 sg13_lv_nmos L=0.13u W=0.74u AS=0.2516p AD=0.317325p PS=2.16u
+ PD=1.805u
M$514 1 118 293 1 sg13_lv_nmos L=0.13u W=0.74u AS=0.317325p AD=0.2516p
+ PS=1.805u PD=2.16u
M$515 305 293 294 1 sg13_lv_nmos L=0.13u W=0.42u AS=0.1428p AD=0.12665p
+ PS=1.52u PD=1.145u
M$516 294 282 280 1 sg13_lv_nmos L=0.13u W=0.74u AS=0.12665p AD=0.3473p
+ PS=1.145u PD=2.71u
M$517 283 294 1 1 sg13_lv_nmos L=0.13u W=0.74u AS=0.2516p AD=0.1406p PS=2.16u
+ PD=1.12u
M$518 1 283 229 1 sg13_lv_nmos L=0.13u W=0.74u AS=0.1406p AD=0.2516p PS=1.12u
+ PD=2.16u
M$521 1 96 320 1 sg13_lv_nmos L=0.13u W=0.74u AS=0.2516p AD=0.2516p PS=2.16u
+ PD=2.16u
M$522 321 396 358 1 sg13_lv_nmos L=0.13u W=0.42u AS=0.1428p AD=0.0609p PS=1.52u
+ PD=0.71u
M$523 358 320 1 1 sg13_lv_nmos L=0.13u W=0.42u AS=0.0609p AD=0.1626p PS=0.71u
+ PD=1.415u
M$524 1 374 322 1 sg13_lv_nmos L=0.13u W=0.74u AS=0.1626p AD=0.2516p PS=1.415u
+ PD=2.16u
M$525 1 262 261 1 sg13_lv_nmos L=0.13u W=0.74u AS=0.1626p AD=0.2516p PS=1.415u
+ PD=2.16u
M$526 256 220 307 1 sg13_lv_nmos L=0.13u W=0.42u AS=0.1428p AD=0.0609p PS=1.52u
+ PD=0.71u
M$527 1 257 307 1 sg13_lv_nmos L=0.13u W=0.42u AS=0.1626p AD=0.0609p PS=1.415u
+ PD=0.71u
M$528 1 320 359 1 sg13_lv_nmos L=0.13u W=0.42u AS=0.1701p AD=0.0378p PS=1.65u
+ PD=0.6u
M$529 359 322 342 1 sg13_lv_nmos L=0.13u W=0.42u AS=0.0378p AD=0.1428p PS=0.6u
+ PD=1.52u
M$530 1 257 308 1 sg13_lv_nmos L=0.13u W=0.42u AS=0.1701p AD=0.0378p PS=1.65u
+ PD=0.6u
M$531 308 261 300 1 sg13_lv_nmos L=0.13u W=0.42u AS=0.0378p AD=0.1428p PS=0.6u
+ PD=1.52u
M$532 343 323 324 1 sg13_lv_nmos L=0.13u W=0.42u AS=0.12665p AD=0.1428p
+ PS=1.145u PD=1.52u
M$533 322 375 343 1 sg13_lv_nmos L=0.13u W=0.74u AS=0.3473p AD=0.12665p
+ PS=2.71u PD=1.145u
M$534 301 288 1 1 sg13_lv_nmos L=0.13u W=0.42u AS=0.1428p AD=0.0798p PS=1.52u
+ PD=0.8u
M$535 1 257 309 1 sg13_lv_nmos L=0.13u W=0.42u AS=0.0798p AD=0.0378p PS=0.8u
+ PD=0.6u
M$536 309 287 288 1 sg13_lv_nmos L=0.13u W=0.42u AS=0.0378p AD=0.1428p PS=0.6u
+ PD=1.52u
M$537 324 325 1 1 sg13_lv_nmos L=0.13u W=0.42u AS=0.1428p AD=0.0798p PS=1.52u
+ PD=0.8u
M$538 1 320 362 1 sg13_lv_nmos L=0.13u W=0.42u AS=0.0798p AD=0.0378p PS=0.8u
+ PD=0.6u
M$539 362 343 325 1 sg13_lv_nmos L=0.13u W=0.42u AS=0.0378p AD=0.1428p PS=0.6u
+ PD=1.52u
M$540 326 343 1 1 sg13_lv_nmos L=0.13u W=0.74u AS=0.2516p AD=0.1406p PS=2.16u
+ PD=1.12u
M$541 1 326 289 1 sg13_lv_nmos L=0.13u W=0.74u AS=0.1406p AD=0.2516p PS=1.12u
+ PD=2.16u
M$542 1 289 344 1 sg13_lv_nmos L=0.13u W=0.55u AS=0.374p AD=0.174625p PS=2.46u
+ PD=1.185u
M$543 1 30 344 1 sg13_lv_nmos L=0.13u W=0.55u AS=0.15245p AD=0.174625p PS=1.17u
+ PD=1.185u
M$544 1 289 363 1 sg13_lv_nmos L=0.13u W=0.74u AS=0.15245p AD=0.0888p PS=1.17u
+ PD=0.98u
M$545 363 30 290 1 sg13_lv_nmos L=0.13u W=0.74u AS=0.0888p AD=0.1628p PS=0.98u
+ PD=1.18u
M$546 290 344 1 1 sg13_lv_nmos L=0.13u W=0.74u AS=0.1628p AD=0.3108p PS=1.18u
+ PD=2.32u
M$547 1 290 365 1 sg13_lv_nmos L=0.13u W=0.74u AS=0.2516p AD=0.1406p PS=2.16u
+ PD=1.12u
M$548 365 291 345 1 sg13_lv_nmos L=0.13u W=0.74u AS=0.1406p AD=0.2516p PS=1.12u
+ PD=2.16u
M$549 1 347 369 1 sg13_lv_nmos L=0.13u W=0.74u AS=0.2886p AD=0.1406p PS=2.26u
+ PD=1.12u
M$550 369 345 367 1 sg13_lv_nmos L=0.13u W=0.74u AS=0.1406p AD=0.1406p PS=1.12u
+ PD=1.12u
M$551 367 265 327 1 sg13_lv_nmos L=0.13u W=0.74u AS=0.1406p AD=0.2516p PS=1.12u
+ PD=2.16u
M$553 1 274 351 1 sg13_lv_nmos L=0.13u W=0.74u AS=0.1898p AD=0.2516p PS=1.36u
+ PD=2.16u
M$554 1 270 351 1 sg13_lv_nmos L=0.13u W=0.74u AS=0.1898p AD=0.1406p PS=1.36u
+ PD=1.12u
M$555 351 350 328 1 sg13_lv_nmos L=0.13u W=0.74u AS=0.1406p AD=0.2516p PS=1.12u
+ PD=2.16u
M$556 329 328 370 1 sg13_lv_nmos L=0.13u W=0.42u AS=0.1428p AD=0.0609p PS=1.52u
+ PD=0.71u
M$557 370 272 1 1 sg13_lv_nmos L=0.13u W=0.42u AS=0.0609p AD=0.1626p PS=0.71u
+ PD=1.415u
M$558 1 379 330 1 sg13_lv_nmos L=0.13u W=0.74u AS=0.1626p AD=0.2516p PS=1.415u
+ PD=2.16u
M$559 1 272 368 1 sg13_lv_nmos L=0.13u W=0.42u AS=0.1701p AD=0.0378p PS=1.65u
+ PD=0.6u
M$560 368 330 352 1 sg13_lv_nmos L=0.13u W=0.42u AS=0.0378p AD=0.1428p PS=0.6u
+ PD=1.52u
M$561 353 331 332 1 sg13_lv_nmos L=0.13u W=0.42u AS=0.12665p AD=0.1428p
+ PS=1.145u PD=1.52u
M$562 330 380 353 1 sg13_lv_nmos L=0.13u W=0.74u AS=0.3473p AD=0.12665p
+ PS=2.71u PD=1.145u
M$563 332 333 1 1 sg13_lv_nmos L=0.13u W=0.42u AS=0.1428p AD=0.0798p PS=1.52u
+ PD=0.8u
M$564 1 272 364 1 sg13_lv_nmos L=0.13u W=0.42u AS=0.0798p AD=0.0378p PS=0.8u
+ PD=0.6u
M$565 364 353 333 1 sg13_lv_nmos L=0.13u W=0.42u AS=0.0378p AD=0.1428p PS=0.6u
+ PD=1.52u
M$566 334 353 1 1 sg13_lv_nmos L=0.13u W=0.74u AS=0.2516p AD=0.1406p PS=2.16u
+ PD=1.12u
M$567 1 334 291 1 sg13_lv_nmos L=0.13u W=0.74u AS=0.1406p AD=0.2516p PS=1.12u
+ PD=2.16u
M$573 1 118 335 1 sg13_lv_nmos L=0.13u W=0.74u AS=0.2516p AD=0.2516p PS=2.16u
+ PD=2.16u
M$574 336 335 361 1 sg13_lv_nmos L=0.13u W=0.42u AS=0.1428p AD=0.0609p PS=1.52u
+ PD=0.71u
M$575 361 354 1 1 sg13_lv_nmos L=0.13u W=0.42u AS=0.0609p AD=0.1626p PS=0.71u
+ PD=1.415u
M$576 1 381 337 1 sg13_lv_nmos L=0.13u W=0.74u AS=0.1626p AD=0.2516p PS=1.415u
+ PD=2.16u
M$577 1 281 280 1 sg13_lv_nmos L=0.13u W=0.74u AS=0.1626p AD=0.2516p PS=1.415u
+ PD=2.16u
M$578 259 246 311 1 sg13_lv_nmos L=0.13u W=0.42u AS=0.1428p AD=0.0609p PS=1.52u
+ PD=0.71u
M$579 1 260 311 1 sg13_lv_nmos L=0.13u W=0.42u AS=0.1626p AD=0.0609p PS=1.415u
+ PD=0.71u
M$580 1 354 360 1 sg13_lv_nmos L=0.13u W=0.42u AS=0.1701p AD=0.0378p PS=1.65u
+ PD=0.6u
M$581 360 337 355 1 sg13_lv_nmos L=0.13u W=0.42u AS=0.0378p AD=0.1428p PS=0.6u
+ PD=1.52u
M$582 1 260 310 1 sg13_lv_nmos L=0.13u W=0.42u AS=0.1701p AD=0.0378p PS=1.65u
+ PD=0.6u
M$583 310 280 304 1 sg13_lv_nmos L=0.13u W=0.42u AS=0.0378p AD=0.1428p PS=0.6u
+ PD=1.52u
M$584 356 338 339 1 sg13_lv_nmos L=0.13u W=0.42u AS=0.12665p AD=0.1428p
+ PS=1.145u PD=1.52u
M$585 337 382 356 1 sg13_lv_nmos L=0.13u W=0.74u AS=0.3473p AD=0.12665p
+ PS=2.71u PD=1.145u
M$586 305 295 1 1 sg13_lv_nmos L=0.13u W=0.42u AS=0.1428p AD=0.0798p PS=1.52u
+ PD=0.8u
M$587 1 260 306 1 sg13_lv_nmos L=0.13u W=0.42u AS=0.0798p AD=0.0378p PS=0.8u
+ PD=0.6u
M$588 306 294 295 1 sg13_lv_nmos L=0.13u W=0.42u AS=0.0378p AD=0.1428p PS=0.6u
+ PD=1.52u
M$589 339 340 1 1 sg13_lv_nmos L=0.13u W=0.42u AS=0.1428p AD=0.0798p PS=1.52u
+ PD=0.8u
M$590 1 354 357 1 sg13_lv_nmos L=0.13u W=0.42u AS=0.0798p AD=0.0378p PS=0.8u
+ PD=0.6u
M$591 357 356 340 1 sg13_lv_nmos L=0.13u W=0.42u AS=0.0378p AD=0.1428p PS=0.6u
+ PD=1.52u
M$592 341 356 1 1 sg13_lv_nmos L=0.13u W=0.74u AS=0.2516p AD=0.1406p PS=2.16u
+ PD=1.12u
M$593 1 341 247 1 sg13_lv_nmos L=0.13u W=0.74u AS=0.1406p AD=0.2516p PS=1.12u
+ PD=2.16u
M$596 1 97 392 1 sg13_lv_nmos L=0.13u W=0.55u AS=0.18945p AD=0.187p PS=1.27u
+ PD=1.78u
M$597 396 405 1 1 sg13_lv_nmos L=0.13u W=0.74u AS=0.4033p AD=0.148p PS=2.57u
+ PD=1.14u
M$598 1 392 407 1 sg13_lv_nmos L=0.13u W=0.74u AS=0.148p AD=0.3367p PS=1.14u
+ PD=1.65u
M$599 407 289 405 1 sg13_lv_nmos L=0.13u W=0.74u AS=0.3367p AD=0.1628p PS=1.65u
+ PD=1.18u
M$600 405 227 408 1 sg13_lv_nmos L=0.13u W=0.74u AS=0.1628p AD=0.13135p
+ PS=1.18u PD=1.095u
M$601 408 97 1 1 sg13_lv_nmos L=0.13u W=0.74u AS=0.13135p AD=0.18945p PS=1.095u
+ PD=1.27u
M$602 321 323 374 1 sg13_lv_nmos L=0.13u W=0.42u AS=0.1296p AD=0.0798p PS=1.52u
+ PD=0.8u
M$603 374 375 342 1 sg13_lv_nmos L=0.13u W=0.42u AS=0.0798p AD=0.2373p PS=0.8u
+ PD=1.97u
M$606 1 323 375 1 sg13_lv_nmos L=0.13u W=0.74u AS=0.317325p AD=0.2516p
+ PS=1.805u PD=2.16u
M$607 1 210 323 1 sg13_lv_nmos L=0.13u W=0.74u AS=0.317325p AD=0.2516p
+ PS=1.805u PD=2.16u
M$614 393 265 410 1 sg13_lv_nmos L=0.13u W=0.64u AS=0.2176p AD=0.1216p PS=1.96u
+ PD=1.02u
M$615 410 345 409 1 sg13_lv_nmos L=0.13u W=0.64u AS=0.1216p AD=0.1216p PS=1.02u
+ PD=1.02u
M$616 409 347 1 1 sg13_lv_nmos L=0.13u W=0.64u AS=0.1216p AD=0.1371p PS=1.02u
+ PD=1.12u
M$617 1 393 394 1 sg13_lv_nmos L=0.13u W=0.74u AS=0.1371p AD=0.2516p PS=1.12u
+ PD=2.16u
M$618 1 345 366 1 sg13_lv_nmos L=0.13u W=0.74u AS=0.2516p AD=0.1406p PS=2.16u
+ PD=1.12u
M$619 366 265 346 1 sg13_lv_nmos L=0.13u W=0.74u AS=0.1406p AD=0.1406p PS=1.12u
+ PD=1.12u
M$620 346 347 1 1 sg13_lv_nmos L=0.13u W=0.74u AS=0.1406p AD=0.2516p PS=1.12u
+ PD=2.16u
M$621 1 394 397 1 sg13_lv_nmos L=0.13u W=0.74u AS=0.2516p AD=0.1406p PS=2.16u
+ PD=1.12u
M$622 397 346 1 1 sg13_lv_nmos L=0.13u W=0.74u AS=0.1406p AD=0.2516p PS=1.12u
+ PD=2.16u
M$623 1 327 411 1 sg13_lv_nmos L=0.13u W=0.74u AS=0.2516p AD=0.1406p PS=2.16u
+ PD=1.12u
M$624 411 348 399 1 sg13_lv_nmos L=0.13u W=0.74u AS=0.1406p AD=0.1406p PS=1.12u
+ PD=1.12u
M$625 399 346 1 1 sg13_lv_nmos L=0.13u W=0.74u AS=0.1406p AD=0.2516p PS=1.12u
+ PD=2.16u
M$626 1 267 348 1 sg13_lv_nmos L=0.13u W=0.74u AS=0.2516p AD=0.1406p PS=2.16u
+ PD=1.12u
M$627 348 268 371 1 sg13_lv_nmos L=0.13u W=0.74u AS=0.1406p AD=0.1406p PS=1.12u
+ PD=1.12u
M$628 371 292 1 1 sg13_lv_nmos L=0.13u W=0.74u AS=0.1406p AD=0.2516p PS=1.12u
+ PD=2.16u
M$629 395 399 406 1 sg13_lv_nmos L=0.15u W=0.74u AS=0.2516p AD=0.1406p PS=2.16u
+ PD=1.12u
M$630 406 400 1 1 sg13_lv_nmos L=0.15u W=0.74u AS=0.1406p AD=0.1406p PS=1.12u
+ PD=1.12u
M$631 1 274 406 1 sg13_lv_nmos L=0.15u W=0.74u AS=0.1406p AD=0.2516p PS=1.12u
+ PD=2.16u
M$632 400 270 412 1 sg13_lv_nmos L=0.13u W=0.74u AS=0.2516p AD=0.1406p PS=2.16u
+ PD=1.12u
M$633 412 397 1 1 sg13_lv_nmos L=0.13u W=0.74u AS=0.1406p AD=0.2516p PS=1.12u
+ PD=2.16u
M$634 1 348 349 1 sg13_lv_nmos L=0.13u W=0.74u AS=0.2516p AD=0.1406p PS=2.16u
+ PD=1.12u
M$635 349 275 373 1 sg13_lv_nmos L=0.13u W=0.74u AS=0.1406p AD=0.1406p PS=1.12u
+ PD=1.12u
M$636 373 270 1 1 sg13_lv_nmos L=0.13u W=0.74u AS=0.1406p AD=0.2516p PS=1.12u
+ PD=2.16u
M$639 1 274 372 1 sg13_lv_nmos L=0.13u W=0.64u AS=0.2272p AD=0.0784p PS=1.99u
+ PD=0.885u
M$640 372 270 350 1 sg13_lv_nmos L=0.13u W=0.64u AS=0.0784p AD=0.2176p
+ PS=0.885u PD=1.96u
M$645 329 331 379 1 sg13_lv_nmos L=0.13u W=0.42u AS=0.1296p AD=0.0798p PS=1.52u
+ PD=0.8u
M$646 379 380 352 1 sg13_lv_nmos L=0.13u W=0.42u AS=0.0798p AD=0.2373p PS=0.8u
+ PD=1.97u
M$649 1 331 380 1 sg13_lv_nmos L=0.13u W=0.74u AS=0.317325p AD=0.2516p
+ PS=1.805u PD=2.16u
M$650 1 118 331 1 sg13_lv_nmos L=0.13u W=0.74u AS=0.317325p AD=0.2516p
+ PS=1.805u PD=2.16u
M$661 1 104 354 1 sg13_lv_nmos L=0.13u W=0.74u AS=0.2516p AD=0.2516p PS=2.16u
+ PD=2.16u
M$664 336 338 381 1 sg13_lv_nmos L=0.13u W=0.42u AS=0.1296p AD=0.0798p PS=1.52u
+ PD=0.8u
M$665 381 382 355 1 sg13_lv_nmos L=0.13u W=0.42u AS=0.0798p AD=0.2373p PS=0.8u
+ PD=1.97u
M$666 1 338 382 1 sg13_lv_nmos L=0.13u W=0.74u AS=0.317325p AD=0.2516p
+ PS=1.805u PD=2.16u
M$667 1 423 338 1 sg13_lv_nmos L=0.13u W=0.74u AS=0.317325p AD=0.2516p
+ PS=1.805u PD=2.16u
M$679 1 414 413 1 sg13_lv_nmos L=0.13u W=4.44u AS=0.9546p AD=0.8436p PS=7.76u
+ PD=6.72u
M$685 1 413 415 1 sg13_lv_nmos L=0.13u W=11.84u AS=2.2496p AD=2.3606p PS=17.92u
+ PD=18.96u
M$708 1 397 421 1 sg13_lv_nmos L=0.13u W=0.74u AS=0.1898p AD=0.2516p PS=1.36u
+ PD=2.16u
M$709 1 349 421 1 sg13_lv_nmos L=0.13u W=0.74u AS=0.1898p AD=0.1406p PS=1.36u
+ PD=1.12u
M$710 421 420 416 1 sg13_lv_nmos L=0.13u W=0.74u AS=0.1406p AD=0.2516p PS=1.12u
+ PD=2.16u
M$725 1 422 417 1 sg13_lv_nmos L=0.13u W=0.74u AS=0.2516p AD=0.1406p PS=2.16u
+ PD=1.12u
M$726 417 423 1 1 sg13_lv_nmos L=0.13u W=0.74u AS=0.1406p AD=0.2516p PS=1.12u
+ PD=2.16u
M$728 1 463 419 1 sg13_lv_nmos L=0.13u W=0.74u AS=0.2516p AD=0.2516p PS=2.16u
+ PD=2.16u
M$734 433 432 1 1 sg13_lv_nmos L=0.13u W=0.55u AS=0.187p AD=0.14875p PS=1.78u
+ PD=1.16u
M$735 1 433 97 1 sg13_lv_nmos L=0.13u W=0.74u AS=0.14875p AD=0.2886p PS=1.16u
+ PD=2.26u
M$736 1 97 430 1 sg13_lv_nmos L=0.13u W=0.55u AS=0.18945p AD=0.187p PS=1.27u
+ PD=1.78u
M$737 434 435 1 1 sg13_lv_nmos L=0.13u W=0.74u AS=0.4033p AD=0.148p PS=2.57u
+ PD=1.14u
M$738 1 430 467 1 sg13_lv_nmos L=0.13u W=0.74u AS=0.148p AD=0.3367p PS=1.14u
+ PD=1.65u
M$739 467 457 435 1 sg13_lv_nmos L=0.13u W=0.74u AS=0.3367p AD=0.1628p PS=1.65u
+ PD=1.18u
M$740 435 289 468 1 sg13_lv_nmos L=0.13u W=0.74u AS=0.1628p AD=0.13135p
+ PS=1.18u PD=1.095u
M$741 468 97 1 1 sg13_lv_nmos L=0.13u W=0.74u AS=0.13135p AD=0.18945p PS=1.095u
+ PD=1.27u
M$750 1 459 470 1 sg13_lv_nmos L=0.13u W=0.64u AS=0.2272p AD=0.0784p PS=1.99u
+ PD=0.885u
M$751 470 458 436 1 sg13_lv_nmos L=0.13u W=0.64u AS=0.0784p AD=0.2176p
+ PS=0.885u PD=1.96u
M$752 464 459 1 1 sg13_lv_nmos L=0.13u W=0.74u AS=0.2516p AD=0.1898p PS=2.16u
+ PD=1.36u
M$753 1 458 464 1 sg13_lv_nmos L=0.13u W=0.74u AS=0.1898p AD=0.1406p PS=1.36u
+ PD=1.12u
M$754 464 436 347 1 sg13_lv_nmos L=0.13u W=0.74u AS=0.1406p AD=0.2516p PS=1.12u
+ PD=2.16u
M$759 1 397 426 1 sg13_lv_nmos L=0.13u W=0.64u AS=0.2272p AD=0.0784p PS=1.99u
+ PD=0.885u
M$760 426 349 420 1 sg13_lv_nmos L=0.13u W=0.64u AS=0.0784p AD=0.2176p
+ PS=0.885u PD=1.96u
M$773 1 460 437 1 sg13_lv_nmos L=0.13u W=0.74u AS=0.2516p AD=0.1406p PS=2.16u
+ PD=1.12u
M$774 437 423 471 1 sg13_lv_nmos L=0.13u W=0.74u AS=0.1406p AD=0.1406p PS=1.12u
+ PD=1.12u
M$775 471 422 1 1 sg13_lv_nmos L=0.13u W=0.74u AS=0.1406p AD=0.2516p PS=1.12u
+ PD=2.16u
M$776 1 460 439 1 sg13_lv_nmos L=0.13u W=0.77u AS=0.2618p AD=0.1694p PS=2.22u
+ PD=1.21u
M$777 439 461 1 1 sg13_lv_nmos L=0.13u W=0.77u AS=0.1694p AD=0.1463p PS=1.21u
+ PD=1.15u
M$778 1 417 439 1 sg13_lv_nmos L=0.13u W=0.77u AS=0.1463p AD=0.2618p PS=1.15u
+ PD=2.22u
M$779 1 462 440 1 sg13_lv_nmos L=0.13u W=0.74u AS=0.2516p AD=0.1406p PS=2.16u
+ PD=1.12u
M$780 440 422 473 1 sg13_lv_nmos L=0.13u W=0.74u AS=0.1406p AD=0.1406p PS=1.12u
+ PD=1.12u
M$781 473 460 1 1 sg13_lv_nmos L=0.13u W=0.74u AS=0.1406p AD=0.2516p PS=1.12u
+ PD=2.16u
M$782 1 463 431 1 sg13_lv_nmos L=0.13u W=0.74u AS=0.2516p AD=0.2516p PS=2.16u
+ PD=2.16u
M$783 1 424 418 1 sg13_lv_nmos L=0.13u W=0.74u AS=0.2516p AD=0.1406p PS=2.16u
+ PD=1.12u
M$784 418 423 425 1 sg13_lv_nmos L=0.13u W=0.74u AS=0.1406p AD=0.1406p PS=1.12u
+ PD=1.12u
M$785 425 422 1 1 sg13_lv_nmos L=0.13u W=0.74u AS=0.1406p AD=0.2516p PS=1.12u
+ PD=2.16u
M$786 442 446 443 1 sg13_lv_nmos L=0.13u W=0.42u AS=0.1296p AD=0.0798p PS=1.52u
+ PD=0.8u
M$787 443 445 465 1 sg13_lv_nmos L=0.13u W=0.42u AS=0.0798p AD=0.2373p PS=0.8u
+ PD=1.97u
M$788 445 446 1 1 sg13_lv_nmos L=0.13u W=0.74u AS=0.2516p AD=0.317325p PS=2.16u
+ PD=1.805u
M$789 1 461 446 1 sg13_lv_nmos L=0.13u W=0.74u AS=0.317325p AD=0.2516p
+ PS=1.805u PD=2.16u
M$790 466 446 447 1 sg13_lv_nmos L=0.13u W=0.42u AS=0.1428p AD=0.12665p
+ PS=1.52u PD=1.145u
M$791 447 445 444 1 sg13_lv_nmos L=0.13u W=0.74u AS=0.12665p AD=0.3473p
+ PS=1.145u PD=2.71u
M$792 449 447 1 1 sg13_lv_nmos L=0.13u W=0.74u AS=0.2516p AD=0.1406p PS=2.16u
+ PD=1.12u
M$793 1 449 423 1 sg13_lv_nmos L=0.13u W=0.74u AS=0.1406p AD=0.2516p PS=1.12u
+ PD=2.16u
M$795 1 96 524 1 sg13_lv_nmos L=0.13u W=0.74u AS=0.2516p AD=0.2516p PS=2.16u
+ PD=2.16u
M$796 483 434 512 1 sg13_lv_nmos L=0.13u W=0.42u AS=0.1428p AD=0.0609p PS=1.52u
+ PD=0.71u
M$797 512 524 1 1 sg13_lv_nmos L=0.13u W=0.42u AS=0.0609p AD=0.1626p PS=0.71u
+ PD=1.415u
M$798 1 523 475 1 sg13_lv_nmos L=0.13u W=0.74u AS=0.1626p AD=0.2516p PS=1.415u
+ PD=2.16u
M$799 1 524 513 1 sg13_lv_nmos L=0.13u W=0.42u AS=0.1701p AD=0.0378p PS=1.65u
+ PD=0.6u
M$800 513 475 484 1 sg13_lv_nmos L=0.13u W=0.42u AS=0.0378p AD=0.1428p PS=0.6u
+ PD=1.52u
M$801 486 476 485 1 sg13_lv_nmos L=0.13u W=0.42u AS=0.12665p AD=0.1428p
+ PS=1.145u PD=1.52u
M$802 475 536 486 1 sg13_lv_nmos L=0.13u W=0.74u AS=0.3473p AD=0.12665p
+ PS=2.71u PD=1.145u
M$803 485 487 1 1 sg13_lv_nmos L=0.13u W=0.42u AS=0.1428p AD=0.0798p PS=1.52u
+ PD=0.8u
M$804 1 524 517 1 sg13_lv_nmos L=0.13u W=0.42u AS=0.0798p AD=0.0378p PS=0.8u
+ PD=0.6u
M$805 517 486 487 1 sg13_lv_nmos L=0.13u W=0.42u AS=0.0378p AD=0.1428p PS=0.6u
+ PD=1.52u
M$806 488 486 1 1 sg13_lv_nmos L=0.13u W=0.74u AS=0.2516p AD=0.1406p PS=2.16u
+ PD=1.12u
M$807 1 488 457 1 sg13_lv_nmos L=0.13u W=0.74u AS=0.1406p AD=0.2516p PS=1.12u
+ PD=2.16u
M$808 489 457 531 1 sg13_lv_nmos L=0.13u W=0.74u AS=0.2516p AD=0.1406p PS=2.16u
+ PD=1.12u
M$809 531 525 1 1 sg13_lv_nmos L=0.13u W=0.74u AS=0.1406p AD=0.2516p PS=1.12u
+ PD=2.16u
M$811 1 565 534 1 sg13_lv_nmos L=0.13u W=0.74u AS=0.2886p AD=0.1406p PS=2.26u
+ PD=1.12u
M$812 534 492 533 1 sg13_lv_nmos L=0.13u W=0.74u AS=0.1406p AD=0.1406p PS=1.12u
+ PD=1.12u
M$813 533 489 491 1 sg13_lv_nmos L=0.13u W=0.74u AS=0.1406p AD=0.2516p PS=1.12u
+ PD=2.16u
M$814 1 458 535 1 sg13_lv_nmos L=0.13u W=0.74u AS=0.2516p AD=0.1406p PS=2.16u
+ PD=1.12u
M$815 535 459 492 1 sg13_lv_nmos L=0.13u W=0.74u AS=0.1406p AD=0.2516p PS=1.12u
+ PD=2.16u
M$816 1 463 527 1 sg13_lv_nmos L=0.13u W=0.74u AS=0.2516p AD=0.2516p PS=2.16u
+ PD=2.16u
M$817 493 416 522 1 sg13_lv_nmos L=0.13u W=0.42u AS=0.1428p AD=0.0609p PS=1.52u
+ PD=0.71u
M$818 522 527 1 1 sg13_lv_nmos L=0.13u W=0.42u AS=0.0609p AD=0.1626p PS=0.71u
+ PD=1.415u
M$819 1 526 477 1 sg13_lv_nmos L=0.13u W=0.74u AS=0.1626p AD=0.2516p PS=1.415u
+ PD=2.16u
M$820 1 527 521 1 sg13_lv_nmos L=0.13u W=0.42u AS=0.1701p AD=0.0378p PS=1.65u
+ PD=0.6u
M$821 521 477 494 1 sg13_lv_nmos L=0.13u W=0.42u AS=0.0378p AD=0.1428p PS=0.6u
+ PD=1.52u
M$822 496 478 495 1 sg13_lv_nmos L=0.13u W=0.42u AS=0.12665p AD=0.1428p
+ PS=1.145u PD=1.52u
M$823 477 537 496 1 sg13_lv_nmos L=0.13u W=0.74u AS=0.3473p AD=0.12665p
+ PS=2.71u PD=1.145u
M$824 495 497 1 1 sg13_lv_nmos L=0.13u W=0.42u AS=0.1428p AD=0.0798p PS=1.52u
+ PD=0.8u
M$825 1 527 520 1 sg13_lv_nmos L=0.13u W=0.42u AS=0.0798p AD=0.0378p PS=0.8u
+ PD=0.6u
M$826 520 496 497 1 sg13_lv_nmos L=0.13u W=0.42u AS=0.0378p AD=0.1428p PS=0.6u
+ PD=1.52u
M$827 498 496 1 1 sg13_lv_nmos L=0.13u W=0.74u AS=0.2516p AD=0.1406p PS=2.16u
+ PD=1.12u
M$828 1 498 459 1 sg13_lv_nmos L=0.13u W=0.74u AS=0.1406p AD=0.2516p PS=1.12u
+ PD=2.16u
M$829 1 463 529 1 sg13_lv_nmos L=0.13u W=0.74u AS=0.2516p AD=0.2516p PS=2.16u
+ PD=2.16u
M$830 499 437 519 1 sg13_lv_nmos L=0.13u W=0.42u AS=0.1428p AD=0.0609p PS=1.52u
+ PD=0.71u
M$831 519 529 1 1 sg13_lv_nmos L=0.13u W=0.42u AS=0.0609p AD=0.1626p PS=0.71u
+ PD=1.415u
M$832 1 528 479 1 sg13_lv_nmos L=0.13u W=0.74u AS=0.1626p AD=0.2516p PS=1.415u
+ PD=2.16u
M$833 1 529 518 1 sg13_lv_nmos L=0.13u W=0.42u AS=0.1701p AD=0.0378p PS=1.65u
+ PD=0.6u
M$834 518 479 500 1 sg13_lv_nmos L=0.13u W=0.42u AS=0.0378p AD=0.1428p PS=0.6u
+ PD=1.52u
M$836 502 480 501 1 sg13_lv_nmos L=0.13u W=0.42u AS=0.12665p AD=0.1428p
+ PS=1.145u PD=1.52u
M$837 479 538 502 1 sg13_lv_nmos L=0.13u W=0.74u AS=0.3473p AD=0.12665p
+ PS=2.71u PD=1.145u
M$838 501 503 1 1 sg13_lv_nmos L=0.13u W=0.42u AS=0.1428p AD=0.0798p PS=1.52u
+ PD=0.8u
M$839 1 529 516 1 sg13_lv_nmos L=0.13u W=0.42u AS=0.0798p AD=0.0378p PS=0.8u
+ PD=0.6u
M$840 516 502 503 1 sg13_lv_nmos L=0.13u W=0.42u AS=0.0378p AD=0.1428p PS=0.6u
+ PD=1.52u
M$841 504 502 1 1 sg13_lv_nmos L=0.13u W=0.74u AS=0.2516p AD=0.1406p PS=2.16u
+ PD=1.12u
M$842 1 504 460 1 sg13_lv_nmos L=0.13u W=0.74u AS=0.1406p AD=0.2516p PS=1.12u
+ PD=2.16u
M$843 505 440 515 1 sg13_lv_nmos L=0.13u W=0.42u AS=0.1428p AD=0.0609p PS=1.52u
+ PD=0.71u
M$844 515 431 1 1 sg13_lv_nmos L=0.13u W=0.42u AS=0.0609p AD=0.1626p PS=0.71u
+ PD=1.415u
M$845 1 530 481 1 sg13_lv_nmos L=0.13u W=0.74u AS=0.1626p AD=0.2516p PS=1.415u
+ PD=2.16u
M$846 1 443 444 1 sg13_lv_nmos L=0.13u W=0.74u AS=0.1626p AD=0.2516p PS=1.415u
+ PD=2.16u
M$847 442 418 474 1 sg13_lv_nmos L=0.13u W=0.42u AS=0.1428p AD=0.0609p PS=1.52u
+ PD=0.71u
M$848 1 419 474 1 sg13_lv_nmos L=0.13u W=0.42u AS=0.1626p AD=0.0609p PS=1.415u
+ PD=0.71u
M$849 1 431 514 1 sg13_lv_nmos L=0.13u W=0.42u AS=0.1701p AD=0.0378p PS=1.65u
+ PD=0.6u
M$850 514 481 506 1 sg13_lv_nmos L=0.13u W=0.42u AS=0.0378p AD=0.1428p PS=0.6u
+ PD=1.52u
M$851 1 419 472 1 sg13_lv_nmos L=0.13u W=0.42u AS=0.1701p AD=0.0378p PS=1.65u
+ PD=0.6u
M$852 472 444 465 1 sg13_lv_nmos L=0.13u W=0.42u AS=0.0378p AD=0.1428p PS=0.6u
+ PD=1.52u
M$853 508 482 507 1 sg13_lv_nmos L=0.13u W=0.42u AS=0.12665p AD=0.1428p
+ PS=1.145u PD=1.52u
M$854 481 539 508 1 sg13_lv_nmos L=0.13u W=0.74u AS=0.3473p AD=0.12665p
+ PS=2.71u PD=1.145u
M$855 507 509 1 1 sg13_lv_nmos L=0.13u W=0.42u AS=0.1428p AD=0.0798p PS=1.52u
+ PD=0.8u
M$856 1 431 511 1 sg13_lv_nmos L=0.13u W=0.42u AS=0.0798p AD=0.0378p PS=0.8u
+ PD=0.6u
M$857 511 508 509 1 sg13_lv_nmos L=0.13u W=0.42u AS=0.0378p AD=0.1428p PS=0.6u
+ PD=1.52u
M$858 466 448 1 1 sg13_lv_nmos L=0.13u W=0.42u AS=0.1428p AD=0.0798p PS=1.52u
+ PD=0.8u
M$859 1 419 469 1 sg13_lv_nmos L=0.13u W=0.42u AS=0.0798p AD=0.0378p PS=0.8u
+ PD=0.6u
M$860 469 447 448 1 sg13_lv_nmos L=0.13u W=0.42u AS=0.0378p AD=0.1428p PS=0.6u
+ PD=1.52u
M$861 510 508 1 1 sg13_lv_nmos L=0.13u W=0.74u AS=0.2516p AD=0.1406p PS=2.16u
+ PD=1.12u
M$862 1 510 422 1 sg13_lv_nmos L=0.13u W=0.74u AS=0.1406p AD=0.2516p PS=1.12u
+ PD=2.16u
M$864 550 96 1 1 sg13_lv_nmos L=0.13u W=0.74u AS=0.2516p AD=0.2516p PS=2.16u
+ PD=2.16u
M$865 553 573 555 1 sg13_lv_nmos L=0.13u W=0.42u AS=0.1296p AD=0.0798p PS=1.52u
+ PD=0.8u
M$866 555 556 572 1 sg13_lv_nmos L=0.13u W=0.42u AS=0.0798p AD=0.2373p PS=0.8u
+ PD=1.97u
M$867 483 476 523 1 sg13_lv_nmos L=0.13u W=0.42u AS=0.1296p AD=0.0798p PS=1.52u
+ PD=0.8u
M$868 523 536 484 1 sg13_lv_nmos L=0.13u W=0.42u AS=0.0798p AD=0.2373p PS=0.8u
+ PD=1.97u
M$869 556 573 1 1 sg13_lv_nmos L=0.13u W=0.74u AS=0.2516p AD=0.317325p PS=2.16u
+ PD=1.805u
M$870 1 595 573 1 sg13_lv_nmos L=0.13u W=0.74u AS=0.317325p AD=0.2516p
+ PS=1.805u PD=2.16u
M$871 1 476 536 1 sg13_lv_nmos L=0.13u W=0.74u AS=0.317325p AD=0.2516p
+ PS=1.805u PD=2.16u
M$872 1 595 476 1 sg13_lv_nmos L=0.13u W=0.74u AS=0.317325p AD=0.2516p
+ PS=1.805u PD=2.16u
M$873 581 573 557 1 sg13_lv_nmos L=0.13u W=0.42u AS=0.1428p AD=0.12665p
+ PS=1.52u PD=1.145u
M$874 557 556 554 1 sg13_lv_nmos L=0.13u W=0.74u AS=0.12665p AD=0.3473p
+ PS=1.145u PD=2.71u
M$875 1 560 561 1 sg13_lv_nmos L=0.13u W=0.55u AS=0.374p AD=0.174625p PS=2.46u
+ PD=1.185u
M$876 561 525 1 1 sg13_lv_nmos L=0.13u W=0.55u AS=0.174625p AD=0.15245p
+ PS=1.185u PD=1.17u
M$877 1 560 586 1 sg13_lv_nmos L=0.13u W=0.74u AS=0.15245p AD=0.0888p PS=1.17u
+ PD=0.98u
M$878 586 525 563 1 sg13_lv_nmos L=0.13u W=0.74u AS=0.0888p AD=0.1628p PS=0.98u
+ PD=1.18u
M$879 563 561 1 1 sg13_lv_nmos L=0.13u W=0.74u AS=0.1628p AD=0.3108p PS=1.18u
+ PD=2.32u
M$880 1 457 490 1 sg13_lv_nmos L=0.13u W=0.55u AS=0.374p AD=0.174625p PS=2.46u
+ PD=1.185u
M$881 1 525 490 1 sg13_lv_nmos L=0.13u W=0.55u AS=0.15245p AD=0.174625p
+ PS=1.17u PD=1.185u
M$882 1 457 532 1 sg13_lv_nmos L=0.13u W=0.74u AS=0.15245p AD=0.0888p PS=1.17u
+ PD=0.98u
M$883 532 525 458 1 sg13_lv_nmos L=0.13u W=0.74u AS=0.0888p AD=0.1628p PS=0.98u
+ PD=1.18u
M$884 458 490 1 1 sg13_lv_nmos L=0.13u W=0.74u AS=0.1628p AD=0.3108p PS=1.18u
+ PD=2.32u
M$886 1 574 587 1 sg13_lv_nmos L=0.13u W=0.64u AS=0.2272p AD=0.0784p PS=1.99u
+ PD=0.885u
M$887 587 563 564 1 sg13_lv_nmos L=0.13u W=0.64u AS=0.0784p AD=0.2176p
+ PS=0.885u PD=1.96u
M$888 582 574 1 1 sg13_lv_nmos L=0.13u W=0.74u AS=0.2516p AD=0.1898p PS=2.16u
+ PD=1.36u
M$889 1 563 582 1 sg13_lv_nmos L=0.13u W=0.74u AS=0.1898p AD=0.1406p PS=1.36u
+ PD=1.12u
M$890 582 564 565 1 sg13_lv_nmos L=0.13u W=0.74u AS=0.1406p AD=0.2516p PS=1.12u
+ PD=2.16u
M$891 1 565 566 1 sg13_lv_nmos L=0.13u W=0.74u AS=0.2516p AD=0.1406p PS=2.16u
+ PD=1.12u
M$892 566 489 588 1 sg13_lv_nmos L=0.13u W=0.74u AS=0.1406p AD=0.1406p PS=1.12u
+ PD=1.12u
M$893 588 492 1 1 sg13_lv_nmos L=0.13u W=0.74u AS=0.1406p AD=0.2516p PS=1.12u
+ PD=2.16u
M$898 493 478 526 1 sg13_lv_nmos L=0.13u W=0.42u AS=0.1296p AD=0.0798p PS=1.52u
+ PD=0.8u
M$899 526 537 494 1 sg13_lv_nmos L=0.13u W=0.42u AS=0.0798p AD=0.2373p PS=0.8u
+ PD=1.97u
M$900 1 478 537 1 sg13_lv_nmos L=0.13u W=0.74u AS=0.317325p AD=0.2516p
+ PS=1.805u PD=2.16u
M$901 1 118 478 1 sg13_lv_nmos L=0.13u W=0.74u AS=0.317325p AD=0.2516p
+ PS=1.805u PD=2.16u
M$902 499 480 528 1 sg13_lv_nmos L=0.13u W=0.42u AS=0.1296p AD=0.0798p PS=1.52u
+ PD=0.8u
M$903 528 538 500 1 sg13_lv_nmos L=0.13u W=0.42u AS=0.0798p AD=0.2373p PS=0.8u
+ PD=1.97u
M$904 1 480 538 1 sg13_lv_nmos L=0.13u W=0.74u AS=0.317325p AD=0.2516p
+ PS=1.805u PD=2.16u
M$905 1 461 480 1 sg13_lv_nmos L=0.13u W=0.74u AS=0.317325p AD=0.2516p
+ PS=1.805u PD=2.16u
M$906 575 423 591 1 sg13_lv_nmos L=0.13u W=0.74u AS=0.2516p AD=0.1406p PS=2.16u
+ PD=1.12u
M$907 591 422 1 1 sg13_lv_nmos L=0.13u W=0.74u AS=0.1406p AD=0.2516p PS=1.12u
+ PD=2.16u
M$908 1 460 585 1 sg13_lv_nmos L=0.13u W=0.74u AS=0.2516p AD=0.1406p PS=2.16u
+ PD=1.12u
M$909 585 422 424 1 sg13_lv_nmos L=0.13u W=0.74u AS=0.1406p AD=0.1406p PS=1.12u
+ PD=1.12u
M$910 424 423 1 1 sg13_lv_nmos L=0.13u W=0.74u AS=0.1406p AD=0.2516p PS=1.12u
+ PD=2.16u
M$911 505 482 530 1 sg13_lv_nmos L=0.13u W=0.42u AS=0.1296p AD=0.0798p PS=1.52u
+ PD=0.8u
M$912 530 539 506 1 sg13_lv_nmos L=0.13u W=0.42u AS=0.0798p AD=0.2373p PS=0.8u
+ PD=1.97u
M$913 1 482 539 1 sg13_lv_nmos L=0.13u W=0.74u AS=0.317325p AD=0.2516p
+ PS=1.805u PD=2.16u
M$914 1 461 482 1 sg13_lv_nmos L=0.13u W=0.74u AS=0.317325p AD=0.2516p
+ PS=1.805u PD=2.16u
M$915 1 570 552 1 sg13_lv_nmos L=0.13u W=0.55u AS=0.14875p AD=0.187p PS=1.16u
+ PD=1.78u
M$916 96 552 1 1 sg13_lv_nmos L=0.13u W=0.74u AS=0.2886p AD=0.14875p PS=2.26u
+ PD=1.16u
M$917 559 557 1 1 sg13_lv_nmos L=0.13u W=0.74u AS=0.2516p AD=0.1406p PS=2.16u
+ PD=1.12u
M$918 1 559 560 1 sg13_lv_nmos L=0.13u W=0.74u AS=0.1406p AD=0.2516p PS=1.12u
+ PD=2.16u
M$935 583 525 1 1 sg13_lv_nmos L=0.15u W=0.74u AS=0.2516p AD=0.1406p PS=2.16u
+ PD=1.12u
M$936 1 575 583 1 sg13_lv_nmos L=0.15u W=0.74u AS=0.1406p AD=0.1406p PS=1.12u
+ PD=1.12u
M$937 583 439 551 1 sg13_lv_nmos L=0.15u W=0.74u AS=0.1406p AD=0.2516p PS=1.12u
+ PD=2.16u
M$938 584 422 1 1 sg13_lv_nmos L=0.15u W=0.74u AS=0.2516p AD=0.1406p PS=2.16u
+ PD=1.12u
M$939 1 460 584 1 sg13_lv_nmos L=0.15u W=0.74u AS=0.1406p AD=0.1406p PS=1.12u
+ PD=1.12u
M$940 584 575 462 1 sg13_lv_nmos L=0.15u W=0.74u AS=0.1406p AD=0.2516p PS=1.12u
+ PD=2.16u
M$949 1 555 554 1 sg13_lv_nmos L=0.13u W=0.74u AS=0.1626p AD=0.2516p PS=1.415u
+ PD=2.16u
M$950 553 571 589 1 sg13_lv_nmos L=0.13u W=0.42u AS=0.1428p AD=0.0609p PS=1.52u
+ PD=0.71u
M$951 1 550 589 1 sg13_lv_nmos L=0.13u W=0.42u AS=0.1626p AD=0.0609p PS=1.415u
+ PD=0.71u
M$952 571 593 1 1 sg13_lv_nmos L=0.13u W=0.74u AS=0.4033p AD=0.148p PS=2.57u
+ PD=1.14u
M$953 1 605 613 1 sg13_lv_nmos L=0.13u W=0.74u AS=0.148p AD=0.3367p PS=1.14u
+ PD=1.65u
M$954 613 560 593 1 sg13_lv_nmos L=0.13u W=0.74u AS=0.3367p AD=0.1628p PS=1.65u
+ PD=1.18u
M$955 593 457 614 1 sg13_lv_nmos L=0.13u W=0.74u AS=0.1628p AD=0.13135p
+ PS=1.18u PD=1.095u
M$956 614 97 1 1 sg13_lv_nmos L=0.13u W=0.74u AS=0.13135p AD=0.18945p PS=1.095u
+ PD=1.27u
M$957 1 97 605 1 sg13_lv_nmos L=0.13u W=0.55u AS=0.18945p AD=0.187p PS=1.27u
+ PD=1.78u
M$958 1 550 590 1 sg13_lv_nmos L=0.13u W=0.42u AS=0.1701p AD=0.0378p PS=1.65u
+ PD=0.6u
M$959 590 554 572 1 sg13_lv_nmos L=0.13u W=0.42u AS=0.0378p AD=0.1428p PS=0.6u
+ PD=1.52u
M$960 594 595 1 1 sg13_lv_nmos L=0.13u W=0.74u AS=0.2516p AD=0.2516p PS=2.16u
+ PD=2.16u
M$961 1 596 595 1 sg13_lv_nmos L=0.13u W=11.84u AS=2.3606p AD=2.2496p PS=18.96u
+ PD=17.92u
M$977 1 415 596 1 sg13_lv_nmos L=0.13u W=4.44u AS=0.8436p AD=0.9546p PS=6.72u
+ PD=7.76u
M$983 581 558 1 1 sg13_lv_nmos L=0.13u W=0.42u AS=0.1428p AD=0.0798p PS=1.52u
+ PD=0.8u
M$984 1 550 592 1 sg13_lv_nmos L=0.13u W=0.42u AS=0.0798p AD=0.0378p PS=0.8u
+ PD=0.6u
M$985 592 557 558 1 sg13_lv_nmos L=0.13u W=0.42u AS=0.0378p AD=0.1428p PS=0.6u
+ PD=1.52u
M$987 1 563 616 1 sg13_lv_nmos L=0.13u W=0.74u AS=0.2516p AD=0.1406p PS=2.16u
+ PD=1.12u
M$988 616 574 606 1 sg13_lv_nmos L=0.13u W=0.74u AS=0.1406p AD=0.2516p PS=1.12u
+ PD=2.16u
M$990 1 491 607 1 sg13_lv_nmos L=0.13u W=0.55u AS=0.17255p AD=0.187p PS=1.25u
+ PD=1.78u
M$991 1 607 597 1 sg13_lv_nmos L=0.13u W=0.74u AS=0.17255p AD=0.1406p PS=1.25u
+ PD=1.12u
M$992 597 566 1 1 sg13_lv_nmos L=0.13u W=0.74u AS=0.1406p AD=0.2516p PS=1.12u
+ PD=2.16u
M$994 1 395 608 1 sg13_lv_nmos L=0.13u W=0.55u AS=0.374p AD=0.174625p PS=2.46u
+ PD=1.185u
M$995 1 597 608 1 sg13_lv_nmos L=0.13u W=0.55u AS=0.15245p AD=0.174625p
+ PS=1.17u PD=1.185u
M$996 1 395 619 1 sg13_lv_nmos L=0.13u W=0.74u AS=0.15245p AD=0.0888p PS=1.17u
+ PD=0.98u
M$997 619 597 609 1 sg13_lv_nmos L=0.13u W=0.74u AS=0.0888p AD=0.1628p PS=0.98u
+ PD=1.18u
M$998 609 608 1 1 sg13_lv_nmos L=0.13u W=0.74u AS=0.1628p AD=0.3108p PS=1.18u
+ PD=2.32u
M$999 1 463 598 1 sg13_lv_nmos L=0.13u W=0.74u AS=0.2516p AD=0.2516p PS=2.16u
+ PD=2.16u
M$1000 599 609 618 1 sg13_lv_nmos L=0.13u W=0.42u AS=0.1428p AD=0.0609p
+ PS=1.52u PD=0.71u
M$1001 618 598 1 1 sg13_lv_nmos L=0.13u W=0.42u AS=0.0609p AD=0.1626p PS=0.71u
+ PD=1.415u
M$1002 1 620 600 1 sg13_lv_nmos L=0.13u W=0.74u AS=0.1626p AD=0.2516p PS=1.415u
+ PD=2.16u
M$1003 1 598 617 1 sg13_lv_nmos L=0.13u W=0.42u AS=0.1701p AD=0.0378p PS=1.65u
+ PD=0.6u
M$1004 617 600 610 1 sg13_lv_nmos L=0.13u W=0.42u AS=0.0378p AD=0.1428p PS=0.6u
+ PD=1.52u
M$1005 611 601 602 1 sg13_lv_nmos L=0.13u W=0.42u AS=0.12665p AD=0.1428p
+ PS=1.145u PD=1.52u
M$1006 600 621 611 1 sg13_lv_nmos L=0.13u W=0.74u AS=0.3473p AD=0.12665p
+ PS=2.71u PD=1.145u
M$1007 602 603 1 1 sg13_lv_nmos L=0.13u W=0.42u AS=0.1428p AD=0.0798p PS=1.52u
+ PD=0.8u
M$1008 1 598 615 1 sg13_lv_nmos L=0.13u W=0.42u AS=0.0798p AD=0.0378p PS=0.8u
+ PD=0.6u
M$1009 615 611 603 1 sg13_lv_nmos L=0.13u W=0.42u AS=0.0378p AD=0.1428p PS=0.6u
+ PD=1.52u
M$1010 604 611 1 1 sg13_lv_nmos L=0.13u W=0.74u AS=0.2516p AD=0.1406p PS=2.16u
+ PD=1.12u
M$1011 1 604 574 1 sg13_lv_nmos L=0.13u W=0.74u AS=0.1406p AD=0.2516p PS=1.12u
+ PD=2.16u
M$1017 525 612 1 1 sg13_lv_nmos L=0.13u W=0.74u AS=0.2886p AD=0.14875p PS=2.26u
+ PD=1.16u
M$1018 1 723 612 1 sg13_lv_nmos L=0.13u W=0.55u AS=0.14875p AD=0.187p PS=1.16u
+ PD=1.78u
M$1049 1 566 629 1 sg13_lv_nmos L=0.13u W=0.74u AS=0.2516p AD=0.1406p PS=2.16u
+ PD=1.12u
M$1050 629 395 631 1 sg13_lv_nmos L=0.13u W=0.74u AS=0.1406p AD=0.1406p
+ PS=1.12u PD=1.12u
M$1051 631 597 1 1 sg13_lv_nmos L=0.13u W=0.74u AS=0.1406p AD=0.2516p PS=1.12u
+ PD=2.16u
M$1058 599 601 620 1 sg13_lv_nmos L=0.13u W=0.42u AS=0.1296p AD=0.0798p
+ PS=1.52u PD=0.8u
M$1059 620 621 610 1 sg13_lv_nmos L=0.13u W=0.42u AS=0.0798p AD=0.2373p PS=0.8u
+ PD=1.97u
M$1062 1 601 621 1 sg13_lv_nmos L=0.13u W=0.74u AS=0.317325p AD=0.2516p
+ PS=1.805u PD=2.16u
M$1063 1 247 601 1 sg13_lv_nmos L=0.13u W=0.74u AS=0.317325p AD=0.2516p
+ PS=1.805u PD=2.16u
M$1076 640 638 662 1 sg13_lv_nmos L=0.13u W=0.42u AS=0.1428p AD=0.0609p
+ PS=1.52u PD=0.71u
M$1077 662 639 1 1 sg13_lv_nmos L=0.13u W=0.42u AS=0.0609p AD=0.1626p PS=0.71u
+ PD=1.415u
M$1078 1 672 641 1 sg13_lv_nmos L=0.13u W=0.74u AS=0.1626p AD=0.2516p PS=1.415u
+ PD=2.16u
M$1083 643 644 1 1 sg13_lv_nmos L=0.13u W=0.42u AS=0.1428p AD=0.0798p PS=1.52u
+ PD=0.8u
M$1084 1 639 659 1 sg13_lv_nmos L=0.13u W=0.42u AS=0.0798p AD=0.0378p PS=0.8u
+ PD=0.6u
M$1085 659 657 644 1 sg13_lv_nmos L=0.13u W=0.42u AS=0.0378p AD=0.1428p PS=0.6u
+ PD=1.52u
M$1088 645 657 1 1 sg13_lv_nmos L=0.13u W=0.74u AS=0.2516p AD=0.1406p PS=2.16u
+ PD=1.12u
M$1089 1 645 461 1 sg13_lv_nmos L=0.13u W=0.74u AS=0.1406p AD=0.2516p PS=1.12u
+ PD=2.16u
M$1092 632 633 1 1 sg13_lv_nmos L=0.13u W=0.74u AS=0.4033p AD=0.148p PS=2.57u
+ PD=1.14u
M$1093 1 647 658 1 sg13_lv_nmos L=0.13u W=0.74u AS=0.148p AD=0.3367p PS=1.14u
+ PD=1.65u
M$1094 658 646 633 1 sg13_lv_nmos L=0.13u W=0.74u AS=0.3367p AD=0.1628p
+ PS=1.65u PD=1.18u
M$1095 633 560 660 1 sg13_lv_nmos L=0.13u W=0.74u AS=0.1628p AD=0.13135p
+ PS=1.18u PD=1.095u
M$1096 660 97 1 1 sg13_lv_nmos L=0.13u W=0.74u AS=0.13135p AD=0.18945p
+ PS=1.095u PD=1.27u
M$1097 1 97 647 1 sg13_lv_nmos L=0.13u W=0.55u AS=0.18945p AD=0.187p PS=1.27u
+ PD=1.78u
M$1098 634 560 663 1 sg13_lv_nmos L=0.13u W=0.74u AS=0.2516p AD=0.1406p
+ PS=2.16u PD=1.12u
M$1099 663 525 1 1 sg13_lv_nmos L=0.13u W=0.74u AS=0.1406p AD=0.2516p PS=1.12u
+ PD=2.16u
M$1100 1 635 649 1 sg13_lv_nmos L=0.13u W=0.55u AS=0.17255p AD=0.187p PS=1.25u
+ PD=1.78u
M$1101 1 649 636 1 sg13_lv_nmos L=0.13u W=0.74u AS=0.17255p AD=0.1406p PS=1.25u
+ PD=1.12u
M$1102 636 648 1 1 sg13_lv_nmos L=0.13u W=0.74u AS=0.1406p AD=0.2516p PS=1.12u
+ PD=2.16u
M$1103 1 463 637 1 sg13_lv_nmos L=0.13u W=0.74u AS=0.2516p AD=0.2516p PS=2.16u
+ PD=2.16u
M$1104 1 104 639 1 sg13_lv_nmos L=0.13u W=0.74u AS=0.2516p AD=0.2516p PS=2.16u
+ PD=2.16u
M$1112 1 671 666 1 sg13_lv_nmos L=0.13u W=0.74u AS=0.2886p AD=0.1406p PS=2.26u
+ PD=1.12u
M$1113 666 606 665 1 sg13_lv_nmos L=0.13u W=0.74u AS=0.1406p AD=0.1406p
+ PS=1.12u PD=1.12u
M$1114 665 634 635 1 sg13_lv_nmos L=0.13u W=0.74u AS=0.1406p AD=0.2516p
+ PS=1.12u PD=2.16u
M$1129 1 639 661 1 sg13_lv_nmos L=0.13u W=0.42u AS=0.1701p AD=0.0378p PS=1.65u
+ PD=0.6u
M$1130 661 641 655 1 sg13_lv_nmos L=0.13u W=0.42u AS=0.0378p AD=0.1428p PS=0.6u
+ PD=1.52u
M$1131 657 642 643 1 sg13_lv_nmos L=0.13u W=0.42u AS=0.12665p AD=0.1428p
+ PS=1.145u PD=1.52u
M$1132 641 656 657 1 sg13_lv_nmos L=0.13u W=0.74u AS=0.3473p AD=0.12665p
+ PS=2.71u PD=1.145u
M$1134 1 718 681 1 sg13_lv_nmos L=0.13u W=0.74u AS=0.2516p AD=0.2516p PS=2.16u
+ PD=2.16u
M$1135 688 721 690 1 sg13_lv_nmos L=0.13u W=0.42u AS=0.1296p AD=0.0798p
+ PS=1.52u PD=0.8u
M$1136 690 691 720 1 sg13_lv_nmos L=0.13u W=0.42u AS=0.0798p AD=0.2373p PS=0.8u
+ PD=1.97u
M$1137 691 721 1 1 sg13_lv_nmos L=0.13u W=0.74u AS=0.2516p AD=0.317325p
+ PS=2.16u PD=1.805u
M$1138 1 595 721 1 sg13_lv_nmos L=0.13u W=0.74u AS=0.317325p AD=0.2516p
+ PS=1.805u PD=2.16u
M$1139 739 721 722 1 sg13_lv_nmos L=0.13u W=0.42u AS=0.1428p AD=0.12665p
+ PS=1.52u PD=1.145u
M$1140 722 691 689 1 sg13_lv_nmos L=0.13u W=0.74u AS=0.12665p AD=0.3473p
+ PS=1.145u PD=2.71u
M$1141 695 646 1 1 sg13_lv_nmos L=0.13u W=0.55u AS=0.187p AD=0.17255p PS=1.78u
+ PD=1.25u
M$1142 1 695 696 1 sg13_lv_nmos L=0.13u W=0.74u AS=0.17255p AD=0.1406p PS=1.25u
+ PD=1.12u
M$1143 696 723 1 1 sg13_lv_nmos L=0.13u W=0.74u AS=0.1406p AD=0.2516p PS=1.12u
+ PD=2.16u
M$1144 1 696 697 1 sg13_lv_nmos L=0.13u W=0.74u AS=0.2516p AD=0.1406p PS=2.16u
+ PD=1.12u
M$1145 697 724 746 1 sg13_lv_nmos L=0.13u W=0.74u AS=0.1406p AD=0.1406p
+ PS=1.12u PD=1.12u
M$1146 746 725 1 1 sg13_lv_nmos L=0.13u W=0.74u AS=0.1406p AD=0.2516p PS=1.12u
+ PD=2.16u
M$1147 1 606 664 1 sg13_lv_nmos L=0.13u W=0.74u AS=0.2516p AD=0.1406p PS=2.16u
+ PD=1.12u
M$1148 664 634 648 1 sg13_lv_nmos L=0.13u W=0.74u AS=0.1406p AD=0.1406p
+ PS=1.12u PD=1.12u
M$1149 648 671 1 1 sg13_lv_nmos L=0.13u W=0.74u AS=0.1406p AD=0.2516p PS=1.12u
+ PD=2.16u
M$1150 1 635 668 1 sg13_lv_nmos L=0.13u W=0.74u AS=0.2516p AD=0.1406p PS=2.16u
+ PD=1.12u
M$1151 668 566 650 1 sg13_lv_nmos L=0.13u W=0.74u AS=0.1406p AD=0.2516p
+ PS=1.12u PD=2.16u
M$1152 1 636 747 1 sg13_lv_nmos L=0.13u W=0.64u AS=0.2272p AD=0.0784p PS=1.99u
+ PD=0.885u
M$1153 747 629 699 1 sg13_lv_nmos L=0.13u W=0.64u AS=0.0784p AD=0.2176p
+ PS=0.885u PD=1.96u
M$1154 650 651 669 1 sg13_lv_nmos L=0.13u W=0.74u AS=0.2516p AD=0.1406p
+ PS=2.16u PD=1.12u
M$1155 669 395 1 1 sg13_lv_nmos L=0.13u W=0.74u AS=0.1406p AD=0.1406p PS=1.12u
+ PD=1.12u
M$1156 1 648 650 1 sg13_lv_nmos L=0.13u W=0.74u AS=0.1406p AD=0.2516p PS=1.12u
+ PD=2.16u
M$1157 740 636 1 1 sg13_lv_nmos L=0.13u W=0.74u AS=0.2516p AD=0.1898p PS=2.16u
+ PD=1.36u
M$1158 1 629 740 1 sg13_lv_nmos L=0.13u W=0.74u AS=0.1898p AD=0.1406p PS=1.36u
+ PD=1.12u
M$1159 740 699 700 1 sg13_lv_nmos L=0.13u W=0.74u AS=0.1406p AD=0.2516p
+ PS=1.12u PD=2.16u
M$1160 651 652 1 1 sg13_lv_nmos L=0.13u W=0.74u AS=0.2516p AD=0.1331p PS=2.16u
+ PD=1.12u
M$1161 1 636 670 1 sg13_lv_nmos L=0.13u W=0.64u AS=0.1331p AD=0.1216p PS=1.12u
+ PD=1.02u
M$1162 670 597 652 1 sg13_lv_nmos L=0.13u W=0.64u AS=0.1216p AD=0.2176p
+ PS=1.02u PD=1.96u
M$1163 701 727 703 1 sg13_lv_nmos L=0.13u W=0.42u AS=0.1296p AD=0.0798p
+ PS=1.52u PD=0.8u
M$1164 703 704 726 1 sg13_lv_nmos L=0.13u W=0.42u AS=0.0798p AD=0.2373p PS=0.8u
+ PD=1.97u
M$1165 704 727 1 1 sg13_lv_nmos L=0.13u W=0.74u AS=0.2516p AD=0.317325p
+ PS=2.16u PD=1.805u
M$1166 1 247 727 1 sg13_lv_nmos L=0.13u W=0.74u AS=0.317325p AD=0.2516p
+ PS=1.805u PD=2.16u
M$1167 741 727 728 1 sg13_lv_nmos L=0.13u W=0.42u AS=0.1428p AD=0.12665p
+ PS=1.52u PD=1.145u
M$1168 728 704 702 1 sg13_lv_nmos L=0.13u W=0.74u AS=0.12665p AD=0.3473p
+ PS=1.145u PD=2.71u
M$1169 683 729 1 1 sg13_lv_nmos L=0.13u W=0.74u AS=0.2516p AD=0.2516p PS=2.16u
+ PD=2.16u
M$1170 1 463 684 1 sg13_lv_nmos L=0.13u W=0.74u AS=0.2516p AD=0.2516p PS=2.16u
+ PD=2.16u
M$1171 685 730 1 1 sg13_lv_nmos L=0.13u W=0.74u AS=0.2516p AD=0.2516p PS=2.16u
+ PD=2.16u
M$1172 653 654 1 1 sg13_lv_nmos L=0.13u W=0.74u AS=0.2516p AD=0.1331p PS=2.16u
+ PD=1.12u
M$1173 1 551 667 1 sg13_lv_nmos L=0.13u W=0.64u AS=0.1331p AD=0.1216p PS=1.12u
+ PD=1.02u
M$1174 667 638 654 1 sg13_lv_nmos L=0.13u W=0.64u AS=0.1216p AD=0.2176p
+ PS=1.02u PD=1.96u
M$1175 707 732 709 1 sg13_lv_nmos L=0.13u W=0.42u AS=0.1296p AD=0.0798p
+ PS=1.52u PD=0.8u
M$1176 709 710 731 1 sg13_lv_nmos L=0.13u W=0.42u AS=0.0798p AD=0.2373p PS=0.8u
+ PD=1.97u
M$1177 710 732 1 1 sg13_lv_nmos L=0.13u W=0.74u AS=0.2516p AD=0.317325p
+ PS=2.16u PD=1.805u
M$1178 1 730 732 1 sg13_lv_nmos L=0.13u W=0.74u AS=0.317325p AD=0.2516p
+ PS=1.805u PD=2.16u
M$1179 742 732 733 1 sg13_lv_nmos L=0.13u W=0.42u AS=0.1428p AD=0.12665p
+ PS=1.52u PD=1.145u
M$1180 733 710 708 1 sg13_lv_nmos L=0.13u W=0.74u AS=0.12665p AD=0.3473p
+ PS=1.145u PD=2.71u
M$1181 640 642 672 1 sg13_lv_nmos L=0.13u W=0.42u AS=0.1296p AD=0.0798p
+ PS=1.52u PD=0.8u
M$1182 672 656 655 1 sg13_lv_nmos L=0.13u W=0.42u AS=0.0798p AD=0.2373p PS=0.8u
+ PD=1.97u
M$1183 1 642 656 1 sg13_lv_nmos L=0.13u W=0.74u AS=0.317325p AD=0.2516p
+ PS=1.805u PD=2.16u
M$1184 1 730 642 1 sg13_lv_nmos L=0.13u W=0.74u AS=0.317325p AD=0.2516p
+ PS=1.805u PD=2.16u
M$1185 1 104 686 1 sg13_lv_nmos L=0.13u W=0.74u AS=0.2516p AD=0.2516p PS=2.16u
+ PD=2.16u
M$1186 1 713 687 1 sg13_lv_nmos L=0.13u W=0.74u AS=0.2516p AD=0.2516p PS=2.16u
+ PD=2.16u
M$1188 1 690 689 1 sg13_lv_nmos L=0.13u W=0.74u AS=0.1626p AD=0.2516p PS=1.415u
+ PD=2.16u
M$1189 688 719 743 1 sg13_lv_nmos L=0.13u W=0.42u AS=0.1428p AD=0.0609p
+ PS=1.52u PD=0.71u
M$1190 1 717 743 1 sg13_lv_nmos L=0.13u W=0.42u AS=0.1626p AD=0.0609p PS=1.415u
+ PD=0.71u
M$1191 1 717 744 1 sg13_lv_nmos L=0.13u W=0.42u AS=0.1701p AD=0.0378p PS=1.65u
+ PD=0.6u
M$1192 744 689 720 1 sg13_lv_nmos L=0.13u W=0.42u AS=0.0378p AD=0.1428p PS=0.6u
+ PD=1.52u
M$1193 739 692 1 1 sg13_lv_nmos L=0.13u W=0.42u AS=0.1428p AD=0.0798p PS=1.52u
+ PD=0.8u
M$1194 1 717 745 1 sg13_lv_nmos L=0.13u W=0.42u AS=0.0798p AD=0.0378p PS=0.8u
+ PD=0.6u
M$1195 745 722 692 1 sg13_lv_nmos L=0.13u W=0.42u AS=0.0378p AD=0.1428p PS=0.6u
+ PD=1.52u
M$1196 693 722 1 1 sg13_lv_nmos L=0.13u W=0.74u AS=0.2516p AD=0.1406p PS=2.16u
+ PD=1.12u
M$1197 1 693 694 1 sg13_lv_nmos L=0.13u W=0.74u AS=0.1406p AD=0.2516p PS=1.12u
+ PD=2.16u
M$1202 1 703 702 1 sg13_lv_nmos L=0.13u W=0.74u AS=0.1626p AD=0.2516p PS=1.415u
+ PD=2.16u
M$1203 701 700 748 1 sg13_lv_nmos L=0.13u W=0.42u AS=0.1428p AD=0.0609p
+ PS=1.52u PD=0.71u
M$1204 1 682 748 1 sg13_lv_nmos L=0.13u W=0.42u AS=0.1626p AD=0.0609p PS=1.415u
+ PD=0.71u
M$1205 1 682 749 1 sg13_lv_nmos L=0.13u W=0.42u AS=0.1701p AD=0.0378p PS=1.65u
+ PD=0.6u
M$1206 749 702 726 1 sg13_lv_nmos L=0.13u W=0.42u AS=0.0378p AD=0.1428p PS=0.6u
+ PD=1.52u
M$1207 741 705 1 1 sg13_lv_nmos L=0.13u W=0.42u AS=0.1428p AD=0.0798p PS=1.52u
+ PD=0.8u
M$1208 1 682 750 1 sg13_lv_nmos L=0.13u W=0.42u AS=0.0798p AD=0.0378p PS=0.8u
+ PD=0.6u
M$1209 750 728 705 1 sg13_lv_nmos L=0.13u W=0.42u AS=0.0378p AD=0.1428p PS=0.6u
+ PD=1.52u
M$1210 706 728 1 1 sg13_lv_nmos L=0.13u W=0.74u AS=0.2516p AD=0.1406p PS=2.16u
+ PD=1.12u
M$1211 1 706 724 1 sg13_lv_nmos L=0.13u W=0.74u AS=0.1406p AD=0.2516p PS=1.12u
+ PD=2.16u
M$1215 1 709 708 1 sg13_lv_nmos L=0.13u W=0.74u AS=0.1626p AD=0.2516p PS=1.415u
+ PD=2.16u
M$1216 707 653 751 1 sg13_lv_nmos L=0.13u W=0.42u AS=0.1428p AD=0.0609p
+ PS=1.52u PD=0.71u
M$1217 1 637 751 1 sg13_lv_nmos L=0.13u W=0.42u AS=0.1626p AD=0.0609p PS=1.415u
+ PD=0.71u
M$1218 1 637 752 1 sg13_lv_nmos L=0.13u W=0.42u AS=0.1701p AD=0.0378p PS=1.65u
+ PD=0.6u
M$1219 752 708 731 1 sg13_lv_nmos L=0.13u W=0.42u AS=0.0378p AD=0.1428p PS=0.6u
+ PD=1.52u
M$1220 742 711 1 1 sg13_lv_nmos L=0.13u W=0.42u AS=0.1428p AD=0.0798p PS=1.52u
+ PD=0.8u
M$1221 1 637 753 1 sg13_lv_nmos L=0.13u W=0.42u AS=0.0798p AD=0.0378p PS=0.8u
+ PD=0.6u
M$1222 753 733 711 1 sg13_lv_nmos L=0.13u W=0.42u AS=0.0378p AD=0.1428p PS=0.6u
+ PD=1.52u
M$1223 712 733 1 1 sg13_lv_nmos L=0.13u W=0.74u AS=0.2516p AD=0.1406p PS=2.16u
+ PD=1.12u
M$1224 1 712 713 1 sg13_lv_nmos L=0.13u W=0.74u AS=0.1406p AD=0.2516p PS=1.12u
+ PD=2.16u
M$1229 717 718 1 1 sg13_lv_nmos L=0.13u W=0.74u AS=0.2516p AD=0.2516p PS=2.16u
+ PD=2.16u
M$1230 718 761 1 1 sg13_lv_nmos L=0.13u W=0.74u AS=0.2886p AD=0.14875p PS=2.26u
+ PD=1.16u
M$1231 1 570 761 1 sg13_lv_nmos L=0.13u W=0.55u AS=0.14875p AD=0.187p PS=1.16u
+ PD=1.78u
M$1232 762 632 798 1 sg13_lv_nmos L=0.13u W=0.42u AS=0.1428p AD=0.0609p
+ PS=1.52u PD=0.71u
M$1233 798 681 1 1 sg13_lv_nmos L=0.13u W=0.42u AS=0.0609p AD=0.1626p PS=0.71u
+ PD=1.415u
M$1234 1 807 754 1 sg13_lv_nmos L=0.13u W=0.74u AS=0.1626p AD=0.2516p PS=1.415u
+ PD=2.16u
M$1235 1 681 799 1 sg13_lv_nmos L=0.13u W=0.42u AS=0.1701p AD=0.0378p PS=1.65u
+ PD=0.6u
M$1236 799 754 763 1 sg13_lv_nmos L=0.13u W=0.42u AS=0.0378p AD=0.1428p PS=0.6u
+ PD=1.52u
M$1237 1 755 816 1 sg13_lv_nmos L=0.13u W=0.74u AS=0.317325p AD=0.2516p
+ PS=1.805u PD=2.16u
M$1238 1 595 755 1 sg13_lv_nmos L=0.13u W=0.74u AS=0.317325p AD=0.2516p
+ PS=1.805u PD=2.16u
M$1239 765 755 764 1 sg13_lv_nmos L=0.13u W=0.42u AS=0.12665p AD=0.1428p
+ PS=1.145u PD=1.52u
M$1240 754 816 765 1 sg13_lv_nmos L=0.13u W=0.74u AS=0.3473p AD=0.12665p
+ PS=2.71u PD=1.145u
M$1241 764 766 1 1 sg13_lv_nmos L=0.13u W=0.42u AS=0.1428p AD=0.0798p PS=1.52u
+ PD=0.8u
M$1242 1 681 801 1 sg13_lv_nmos L=0.13u W=0.42u AS=0.0798p AD=0.0378p PS=0.8u
+ PD=0.6u
M$1243 801 765 766 1 sg13_lv_nmos L=0.13u W=0.42u AS=0.0378p AD=0.1428p PS=0.6u
+ PD=1.52u
M$1244 767 765 1 1 sg13_lv_nmos L=0.13u W=0.74u AS=0.2516p AD=0.1406p PS=2.16u
+ PD=1.12u
M$1245 1 767 646 1 sg13_lv_nmos L=0.13u W=0.74u AS=0.1406p AD=0.2516p PS=1.12u
+ PD=2.16u
M$1246 1 694 768 1 sg13_lv_nmos L=0.13u W=0.55u AS=0.374p AD=0.174625p PS=2.46u
+ PD=1.185u
M$1247 1 697 768 1 sg13_lv_nmos L=0.13u W=0.55u AS=0.15245p AD=0.174625p
+ PS=1.17u PD=1.185u
M$1248 1 694 813 1 sg13_lv_nmos L=0.13u W=0.74u AS=0.15245p AD=0.0888p PS=1.17u
+ PD=0.98u
M$1249 813 697 769 1 sg13_lv_nmos L=0.13u W=0.74u AS=0.0888p AD=0.1628p
+ PS=0.98u PD=1.18u
M$1250 769 768 1 1 sg13_lv_nmos L=0.13u W=0.74u AS=0.1628p AD=0.3108p PS=1.18u
+ PD=2.32u
M$1251 1 724 814 1 sg13_lv_nmos L=0.13u W=0.64u AS=0.2272p AD=0.0784p PS=1.99u
+ PD=0.885u
M$1252 814 725 770 1 sg13_lv_nmos L=0.13u W=0.64u AS=0.0784p AD=0.2176p
+ PS=0.885u PD=1.96u
M$1253 1 724 771 1 sg13_lv_nmos L=0.13u W=0.74u AS=0.1898p AD=0.2516p PS=1.36u
+ PD=2.16u
M$1254 1 725 771 1 sg13_lv_nmos L=0.13u W=0.74u AS=0.1898p AD=0.1406p PS=1.36u
+ PD=1.12u
M$1255 771 770 671 1 sg13_lv_nmos L=0.13u W=0.74u AS=0.1406p AD=0.2516p
+ PS=1.12u PD=2.16u
M$1257 1 650 815 1 sg13_lv_nmos L=0.13u W=0.64u AS=0.2272p AD=0.0784p PS=1.99u
+ PD=0.885u
M$1258 815 769 772 1 sg13_lv_nmos L=0.13u W=0.64u AS=0.0784p AD=0.2176p
+ PS=0.885u PD=1.96u
M$1259 1 650 773 1 sg13_lv_nmos L=0.13u W=0.74u AS=0.1898p AD=0.2516p PS=1.36u
+ PD=2.16u
M$1260 1 769 773 1 sg13_lv_nmos L=0.13u W=0.74u AS=0.1898p AD=0.1406p PS=1.36u
+ PD=1.12u
M$1261 773 772 774 1 sg13_lv_nmos L=0.13u W=0.74u AS=0.1406p AD=0.2516p
+ PS=1.12u PD=2.16u
M$1262 1 718 682 1 sg13_lv_nmos L=0.13u W=0.74u AS=0.2516p AD=0.2516p PS=2.16u
+ PD=2.16u
M$1263 1 718 775 1 sg13_lv_nmos L=0.13u W=0.74u AS=0.2516p AD=0.2516p PS=2.16u
+ PD=2.16u
M$1264 776 774 806 1 sg13_lv_nmos L=0.13u W=0.42u AS=0.1428p AD=0.0609p
+ PS=1.52u PD=0.71u
M$1265 806 775 1 1 sg13_lv_nmos L=0.13u W=0.42u AS=0.0609p AD=0.1626p PS=0.71u
+ PD=1.415u
M$1266 1 808 756 1 sg13_lv_nmos L=0.13u W=0.74u AS=0.1626p AD=0.2516p PS=1.415u
+ PD=2.16u
M$1267 1 775 805 1 sg13_lv_nmos L=0.13u W=0.42u AS=0.1701p AD=0.0378p PS=1.65u
+ PD=0.6u
M$1268 805 756 777 1 sg13_lv_nmos L=0.13u W=0.42u AS=0.0378p AD=0.1428p PS=0.6u
+ PD=1.52u
M$1269 1 757 817 1 sg13_lv_nmos L=0.13u W=0.74u AS=0.317325p AD=0.2516p
+ PS=1.805u PD=2.16u
M$1270 1 247 757 1 sg13_lv_nmos L=0.13u W=0.74u AS=0.317325p AD=0.2516p
+ PS=1.805u PD=2.16u
M$1271 779 757 778 1 sg13_lv_nmos L=0.13u W=0.42u AS=0.12665p AD=0.1428p
+ PS=1.145u PD=1.52u
M$1272 756 817 779 1 sg13_lv_nmos L=0.13u W=0.74u AS=0.3473p AD=0.12665p
+ PS=2.71u PD=1.145u
M$1273 778 780 1 1 sg13_lv_nmos L=0.13u W=0.42u AS=0.1428p AD=0.0798p PS=1.52u
+ PD=0.8u
M$1274 1 775 804 1 sg13_lv_nmos L=0.13u W=0.42u AS=0.0798p AD=0.0378p PS=0.8u
+ PD=0.6u
M$1275 804 779 780 1 sg13_lv_nmos L=0.13u W=0.42u AS=0.0378p AD=0.1428p PS=0.6u
+ PD=1.52u
M$1276 781 779 1 1 sg13_lv_nmos L=0.13u W=0.74u AS=0.2516p AD=0.1406p PS=2.16u
+ PD=1.12u
M$1277 1 781 723 1 sg13_lv_nmos L=0.13u W=0.74u AS=0.1406p AD=0.2516p PS=1.12u
+ PD=2.16u
M$1278 782 463 1 1 sg13_lv_nmos L=0.13u W=0.74u AS=0.2516p AD=0.2516p PS=2.16u
+ PD=2.16u
M$1279 783 685 803 1 sg13_lv_nmos L=0.13u W=0.42u AS=0.1428p AD=0.0609p
+ PS=1.52u PD=0.71u
M$1280 803 684 1 1 sg13_lv_nmos L=0.13u W=0.42u AS=0.0609p AD=0.1626p PS=0.71u
+ PD=1.415u
M$1281 1 809 758 1 sg13_lv_nmos L=0.13u W=0.74u AS=0.1626p AD=0.2516p PS=1.415u
+ PD=2.16u
M$1282 1 684 802 1 sg13_lv_nmos L=0.13u W=0.42u AS=0.1701p AD=0.0378p PS=1.65u
+ PD=0.6u
M$1283 802 758 784 1 sg13_lv_nmos L=0.13u W=0.42u AS=0.0378p AD=0.1428p PS=0.6u
+ PD=1.52u
M$1284 1 759 818 1 sg13_lv_nmos L=0.13u W=0.74u AS=0.317325p AD=0.2516p
+ PS=1.805u PD=2.16u
M$1285 1 729 759 1 sg13_lv_nmos L=0.13u W=0.74u AS=0.317325p AD=0.2516p
+ PS=1.805u PD=2.16u
M$1286 786 759 785 1 sg13_lv_nmos L=0.13u W=0.42u AS=0.12665p AD=0.1428p
+ PS=1.145u PD=1.52u
M$1287 758 818 786 1 sg13_lv_nmos L=0.13u W=0.74u AS=0.3473p AD=0.12665p
+ PS=2.71u PD=1.145u
M$1288 785 787 1 1 sg13_lv_nmos L=0.13u W=0.42u AS=0.1428p AD=0.0798p PS=1.52u
+ PD=0.8u
M$1289 1 684 800 1 sg13_lv_nmos L=0.13u W=0.42u AS=0.0798p AD=0.0378p PS=0.8u
+ PD=0.6u
M$1290 800 786 787 1 sg13_lv_nmos L=0.13u W=0.42u AS=0.0378p AD=0.1428p PS=0.6u
+ PD=1.52u
M$1291 788 786 1 1 sg13_lv_nmos L=0.13u W=0.74u AS=0.2516p AD=0.1406p PS=2.16u
+ PD=1.12u
M$1292 1 788 730 1 sg13_lv_nmos L=0.13u W=0.74u AS=0.1406p AD=0.2516p PS=1.12u
+ PD=2.16u
M$1294 638 789 1 1 sg13_lv_nmos L=0.13u W=0.74u AS=0.2516p AD=0.1406p PS=2.16u
+ PD=1.12u
M$1295 1 810 789 1 sg13_lv_nmos L=0.13u W=0.74u AS=0.1406p AD=0.2516p PS=1.12u
+ PD=2.16u
M$1296 790 810 797 1 sg13_lv_nmos L=0.13u W=0.42u AS=0.1428p AD=0.0378p
+ PS=1.52u PD=0.6u
M$1297 797 686 1 1 sg13_lv_nmos L=0.13u W=0.42u AS=0.0378p AD=0.0798p PS=0.6u
+ PD=0.8u
M$1298 1 790 791 1 sg13_lv_nmos L=0.13u W=0.42u AS=0.0798p AD=0.1428p PS=0.8u
+ PD=1.52u
M$1299 760 793 810 1 sg13_lv_nmos L=0.13u W=0.74u AS=0.3473p AD=0.12665p
+ PS=2.71u PD=1.145u
M$1300 810 792 791 1 sg13_lv_nmos L=0.13u W=0.42u AS=0.12665p AD=0.1428p
+ PS=1.145u PD=1.52u
M$1301 1 730 792 1 sg13_lv_nmos L=0.13u W=0.74u AS=0.317325p AD=0.2516p
+ PS=1.805u PD=2.16u
M$1302 1 792 793 1 sg13_lv_nmos L=0.13u W=0.74u AS=0.317325p AD=0.2516p
+ PS=1.805u PD=2.16u
M$1303 794 760 796 1 sg13_lv_nmos L=0.13u W=0.42u AS=0.1428p AD=0.0378p
+ PS=1.52u PD=0.6u
M$1304 796 686 1 1 sg13_lv_nmos L=0.13u W=0.42u AS=0.0378p AD=0.1701p PS=0.6u
+ PD=1.65u
M$1305 1 686 795 1 sg13_lv_nmos L=0.13u W=0.42u AS=0.1626p AD=0.0609p PS=1.415u
+ PD=0.71u
M$1306 795 687 811 1 sg13_lv_nmos L=0.13u W=0.42u AS=0.0609p AD=0.1428p
+ PS=0.71u PD=1.52u
M$1307 1 812 760 1 sg13_lv_nmos L=0.13u W=0.74u AS=0.1626p AD=0.2516p PS=1.415u
+ PD=2.16u
M$1309 833 819 1 1 sg13_lv_nmos L=0.13u W=0.55u AS=0.187p AD=0.14875p PS=1.78u
+ PD=1.16u
M$1310 1 833 570 1 sg13_lv_nmos L=0.13u W=0.74u AS=0.14875p AD=0.2886p PS=1.16u
+ PD=2.26u
M$1312 1 97 832 1 sg13_lv_nmos L=0.13u W=0.55u AS=0.18945p AD=0.187p PS=1.27u
+ PD=1.78u
M$1313 719 849 1 1 sg13_lv_nmos L=0.13u W=0.74u AS=0.4033p AD=0.148p PS=2.57u
+ PD=1.14u
M$1314 1 832 853 1 sg13_lv_nmos L=0.13u W=0.74u AS=0.148p AD=0.3367p PS=1.14u
+ PD=1.65u
M$1315 853 694 849 1 sg13_lv_nmos L=0.13u W=0.74u AS=0.3367p AD=0.1628p
+ PS=1.65u PD=1.18u
M$1316 849 646 854 1 sg13_lv_nmos L=0.13u W=0.74u AS=0.1628p AD=0.13135p
+ PS=1.18u PD=1.095u
M$1317 854 97 1 1 sg13_lv_nmos L=0.13u W=0.74u AS=0.13135p AD=0.18945p
+ PS=1.095u PD=1.27u
M$1318 762 755 807 1 sg13_lv_nmos L=0.13u W=0.42u AS=0.1296p AD=0.0798p
+ PS=1.52u PD=0.8u
M$1319 807 816 763 1 sg13_lv_nmos L=0.13u W=0.42u AS=0.0798p AD=0.2373p PS=0.8u
+ PD=1.97u
M$1324 1 646 855 1 sg13_lv_nmos L=0.13u W=0.64u AS=0.2272p AD=0.0784p PS=1.99u
+ PD=0.885u
M$1325 855 723 834 1 sg13_lv_nmos L=0.13u W=0.64u AS=0.0784p AD=0.2176p
+ PS=0.885u PD=1.96u
M$1326 852 646 1 1 sg13_lv_nmos L=0.13u W=0.74u AS=0.2516p AD=0.1898p PS=2.16u
+ PD=1.36u
M$1327 1 723 852 1 sg13_lv_nmos L=0.13u W=0.74u AS=0.1898p AD=0.1406p PS=1.36u
+ PD=1.12u
M$1328 852 834 725 1 sg13_lv_nmos L=0.13u W=0.74u AS=0.1406p AD=0.2516p
+ PS=1.12u PD=2.16u
M$1341 776 757 808 1 sg13_lv_nmos L=0.13u W=0.42u AS=0.1296p AD=0.0798p
+ PS=1.52u PD=0.8u
M$1342 808 817 777 1 sg13_lv_nmos L=0.13u W=0.42u AS=0.0798p AD=0.2373p PS=0.8u
+ PD=1.97u
M$1343 835 570 1 1 sg13_lv_nmos L=0.13u W=0.55u AS=0.187p AD=0.14875p PS=1.78u
+ PD=1.16u
M$1344 1 835 104 1 sg13_lv_nmos L=0.13u W=0.74u AS=0.14875p AD=0.2886p PS=1.16u
+ PD=2.26u
M$1345 1 837 838 1 sg13_lv_nmos L=0.13u W=0.74u AS=0.1626p AD=0.2516p PS=1.415u
+ PD=2.16u
M$1346 836 683 858 1 sg13_lv_nmos L=0.13u W=0.42u AS=0.1428p AD=0.0609p
+ PS=1.52u PD=0.71u
M$1347 1 782 858 1 sg13_lv_nmos L=0.13u W=0.42u AS=0.1626p AD=0.0609p PS=1.415u
+ PD=0.71u
M$1348 1 782 857 1 sg13_lv_nmos L=0.13u W=0.42u AS=0.1701p AD=0.0378p PS=1.65u
+ PD=0.6u
M$1349 857 838 850 1 sg13_lv_nmos L=0.13u W=0.42u AS=0.0378p AD=0.1428p PS=0.6u
+ PD=1.52u
M$1350 463 859 1 1 sg13_lv_nmos L=0.13u W=0.74u AS=0.2886p AD=0.14875p PS=2.26u
+ PD=1.16u
M$1351 1 104 859 1 sg13_lv_nmos L=0.13u W=0.55u AS=0.14875p AD=0.187p PS=1.16u
+ PD=1.78u
M$1352 836 840 837 1 sg13_lv_nmos L=0.13u W=0.42u AS=0.1296p AD=0.0798p
+ PS=1.52u PD=0.8u
M$1353 837 839 850 1 sg13_lv_nmos L=0.13u W=0.42u AS=0.0798p AD=0.2373p PS=0.8u
+ PD=1.97u
M$1354 839 840 1 1 sg13_lv_nmos L=0.13u W=0.74u AS=0.2516p AD=0.317325p
+ PS=2.16u PD=1.805u
M$1355 1 1 840 1 sg13_lv_nmos L=0.13u W=0.74u AS=0.317325p AD=0.2516p PS=1.805u
+ PD=2.16u
M$1356 851 840 841 1 sg13_lv_nmos L=0.13u W=0.42u AS=0.1428p AD=0.12665p
+ PS=1.52u PD=1.145u
M$1357 841 839 838 1 sg13_lv_nmos L=0.13u W=0.74u AS=0.12665p AD=0.3473p
+ PS=1.145u PD=2.71u
M$1358 851 842 1 1 sg13_lv_nmos L=0.13u W=0.42u AS=0.1428p AD=0.0798p PS=1.52u
+ PD=0.8u
M$1359 1 782 856 1 sg13_lv_nmos L=0.13u W=0.42u AS=0.0798p AD=0.0378p PS=0.8u
+ PD=0.6u
M$1360 856 841 842 1 sg13_lv_nmos L=0.13u W=0.42u AS=0.0378p AD=0.1428p PS=0.6u
+ PD=1.52u
M$1361 783 759 809 1 sg13_lv_nmos L=0.13u W=0.42u AS=0.1296p AD=0.0798p
+ PS=1.52u PD=0.8u
M$1362 809 818 784 1 sg13_lv_nmos L=0.13u W=0.42u AS=0.0798p AD=0.2373p PS=0.8u
+ PD=1.97u
M$1363 843 841 1 1 sg13_lv_nmos L=0.13u W=0.74u AS=0.2516p AD=0.1406p PS=2.16u
+ PD=1.12u
M$1364 1 843 729 1 sg13_lv_nmos L=0.13u W=0.74u AS=0.1406p AD=0.2516p PS=1.12u
+ PD=2.16u
M$1377 794 793 812 1 sg13_lv_nmos L=0.13u W=0.42u AS=0.2373p AD=0.0798p
+ PS=1.97u PD=0.8u
M$1378 812 792 811 1 sg13_lv_nmos L=0.13u W=0.42u AS=0.0798p AD=0.1296p PS=0.8u
+ PD=1.52u
M$1427 1 862 861 1 sg13_lv_nmos L=0.15u W=60u AS=11.55p AD=11.55p PS=84.1u
+ PD=84.1u
M$1487 861 863 860 1 sg13_lv_nmos L=0.5u W=24u AS=4.86p AD=4.86p PS=30.86u
+ PD=30.86u
M$1499 1 1 860 1 sg13_lv_nmos L=0.13u W=1.48u AS=0.3922p AD=0.3922p PS=3.28u
+ PD=3.28u
M$1501 861 860 863 1 sg13_lv_nmos L=0.5u W=24u AS=4.86p AD=4.86p PS=30.86u
+ PD=30.86u
M$1513 862 862 1 1 sg13_lv_nmos L=0.15u W=1u AS=0.34p AD=0.34p PS=2.68u PD=2.68u
M$1514 866 877 874 1 sg13_lv_nmos L=0.13u W=0.42u AS=0.1428p AD=0.0609p
+ PS=1.52u PD=0.71u
M$1515 874 879 1 1 sg13_lv_nmos L=0.13u W=0.42u AS=0.0609p AD=0.1626p PS=0.71u
+ PD=1.415u
M$1516 1 878 864 1 sg13_lv_nmos L=0.13u W=0.74u AS=0.1626p AD=0.2516p PS=1.415u
+ PD=2.16u
M$1517 868 880 1 1 sg13_lv_nmos L=0.13u W=0.42u AS=0.1428p AD=0.0798p PS=1.52u
+ PD=0.8u
M$1518 1 879 876 1 sg13_lv_nmos L=0.13u W=0.42u AS=0.0798p AD=0.0378p PS=0.8u
+ PD=0.6u
M$1519 876 869 880 1 sg13_lv_nmos L=0.13u W=0.42u AS=0.0378p AD=0.1428p PS=0.6u
+ PD=1.52u
M$1520 1 869 871 1 sg13_lv_nmos L=0.13u W=0.64u AS=0.1331p AD=0.2176p PS=1.12u
+ PD=1.96u
M$1521 1 869 870 1 sg13_lv_nmos L=0.13u W=1.48u AS=0.3922p AD=0.2737p PS=3.28u
+ PD=2.24u
M$1523 1 871 872 1 sg13_lv_nmos L=0.13u W=1.48u AS=0.3922p AD=0.3922p PS=3.28u
+ PD=3.28u
M$1525 1 879 875 1 sg13_lv_nmos L=0.13u W=0.42u AS=0.1701p AD=0.03885p PS=1.65u
+ PD=0.605u
M$1526 875 864 867 1 sg13_lv_nmos L=0.13u W=0.42u AS=0.03885p AD=0.1596p
+ PS=0.605u PD=1.6u
M$1527 866 865 878 1 sg13_lv_nmos L=0.13u W=0.42u AS=0.1296p AD=0.081p PS=1.52u
+ PD=0.81u
M$1528 878 881 867 1 sg13_lv_nmos L=0.13u W=0.42u AS=0.081p AD=0.2163p PS=0.81u
+ PD=1.87u
M$1529 1 865 881 1 sg13_lv_nmos L=0.13u W=0.74u AS=0.43315p AD=0.2516p
+ PS=2.205u PD=2.16u
M$1530 1 60 865 1 sg13_lv_nmos L=0.13u W=0.74u AS=0.43315p AD=0.2516p PS=2.205u
+ PD=2.16u
M$1531 869 865 868 1 sg13_lv_nmos L=0.13u W=0.42u AS=0.12665p AD=0.1428p
+ PS=1.145u PD=1.52u
M$1532 864 881 869 1 sg13_lv_nmos L=0.13u W=0.74u AS=0.3473p AD=0.12665p
+ PS=2.71u PD=1.145u
M$1533 873 872 1 1 sg13_lv_nmos L=0.13u W=1.44u AS=0.4068p AD=0.2772p PS=3.29u
+ PD=2.21u
M$1535 873 890 879 1 sg13_lv_nmos L=0.13u W=1.44u AS=0.2772p AD=0.3816p
+ PS=2.21u PD=3.22u
M$1537 884 877 897 1 sg13_lv_nmos L=0.13u W=0.42u AS=0.1428p AD=0.0609p
+ PS=1.52u PD=0.71u
M$1538 897 879 1 1 sg13_lv_nmos L=0.13u W=0.42u AS=0.0609p AD=0.1626p PS=0.71u
+ PD=1.415u
M$1539 1 892 885 1 sg13_lv_nmos L=0.13u W=0.74u AS=0.1626p AD=0.2516p PS=1.415u
+ PD=2.16u
M$1540 887 896 1 1 sg13_lv_nmos L=0.13u W=0.42u AS=0.1428p AD=0.0798p PS=1.52u
+ PD=0.8u
M$1541 1 879 899 1 sg13_lv_nmos L=0.13u W=0.42u AS=0.0798p AD=0.0378p PS=0.8u
+ PD=0.6u
M$1542 899 895 896 1 sg13_lv_nmos L=0.13u W=0.42u AS=0.0378p AD=0.1428p PS=0.6u
+ PD=1.52u
M$1543 1 895 889 1 sg13_lv_nmos L=0.13u W=0.64u AS=0.1331p AD=0.2176p PS=1.12u
+ PD=1.96u
M$1544 1 895 888 1 sg13_lv_nmos L=0.13u W=1.48u AS=0.3922p AD=0.2737p PS=3.28u
+ PD=2.24u
M$1546 1 889 890 1 sg13_lv_nmos L=0.13u W=1.48u AS=0.3922p AD=0.3922p PS=3.28u
+ PD=3.28u
M$1548 1 879 898 1 sg13_lv_nmos L=0.13u W=0.42u AS=0.1701p AD=0.03885p PS=1.65u
+ PD=0.605u
M$1549 898 885 893 1 sg13_lv_nmos L=0.13u W=0.42u AS=0.03885p AD=0.1596p
+ PS=0.605u PD=1.6u
M$1550 884 886 892 1 sg13_lv_nmos L=0.13u W=0.42u AS=0.1296p AD=0.081p PS=1.52u
+ PD=0.81u
M$1551 892 900 893 1 sg13_lv_nmos L=0.13u W=0.42u AS=0.081p AD=0.2163p PS=0.81u
+ PD=1.87u
M$1552 1 886 900 1 sg13_lv_nmos L=0.13u W=0.74u AS=0.43315p AD=0.2516p
+ PS=2.205u PD=2.16u
M$1553 1 894 886 1 sg13_lv_nmos L=0.13u W=0.74u AS=0.43315p AD=0.2516p
+ PS=2.205u PD=2.16u
M$1554 895 886 887 1 sg13_lv_nmos L=0.13u W=0.42u AS=0.12665p AD=0.1428p
+ PS=1.145u PD=1.52u
M$1555 885 900 895 1 sg13_lv_nmos L=0.13u W=0.74u AS=0.3473p AD=0.12665p
+ PS=2.71u PD=1.145u
M$1556 1 890 891 1 sg13_lv_nmos L=0.13u W=1.48u AS=0.3922p AD=0.3922p PS=3.28u
+ PD=3.28u
M$1558 1 3 908 1 sg13_lv_nmos L=2u W=3u AS=1.02p AD=1.02p PS=6.68u PD=6.68u
M$1559 908 909 909 1 sg13_lv_nmos L=2u W=3u AS=1.02p AD=1.02p PS=6.68u PD=6.68u
M$1560 1 872 911 1 sg13_lv_nmos L=2u W=3u AS=1.02p AD=1.02p PS=6.68u PD=6.68u
M$1561 911 909 904 1 sg13_lv_nmos L=2u W=3u AS=1.02p AD=1.02p PS=6.68u PD=6.68u
M$1562 3 4 2 3 sg13_lv_pmos L=0.13u W=1.12u AS=0.3808p AD=0.3808p PS=2.92u
+ PD=2.92u
M$1563 3 1 3 3 sg13_lv_pmos L=1u W=517u AS=140.23p AD=140.23p PS=1077.46u
+ PD=1077.46u
M$1612 8 27 3 3 sg13_lv_pmos L=0.13u W=1.12u AS=0.3864p AD=0.2128p PS=2.93u
+ PD=1.5u
M$1613 3 8 9 3 sg13_lv_pmos L=0.13u W=1.12u AS=0.2128p AD=0.3808p PS=1.5u
+ PD=2.92u
M$1617 3 12 11 3 sg13_lv_pmos L=0.13u W=0.84u AS=0.2891p AD=0.1596p PS=1.695u
+ PD=1.22u
M$1618 11 68 3 3 sg13_lv_pmos L=0.13u W=0.84u AS=0.1596p AD=0.4536p PS=1.22u
+ PD=2.76u
M$1619 3 11 10 3 sg13_lv_pmos L=0.13u W=1.12u AS=0.3808p AD=0.2408p PS=2.92u
+ PD=1.55u
M$1620 10 12 36 3 sg13_lv_pmos L=0.13u W=1.12u AS=0.2408p AD=0.1428p PS=1.55u
+ PD=1.375u
M$1621 36 68 3 3 sg13_lv_pmos L=0.13u W=1.12u AS=0.1428p AD=0.2891p PS=1.375u
+ PD=1.695u
M$1622 12 14 13 3 sg13_lv_pmos L=0.13u W=1.12u AS=0.3808p AD=0.2128p PS=2.92u
+ PD=1.5u
M$1623 13 29 3 3 sg13_lv_pmos L=0.13u W=1.12u AS=0.2128p AD=0.2128p PS=1.5u
+ PD=1.5u
M$1624 3 30 13 3 sg13_lv_pmos L=0.13u W=1.12u AS=0.2128p AD=0.3808p PS=1.5u
+ PD=2.92u
M$1625 14 29 38 3 sg13_lv_pmos L=0.13u W=1u AS=0.34p AD=0.1225p PS=2.68u
+ PD=1.245u
M$1626 38 30 3 3 sg13_lv_pmos L=0.13u W=1u AS=0.1225p AD=0.36p PS=1.245u
+ PD=2.72u
M$1628 3 30 39 3 sg13_lv_pmos L=0.13u W=1.12u AS=0.4032p AD=0.1176p PS=2.96u
+ PD=1.33u
M$1629 39 29 15 3 sg13_lv_pmos L=0.13u W=1.12u AS=0.1176p AD=0.3808p PS=1.33u
+ PD=2.92u
M$1630 16 165 3 3 sg13_lv_pmos L=0.13u W=1u AS=0.34p AD=0.19p PS=2.68u PD=1.38u
M$1631 3 2 16 3 sg13_lv_pmos L=0.13u W=1u AS=0.19p AD=0.2125p PS=1.38u PD=1.425u
M$1632 16 31 17 3 sg13_lv_pmos L=0.13u W=1u AS=0.2125p AD=0.35p PS=1.425u
+ PD=2.7u
M$1633 3 17 18 3 sg13_lv_pmos L=0.13u W=2.24u AS=0.5936p AD=0.5936p PS=4.42u
+ PD=4.42u
M$1635 3 15 40 3 sg13_lv_pmos L=0.13u W=1.12u AS=0.4032p AD=0.1176p PS=2.96u
+ PD=1.33u
M$1636 40 166 31 3 sg13_lv_pmos L=0.13u W=1.12u AS=0.1176p AD=0.3808p PS=1.33u
+ PD=2.92u
M$1640 3 9 37 3 sg13_lv_pmos L=0.13u W=1u AS=0.36p AD=0.1225p PS=2.72u PD=1.245u
M$1641 37 30 19 3 sg13_lv_pmos L=0.13u W=1u AS=0.1225p AD=0.34p PS=1.245u
+ PD=2.68u
M$1642 20 9 3 3 sg13_lv_pmos L=0.13u W=1.12u AS=0.3808p AD=0.2128p PS=2.92u
+ PD=1.5u
M$1643 3 30 20 3 sg13_lv_pmos L=0.13u W=1.12u AS=0.2128p AD=0.2128p PS=1.5u
+ PD=1.5u
M$1644 20 19 21 3 sg13_lv_pmos L=0.13u W=1.12u AS=0.2128p AD=0.3808p PS=1.5u
+ PD=2.92u
M$1645 22 21 3 3 sg13_lv_pmos L=0.13u W=1.12u AS=0.3808p AD=0.2128p PS=2.92u
+ PD=1.5u
M$1646 3 32 22 3 sg13_lv_pmos L=0.13u W=1.12u AS=0.2128p AD=0.2128p PS=1.5u
+ PD=1.5u
M$1647 22 33 23 3 sg13_lv_pmos L=0.13u W=1.12u AS=0.2128p AD=0.3808p PS=1.5u
+ PD=2.92u
M$1664 3 96 24 3 sg13_lv_pmos L=0.13u W=1.12u AS=0.3808p AD=0.3808p PS=2.92u
+ PD=2.92u
M$1665 3 96 61 3 sg13_lv_pmos L=0.13u W=1.12u AS=0.3808p AD=0.3808p PS=2.92u
+ PD=2.92u
M$1666 62 97 3 3 sg13_lv_pmos L=0.13u W=0.84u AS=0.2856p AD=0.253p PS=2.36u
+ PD=1.53u
M$1667 3 97 121 3 sg13_lv_pmos L=0.13u W=1u AS=0.253p AD=0.3325p PS=1.53u
+ PD=1.665u
M$1668 121 9 53 3 sg13_lv_pmos L=0.13u W=1u AS=0.3325p AD=0.2225p PS=1.665u
+ PD=1.445u
M$1669 53 68 122 3 sg13_lv_pmos L=0.13u W=1u AS=0.2225p AD=0.2975p PS=1.445u
+ PD=1.595u
M$1670 122 62 3 3 sg13_lv_pmos L=0.13u W=1u AS=0.2975p AD=0.2198p PS=1.595u
+ PD=1.52u
M$1671 3 53 41 3 sg13_lv_pmos L=0.13u W=1.12u AS=0.2198p AD=0.6048p PS=1.52u
+ PD=3.32u
M$1672 3 41 5 3 sg13_lv_pmos L=0.13u W=0.42u AS=0.1428p AD=0.0798p PS=1.52u
+ PD=0.8u
M$1673 3 24 5 3 sg13_lv_pmos L=0.13u W=0.42u AS=0.3623875p AD=0.0798p PS=2.605u
+ PD=0.8u
M$1674 3 7 6 3 sg13_lv_pmos L=0.13u W=1u AS=0.3623875p AD=0.34p PS=2.605u
+ PD=2.68u
M$1675 3 24 7 3 sg13_lv_pmos L=0.13u W=0.42u AS=0.1563p AD=0.147p PS=1.22u
+ PD=1.54u
M$1676 3 6 34 3 sg13_lv_pmos L=0.13u W=0.42u AS=0.1563p AD=0.063p PS=1.22u
+ PD=0.72u
M$1677 34 26 7 3 sg13_lv_pmos L=0.13u W=0.42u AS=0.063p AD=0.0798p PS=0.72u
+ PD=0.8u
M$1678 7 25 5 3 sg13_lv_pmos L=0.13u W=0.42u AS=0.0798p AD=0.1428p PS=0.8u
+ PD=1.52u
M$1679 3 26 25 3 sg13_lv_pmos L=0.13u W=1.12u AS=0.41165p AD=0.3864p PS=2.12u
+ PD=2.93u
M$1680 3 210 26 3 sg13_lv_pmos L=0.13u W=1.12u AS=0.41165p AD=0.4088p PS=2.12u
+ PD=2.97u
M$1681 6 26 27 3 sg13_lv_pmos L=0.13u W=1u AS=0.34p AD=0.2048p PS=2.68u PD=1.63u
M$1682 27 25 35 3 sg13_lv_pmos L=0.13u W=0.42u AS=0.2048p AD=0.09345p PS=1.63u
+ PD=0.865u
M$1683 3 28 35 3 sg13_lv_pmos L=0.13u W=0.42u AS=0.204p AD=0.09345p PS=1.835u
+ PD=0.865u
M$1684 3 24 28 3 sg13_lv_pmos L=0.13u W=0.42u AS=0.204p AD=0.0798p PS=1.835u
+ PD=0.8u
M$1685 3 27 28 3 sg13_lv_pmos L=0.13u W=0.42u AS=0.4659p AD=0.0798p PS=3.65u
+ PD=0.8u
M$1686 115 55 3 3 sg13_lv_pmos L=0.13u W=1.12u AS=0.3864p AD=0.41165p PS=2.93u
+ PD=2.12u
M$1687 3 210 55 3 sg13_lv_pmos L=0.13u W=1.12u AS=0.41165p AD=0.4088p PS=2.12u
+ PD=2.97u
M$1688 100 115 124 3 sg13_lv_pmos L=0.13u W=0.42u AS=0.2048p AD=0.09345p
+ PS=1.63u PD=0.865u
M$1689 124 66 3 3 sg13_lv_pmos L=0.13u W=0.42u AS=0.09345p AD=0.204p PS=0.865u
+ PD=1.835u
M$1690 3 61 66 3 sg13_lv_pmos L=0.13u W=0.42u AS=0.204p AD=0.0798p PS=1.835u
+ PD=0.8u
M$1691 66 100 3 3 sg13_lv_pmos L=0.13u W=0.42u AS=0.0798p AD=0.4659p PS=0.8u
+ PD=3.65u
M$1692 54 55 100 3 sg13_lv_pmos L=0.13u W=1u AS=0.34p AD=0.2048p PS=2.68u
+ PD=1.63u
M$1693 67 100 3 3 sg13_lv_pmos L=0.13u W=1.12u AS=0.3864p AD=0.2128p PS=2.93u
+ PD=1.5u
M$1694 3 67 68 3 sg13_lv_pmos L=0.13u W=1.12u AS=0.2128p AD=0.3808p PS=1.5u
+ PD=2.92u
M$1695 3 96 102 3 sg13_lv_pmos L=0.13u W=1.12u AS=0.3808p AD=0.3808p PS=2.92u
+ PD=2.92u
M$1696 116 57 3 3 sg13_lv_pmos L=0.13u W=1.12u AS=0.3864p AD=0.41165p PS=2.93u
+ PD=2.12u
M$1697 3 118 57 3 sg13_lv_pmos L=0.13u W=1.12u AS=0.41165p AD=0.4088p PS=2.12u
+ PD=2.97u
M$1698 103 116 128 3 sg13_lv_pmos L=0.13u W=0.42u AS=0.2048p AD=0.09345p
+ PS=1.63u PD=0.865u
M$1699 128 72 3 3 sg13_lv_pmos L=0.13u W=0.42u AS=0.09345p AD=0.204p PS=0.865u
+ PD=1.835u
M$1700 3 102 72 3 sg13_lv_pmos L=0.13u W=0.42u AS=0.204p AD=0.0798p PS=1.835u
+ PD=0.8u
M$1701 72 103 3 3 sg13_lv_pmos L=0.13u W=0.42u AS=0.0798p AD=0.4659p PS=0.8u
+ PD=3.65u
M$1702 56 57 103 3 sg13_lv_pmos L=0.13u W=1u AS=0.34p AD=0.2048p PS=2.68u
+ PD=1.63u
M$1703 73 103 3 3 sg13_lv_pmos L=0.13u W=1.12u AS=0.3864p AD=0.2128p PS=2.93u
+ PD=1.5u
M$1704 3 73 29 3 sg13_lv_pmos L=0.13u W=1.12u AS=0.2128p AD=0.3808p PS=1.5u
+ PD=2.92u
M$1705 74 104 3 3 sg13_lv_pmos L=0.13u W=1.12u AS=0.3808p AD=0.3808p PS=2.92u
+ PD=2.92u
M$1706 117 59 3 3 sg13_lv_pmos L=0.13u W=1.12u AS=0.3864p AD=0.41165p PS=2.93u
+ PD=2.12u
M$1707 3 118 59 3 sg13_lv_pmos L=0.13u W=1.12u AS=0.41165p AD=0.4088p PS=2.12u
+ PD=2.97u
M$1708 107 117 131 3 sg13_lv_pmos L=0.13u W=0.42u AS=0.2048p AD=0.09345p
+ PS=1.63u PD=0.865u
M$1709 131 78 3 3 sg13_lv_pmos L=0.13u W=0.42u AS=0.09345p AD=0.204p PS=0.865u
+ PD=1.835u
M$1710 3 74 78 3 sg13_lv_pmos L=0.13u W=0.42u AS=0.204p AD=0.0798p PS=1.835u
+ PD=0.8u
M$1711 78 107 3 3 sg13_lv_pmos L=0.13u W=0.42u AS=0.0798p AD=0.4659p PS=0.8u
+ PD=3.65u
M$1712 58 59 107 3 sg13_lv_pmos L=0.13u W=1u AS=0.34p AD=0.2048p PS=2.68u
+ PD=1.63u
M$1713 79 107 3 3 sg13_lv_pmos L=0.13u W=1.12u AS=0.3864p AD=0.2128p PS=2.93u
+ PD=1.5u
M$1714 3 79 32 3 sg13_lv_pmos L=0.13u W=1.12u AS=0.2128p AD=0.3808p PS=1.5u
+ PD=2.92u
M$1715 119 109 3 3 sg13_lv_pmos L=0.13u W=1.12u AS=0.3808p AD=0.2128p PS=2.92u
+ PD=1.5u
M$1716 3 525 119 3 sg13_lv_pmos L=0.13u W=1.12u AS=0.2128p AD=0.2128p PS=1.5u
+ PD=1.5u
M$1717 119 80 81 3 sg13_lv_pmos L=0.13u W=1.12u AS=0.2128p AD=0.3808p PS=1.5u
+ PD=2.92u
M$1718 3 23 126 3 sg13_lv_pmos L=0.13u W=1.12u AS=0.4032p AD=0.1176p PS=2.96u
+ PD=1.33u
M$1719 126 167 82 3 sg13_lv_pmos L=0.13u W=1.12u AS=0.1176p AD=0.3808p PS=1.33u
+ PD=2.92u
M$1720 120 18 3 3 sg13_lv_pmos L=0.13u W=1.12u AS=0.3808p AD=0.2128p PS=2.92u
+ PD=1.5u
M$1721 3 151 120 3 sg13_lv_pmos L=0.13u W=1.12u AS=0.2128p AD=0.2128p PS=1.5u
+ PD=1.5u
M$1722 120 83 84 3 sg13_lv_pmos L=0.13u W=1.12u AS=0.2128p AD=0.3808p PS=1.5u
+ PD=2.92u
M$1723 3 104 85 3 sg13_lv_pmos L=0.13u W=1.12u AS=0.3808p AD=0.3808p PS=2.92u
+ PD=2.92u
M$1724 3 118 86 3 sg13_lv_pmos L=0.13u W=0.84u AS=0.2114p AD=0.2856p PS=1.54u
+ PD=2.36u
M$1725 3 86 60 3 sg13_lv_pmos L=0.13u W=1.12u AS=0.2114p AD=0.42p PS=1.54u
+ PD=2.99u
M$1728 3 98 63 3 sg13_lv_pmos L=0.13u W=0.42u AS=0.1428p AD=0.0798p PS=1.52u
+ PD=0.8u
M$1729 3 61 63 3 sg13_lv_pmos L=0.13u W=0.42u AS=0.3623875p AD=0.0798p
+ PS=2.605u PD=0.8u
M$1730 3 99 54 3 sg13_lv_pmos L=0.13u W=1u AS=0.3623875p AD=0.34p PS=2.605u
+ PD=2.68u
M$1731 99 61 3 3 sg13_lv_pmos L=0.13u W=0.42u AS=0.147p AD=0.1563p PS=1.54u
+ PD=1.22u
M$1732 3 54 123 3 sg13_lv_pmos L=0.13u W=0.42u AS=0.1563p AD=0.063p PS=1.22u
+ PD=0.72u
M$1733 123 55 99 3 sg13_lv_pmos L=0.13u W=0.42u AS=0.063p AD=0.0798p PS=0.72u
+ PD=0.8u
M$1734 99 115 63 3 sg13_lv_pmos L=0.13u W=0.42u AS=0.0798p AD=0.1428p PS=0.8u
+ PD=1.52u
M$1735 141 139 3 3 sg13_lv_pmos L=0.13u W=1.12u AS=0.3864p AD=0.2128p PS=2.93u
+ PD=1.5u
M$1736 3 141 109 3 sg13_lv_pmos L=0.13u W=1.12u AS=0.2128p AD=0.3808p PS=1.5u
+ PD=2.92u
M$1739 3 10 69 3 sg13_lv_pmos L=0.13u W=0.42u AS=0.1428p AD=0.0798p PS=1.52u
+ PD=0.8u
M$1740 3 102 69 3 sg13_lv_pmos L=0.13u W=0.42u AS=0.3623875p AD=0.0798p
+ PS=2.605u PD=0.8u
M$1741 3 101 56 3 sg13_lv_pmos L=0.13u W=1u AS=0.3623875p AD=0.34p PS=2.605u
+ PD=2.68u
M$1743 101 102 3 3 sg13_lv_pmos L=0.13u W=0.42u AS=0.147p AD=0.1563p PS=1.54u
+ PD=1.22u
M$1744 3 56 127 3 sg13_lv_pmos L=0.13u W=0.42u AS=0.1563p AD=0.063p PS=1.22u
+ PD=0.72u
M$1745 127 57 101 3 sg13_lv_pmos L=0.13u W=0.42u AS=0.063p AD=0.0798p PS=0.72u
+ PD=0.8u
M$1746 101 116 69 3 sg13_lv_pmos L=0.13u W=0.42u AS=0.0798p AD=0.1428p PS=0.8u
+ PD=1.52u
M$1747 3 12 142 3 sg13_lv_pmos L=0.13u W=0.84u AS=0.2198p AD=0.2856p PS=1.53u
+ PD=2.36u
M$1748 3 68 4 3 sg13_lv_pmos L=0.13u W=1.12u AS=0.2198p AD=0.2128p PS=1.53u
+ PD=1.5u
M$1749 4 142 3 3 sg13_lv_pmos L=0.13u W=1.12u AS=0.2128p AD=0.3808p PS=1.5u
+ PD=2.92u
M$1751 3 4 143 3 sg13_lv_pmos L=0.13u W=0.84u AS=0.4536p AD=0.1596p PS=2.76u
+ PD=1.22u
M$1752 3 165 143 3 sg13_lv_pmos L=0.13u W=0.84u AS=0.2891p AD=0.1596p PS=1.695u
+ PD=1.22u
M$1753 3 4 175 3 sg13_lv_pmos L=0.13u W=1.12u AS=0.2891p AD=0.1428p PS=1.695u
+ PD=1.375u
M$1754 175 165 105 3 sg13_lv_pmos L=0.13u W=1.12u AS=0.1428p AD=0.2408p
+ PS=1.375u PD=1.55u
M$1755 105 143 3 3 sg13_lv_pmos L=0.13u W=1.12u AS=0.2408p AD=0.3808p PS=1.55u
+ PD=2.92u
M$1756 165 145 144 3 sg13_lv_pmos L=0.13u W=1.12u AS=0.3808p AD=0.2128p
+ PS=2.92u PD=1.5u
M$1757 144 166 3 3 sg13_lv_pmos L=0.13u W=1.12u AS=0.2128p AD=0.2128p PS=1.5u
+ PD=1.5u
M$1758 3 15 144 3 sg13_lv_pmos L=0.13u W=1.12u AS=0.2128p AD=0.3808p PS=1.5u
+ PD=2.92u
M$1759 145 166 177 3 sg13_lv_pmos L=0.13u W=1u AS=0.34p AD=0.1225p PS=2.68u
+ PD=1.245u
M$1760 177 15 3 3 sg13_lv_pmos L=0.13u W=1u AS=0.1225p AD=0.36p PS=1.245u
+ PD=2.72u
M$1761 3 105 75 3 sg13_lv_pmos L=0.13u W=0.42u AS=0.1428p AD=0.0798p PS=1.52u
+ PD=0.8u
M$1762 3 74 75 3 sg13_lv_pmos L=0.13u W=0.42u AS=0.3623875p AD=0.0798p
+ PS=2.605u PD=0.8u
M$1763 3 106 58 3 sg13_lv_pmos L=0.13u W=1u AS=0.3623875p AD=0.34p PS=2.605u
+ PD=2.68u
M$1766 106 74 3 3 sg13_lv_pmos L=0.13u W=0.42u AS=0.147p AD=0.1563p PS=1.54u
+ PD=1.22u
M$1767 3 58 130 3 sg13_lv_pmos L=0.13u W=0.42u AS=0.1563p AD=0.063p PS=1.22u
+ PD=0.72u
M$1768 130 59 106 3 sg13_lv_pmos L=0.13u W=0.42u AS=0.063p AD=0.0798p PS=0.72u
+ PD=0.8u
M$1769 106 117 75 3 sg13_lv_pmos L=0.13u W=0.42u AS=0.0798p AD=0.1428p PS=0.8u
+ PD=1.52u
M$1772 3 21 146 3 sg13_lv_pmos L=0.13u W=0.84u AS=0.2891p AD=0.1596p PS=1.695u
+ PD=1.22u
M$1773 146 32 3 3 sg13_lv_pmos L=0.13u W=0.84u AS=0.1596p AD=0.4536p PS=1.22u
+ PD=2.76u
M$1774 3 146 166 3 sg13_lv_pmos L=0.13u W=1.12u AS=0.3808p AD=0.2408p PS=2.92u
+ PD=1.55u
M$1775 166 21 178 3 sg13_lv_pmos L=0.13u W=1.12u AS=0.2408p AD=0.1428p PS=1.55u
+ PD=1.375u
M$1776 178 32 3 3 sg13_lv_pmos L=0.13u W=1.12u AS=0.1428p AD=0.2891p PS=1.375u
+ PD=1.695u
M$1779 3 9 108 3 sg13_lv_pmos L=0.13u W=0.84u AS=0.2856p AD=0.1596p PS=2.36u
+ PD=1.22u
M$1780 3 30 108 3 sg13_lv_pmos L=0.13u W=0.84u AS=0.1918p AD=0.1596p PS=1.5u
+ PD=1.22u
M$1781 3 108 33 3 sg13_lv_pmos L=0.13u W=1.12u AS=0.1918p AD=0.3808p PS=1.5u
+ PD=2.92u
M$1782 3 109 147 3 sg13_lv_pmos L=0.13u W=0.84u AS=0.2856p AD=0.1596p PS=2.36u
+ PD=1.22u
M$1783 147 525 3 3 sg13_lv_pmos L=0.13u W=0.84u AS=0.1596p AD=0.1918p PS=1.22u
+ PD=1.5u
M$1784 3 147 148 3 sg13_lv_pmos L=0.13u W=1.12u AS=0.1918p AD=0.3808p PS=1.5u
+ PD=2.92u
M$1785 3 109 129 3 sg13_lv_pmos L=0.13u W=1u AS=0.36p AD=0.1225p PS=2.72u
+ PD=1.245u
M$1786 129 525 80 3 sg13_lv_pmos L=0.13u W=1u AS=0.1225p AD=0.34p PS=1.245u
+ PD=2.68u
M$1787 3 23 179 3 sg13_lv_pmos L=0.13u W=1u AS=0.36p AD=0.1225p PS=2.72u
+ PD=1.245u
M$1788 179 167 149 3 sg13_lv_pmos L=0.13u W=1u AS=0.1225p AD=0.34p PS=1.245u
+ PD=2.68u
M$1789 150 23 3 3 sg13_lv_pmos L=0.13u W=1.12u AS=0.3808p AD=0.2128p PS=2.92u
+ PD=1.5u
M$1790 3 167 150 3 sg13_lv_pmos L=0.13u W=1.12u AS=0.2128p AD=0.2128p PS=1.5u
+ PD=1.5u
M$1791 150 149 151 3 sg13_lv_pmos L=0.13u W=1.12u AS=0.2128p AD=0.3808p PS=1.5u
+ PD=2.92u
M$1792 3 18 125 3 sg13_lv_pmos L=0.13u W=1u AS=0.36p AD=0.1225p PS=2.72u
+ PD=1.245u
M$1793 125 151 83 3 sg13_lv_pmos L=0.13u W=1u AS=0.1225p AD=0.34p PS=1.245u
+ PD=2.68u
M$1794 3 81 152 3 sg13_lv_pmos L=0.13u W=0.84u AS=0.2891p AD=0.1596p PS=1.695u
+ PD=1.22u
M$1795 152 168 3 3 sg13_lv_pmos L=0.13u W=0.84u AS=0.1596p AD=0.4536p PS=1.22u
+ PD=2.76u
M$1796 3 152 167 3 sg13_lv_pmos L=0.13u W=1.12u AS=0.3808p AD=0.2408p PS=2.92u
+ PD=1.55u
M$1797 167 81 176 3 sg13_lv_pmos L=0.13u W=1.12u AS=0.2408p AD=0.1428p PS=1.55u
+ PD=1.375u
M$1798 176 168 3 3 sg13_lv_pmos L=0.13u W=1.12u AS=0.1428p AD=0.2891p PS=1.375u
+ PD=1.695u
M$1805 159 157 3 3 sg13_lv_pmos L=0.13u W=1.12u AS=0.3864p AD=0.2128p PS=2.93u
+ PD=1.5u
M$1806 3 159 168 3 sg13_lv_pmos L=0.13u W=1.12u AS=0.2128p AD=0.3808p PS=1.5u
+ PD=2.92u
M$1809 3 97 133 3 sg13_lv_pmos L=0.13u W=0.84u AS=0.253p AD=0.2856p PS=1.53u
+ PD=2.36u
M$1810 3 97 171 3 sg13_lv_pmos L=0.13u W=1u AS=0.253p AD=0.3325p PS=1.53u
+ PD=1.665u
M$1811 171 68 134 3 sg13_lv_pmos L=0.13u W=1u AS=0.3325p AD=0.2225p PS=1.665u
+ PD=1.445u
M$1812 134 162 172 3 sg13_lv_pmos L=0.13u W=1u AS=0.2225p AD=0.2975p PS=1.445u
+ PD=1.595u
M$1813 3 133 172 3 sg13_lv_pmos L=0.13u W=1u AS=0.2198p AD=0.2975p PS=1.52u
+ PD=1.595u
M$1814 3 134 98 3 sg13_lv_pmos L=0.13u W=1.12u AS=0.2198p AD=0.6048p PS=1.52u
+ PD=3.32u
M$1815 203 97 3 3 sg13_lv_pmos L=0.13u W=0.84u AS=0.2856p AD=0.253p PS=2.36u
+ PD=1.53u
M$1816 3 97 208 3 sg13_lv_pmos L=0.13u W=1u AS=0.253p AD=0.3325p PS=1.53u
+ PD=1.665u
M$1817 208 109 200 3 sg13_lv_pmos L=0.13u W=1u AS=0.3325p AD=0.2225p PS=1.665u
+ PD=1.445u
M$1818 200 9 209 3 sg13_lv_pmos L=0.13u W=1u AS=0.2225p AD=0.2975p PS=1.445u
+ PD=1.595u
M$1819 209 203 3 3 sg13_lv_pmos L=0.13u W=1u AS=0.2975p AD=0.2198p PS=1.595u
+ PD=1.52u
M$1820 3 200 201 3 sg13_lv_pmos L=0.13u W=1.12u AS=0.2198p AD=0.6048p PS=1.52u
+ PD=3.32u
M$1821 3 201 135 3 sg13_lv_pmos L=0.13u W=0.42u AS=0.1428p AD=0.0798p PS=1.52u
+ PD=0.8u
M$1822 3 132 135 3 sg13_lv_pmos L=0.13u W=0.42u AS=0.3623875p AD=0.0798p
+ PS=2.605u PD=0.8u
M$1823 3 137 136 3 sg13_lv_pmos L=0.13u W=1u AS=0.3623875p AD=0.34p PS=2.605u
+ PD=2.68u
M$1824 3 96 132 3 sg13_lv_pmos L=0.13u W=1.12u AS=0.3808p AD=0.3808p PS=2.92u
+ PD=2.92u
M$1827 3 132 137 3 sg13_lv_pmos L=0.13u W=0.42u AS=0.1563p AD=0.147p PS=1.22u
+ PD=1.54u
M$1828 3 136 161 3 sg13_lv_pmos L=0.13u W=0.42u AS=0.1563p AD=0.063p PS=1.22u
+ PD=0.72u
M$1829 161 164 137 3 sg13_lv_pmos L=0.13u W=0.42u AS=0.063p AD=0.0798p PS=0.72u
+ PD=0.8u
M$1830 137 138 135 3 sg13_lv_pmos L=0.13u W=0.42u AS=0.0798p AD=0.1428p PS=0.8u
+ PD=1.52u
M$1833 3 164 138 3 sg13_lv_pmos L=0.13u W=1.12u AS=0.41165p AD=0.3864p PS=2.12u
+ PD=2.93u
M$1834 3 210 164 3 sg13_lv_pmos L=0.13u W=1.12u AS=0.41165p AD=0.4088p PS=2.12u
+ PD=2.97u
M$1835 136 164 139 3 sg13_lv_pmos L=0.13u W=1u AS=0.34p AD=0.2048p PS=2.68u
+ PD=1.63u
M$1836 139 138 174 3 sg13_lv_pmos L=0.13u W=0.42u AS=0.2048p AD=0.09345p
+ PS=1.63u PD=0.865u
M$1837 3 140 174 3 sg13_lv_pmos L=0.13u W=0.42u AS=0.204p AD=0.09345p PS=1.835u
+ PD=0.865u
M$1838 3 132 140 3 sg13_lv_pmos L=0.13u W=0.42u AS=0.204p AD=0.0798p PS=1.835u
+ PD=0.8u
M$1839 3 139 140 3 sg13_lv_pmos L=0.13u W=0.42u AS=0.4659p AD=0.0798p PS=3.65u
+ PD=0.8u
M$1864 202 148 207 3 sg13_lv_pmos L=0.13u W=1.12u AS=0.3808p AD=0.2128p
+ PS=2.92u PD=1.5u
M$1865 207 168 3 3 sg13_lv_pmos L=0.13u W=1.12u AS=0.2128p AD=0.2128p PS=1.5u
+ PD=1.5u
M$1866 3 81 207 3 sg13_lv_pmos L=0.13u W=1.12u AS=0.2128p AD=0.3808p PS=1.5u
+ PD=2.92u
M$1871 3 84 153 3 sg13_lv_pmos L=0.13u W=0.42u AS=0.1428p AD=0.0798p PS=1.52u
+ PD=0.8u
M$1872 3 85 153 3 sg13_lv_pmos L=0.13u W=0.42u AS=0.3623875p AD=0.0798p
+ PS=2.605u PD=0.8u
M$1873 3 155 154 3 sg13_lv_pmos L=0.13u W=1u AS=0.3623875p AD=0.34p PS=2.605u
+ PD=2.68u
M$1876 3 85 155 3 sg13_lv_pmos L=0.13u W=0.42u AS=0.1563p AD=0.147p PS=1.22u
+ PD=1.54u
M$1877 3 154 160 3 sg13_lv_pmos L=0.13u W=0.42u AS=0.1563p AD=0.063p PS=1.22u
+ PD=0.72u
M$1878 160 170 155 3 sg13_lv_pmos L=0.13u W=0.42u AS=0.063p AD=0.0798p PS=0.72u
+ PD=0.8u
M$1879 155 156 153 3 sg13_lv_pmos L=0.13u W=0.42u AS=0.0798p AD=0.1428p PS=0.8u
+ PD=1.52u
M$1882 3 170 156 3 sg13_lv_pmos L=0.13u W=1.12u AS=0.41165p AD=0.3864p PS=2.12u
+ PD=2.93u
M$1883 3 118 170 3 sg13_lv_pmos L=0.13u W=1.12u AS=0.41165p AD=0.4088p PS=2.12u
+ PD=2.97u
M$1884 154 170 157 3 sg13_lv_pmos L=0.13u W=1u AS=0.34p AD=0.2048p PS=2.68u
+ PD=1.63u
M$1885 157 156 173 3 sg13_lv_pmos L=0.13u W=0.42u AS=0.2048p AD=0.09345p
+ PS=1.63u PD=0.865u
M$1886 3 158 173 3 sg13_lv_pmos L=0.13u W=0.42u AS=0.204p AD=0.09345p PS=1.835u
+ PD=0.865u
M$1887 3 85 158 3 sg13_lv_pmos L=0.13u W=0.42u AS=0.204p AD=0.0798p PS=1.835u
+ PD=0.8u
M$1888 3 157 158 3 sg13_lv_pmos L=0.13u W=0.42u AS=0.4659p AD=0.0798p PS=3.65u
+ PD=0.8u
M$1900 3 211 210 3 sg13_lv_pmos L=0.13u W=17.92u AS=3.5896p AD=3.4048p
+ PS=25.45u PD=24u
M$1916 3 415 211 3 sg13_lv_pmos L=0.13u W=6.72u AS=1.2768p AD=1.4448p PS=9u
+ PD=10.42u
M$1940 212 217 216 3 sg13_lv_pmos L=0.13u W=1.12u AS=0.3808p AD=0.1176p
+ PS=2.92u PD=1.33u
M$1941 216 202 3 3 sg13_lv_pmos L=0.13u W=1.12u AS=0.1176p AD=0.4032p PS=1.33u
+ PD=2.96u
M$1942 3 215 214 3 sg13_lv_pmos L=0.13u W=0.84u AS=0.1918p AD=0.1596p PS=1.5u
+ PD=1.22u
M$1943 214 151 3 3 sg13_lv_pmos L=0.13u W=0.84u AS=0.1596p AD=0.2856p PS=1.22u
+ PD=2.36u
M$1944 213 214 3 3 sg13_lv_pmos L=0.13u W=1.12u AS=0.3808p AD=0.1918p PS=2.92u
+ PD=1.5u
M$1955 3 218 225 3 sg13_lv_pmos L=0.13u W=0.84u AS=0.2114p AD=0.2856p PS=1.54u
+ PD=2.36u
M$1956 3 225 162 3 sg13_lv_pmos L=0.13u W=1.12u AS=0.2114p AD=0.42p PS=1.54u
+ PD=2.99u
M$1958 3 97 226 3 sg13_lv_pmos L=0.13u W=0.84u AS=0.253p AD=0.2856p PS=1.53u
+ PD=2.36u
M$1959 3 226 250 3 sg13_lv_pmos L=0.13u W=1u AS=0.2198p AD=0.2975p PS=1.52u
+ PD=1.595u
M$1960 250 109 221 3 sg13_lv_pmos L=0.13u W=1u AS=0.2975p AD=0.2225p PS=1.595u
+ PD=1.445u
M$1961 221 227 251 3 sg13_lv_pmos L=0.13u W=1u AS=0.2225p AD=0.3325p PS=1.445u
+ PD=1.665u
M$1962 251 97 3 3 sg13_lv_pmos L=0.13u W=1u AS=0.3325p AD=0.253p PS=1.665u
+ PD=1.53u
M$1963 220 221 3 3 sg13_lv_pmos L=0.13u W=1.12u AS=0.6048p AD=0.2198p PS=3.32u
+ PD=1.52u
M$1978 3 227 252 3 sg13_lv_pmos L=0.13u W=1u AS=0.36p AD=0.1225p PS=2.72u
+ PD=1.245u
M$1979 252 30 228 3 sg13_lv_pmos L=0.13u W=1u AS=0.1225p AD=0.34p PS=1.245u
+ PD=2.68u
M$1980 248 227 3 3 sg13_lv_pmos L=0.13u W=1.12u AS=0.3808p AD=0.2128p PS=2.92u
+ PD=1.5u
M$1981 3 30 248 3 sg13_lv_pmos L=0.13u W=1.12u AS=0.2128p AD=0.2128p PS=1.5u
+ PD=1.5u
M$1982 248 228 222 3 sg13_lv_pmos L=0.13u W=1.12u AS=0.2128p AD=0.3808p PS=1.5u
+ PD=2.92u
M$1985 3 222 292 3 sg13_lv_pmos L=0.13u W=1.12u AS=0.3808p AD=0.2128p PS=2.92u
+ PD=1.5u
M$1986 292 229 3 3 sg13_lv_pmos L=0.13u W=1.12u AS=0.2128p AD=0.3808p PS=1.5u
+ PD=2.92u
M$1989 3 229 230 3 sg13_lv_pmos L=0.13u W=0.84u AS=0.4536p AD=0.1596p PS=2.76u
+ PD=1.22u
M$1990 3 222 230 3 sg13_lv_pmos L=0.13u W=0.84u AS=0.2891p AD=0.1596p PS=1.695u
+ PD=1.22u
M$1991 3 229 253 3 sg13_lv_pmos L=0.13u W=1.12u AS=0.2891p AD=0.1428p PS=1.695u
+ PD=1.375u
M$1992 253 222 217 3 sg13_lv_pmos L=0.13u W=1.12u AS=0.1428p AD=0.2408p
+ PS=1.375u PD=1.55u
M$1993 217 230 3 3 sg13_lv_pmos L=0.13u W=1.12u AS=0.2408p AD=0.3808p PS=1.55u
+ PD=2.92u
M$1996 3 224 223 3 sg13_lv_pmos L=0.13u W=2.24u AS=0.5936p AD=0.5936p PS=4.42u
+ PD=4.42u
M$1998 224 212 245 3 sg13_lv_pmos L=0.13u W=1u AS=0.35p AD=0.2125p PS=2.7u
+ PD=1.425u
M$1999 245 82 3 3 sg13_lv_pmos L=0.13u W=1u AS=0.2125p AD=0.19p PS=1.425u
+ PD=1.38u
M$2000 3 232 245 3 sg13_lv_pmos L=0.13u W=1u AS=0.19p AD=0.34p PS=1.38u PD=2.68u
M$2001 3 202 254 3 sg13_lv_pmos L=0.13u W=1u AS=0.36p AD=0.1225p PS=2.72u
+ PD=1.245u
M$2002 254 217 233 3 sg13_lv_pmos L=0.13u W=1u AS=0.1225p AD=0.34p PS=1.245u
+ PD=2.68u
M$2003 249 202 3 3 sg13_lv_pmos L=0.13u W=1.12u AS=0.3808p AD=0.2128p PS=2.92u
+ PD=1.5u
M$2004 3 217 249 3 sg13_lv_pmos L=0.13u W=1.12u AS=0.2128p AD=0.2128p PS=1.5u
+ PD=1.5u
M$2005 249 233 215 3 sg13_lv_pmos L=0.13u W=1.12u AS=0.2128p AD=0.3808p PS=1.5u
+ PD=2.92u
M$2006 3 215 234 3 sg13_lv_pmos L=0.13u W=0.84u AS=0.4536p AD=0.1596p PS=2.76u
+ PD=1.22u
M$2007 3 278 234 3 sg13_lv_pmos L=0.13u W=0.84u AS=0.2891p AD=0.1596p PS=1.695u
+ PD=1.22u
M$2008 3 215 255 3 sg13_lv_pmos L=0.13u W=1.12u AS=0.2891p AD=0.1428p PS=1.695u
+ PD=1.375u
M$2009 255 278 246 3 sg13_lv_pmos L=0.13u W=1.12u AS=0.1428p AD=0.2408p
+ PS=1.375u PD=1.55u
M$2010 246 234 3 3 sg13_lv_pmos L=0.13u W=1.12u AS=0.2408p AD=0.3808p PS=1.55u
+ PD=2.92u
M$2015 118 236 3 3 sg13_lv_pmos L=0.13u W=1.12u AS=0.42p AD=0.2114p PS=2.99u
+ PD=1.54u
M$2016 3 247 236 3 sg13_lv_pmos L=0.13u W=0.84u AS=0.2114p AD=0.2856p PS=1.54u
+ PD=2.36u
M$2021 3 96 257 3 sg13_lv_pmos L=0.13u W=1.12u AS=0.3808p AD=0.3808p PS=2.92u
+ PD=2.92u
M$2022 3 220 256 3 sg13_lv_pmos L=0.13u W=0.42u AS=0.1428p AD=0.0798p PS=1.52u
+ PD=0.8u
M$2023 3 257 256 3 sg13_lv_pmos L=0.13u W=0.42u AS=0.3623875p AD=0.0798p
+ PS=2.605u PD=0.8u
M$2024 3 262 261 3 sg13_lv_pmos L=0.13u W=1u AS=0.3623875p AD=0.34p PS=2.605u
+ PD=2.68u
M$2025 3 286 263 3 sg13_lv_pmos L=0.13u W=1.12u AS=0.41165p AD=0.3864p PS=2.12u
+ PD=2.93u
M$2026 3 210 286 3 sg13_lv_pmos L=0.13u W=1.12u AS=0.41165p AD=0.4088p PS=2.12u
+ PD=2.97u
M$2027 261 286 287 3 sg13_lv_pmos L=0.13u W=1u AS=0.34p AD=0.2048p PS=2.68u
+ PD=1.63u
M$2028 287 263 297 3 sg13_lv_pmos L=0.13u W=0.42u AS=0.2048p AD=0.09345p
+ PS=1.63u PD=0.865u
M$2029 3 288 297 3 sg13_lv_pmos L=0.13u W=0.42u AS=0.204p AD=0.09345p PS=1.835u
+ PD=0.865u
M$2030 3 257 288 3 sg13_lv_pmos L=0.13u W=0.42u AS=0.204p AD=0.0798p PS=1.835u
+ PD=0.8u
M$2031 3 287 288 3 sg13_lv_pmos L=0.13u W=0.42u AS=0.4659p AD=0.0798p PS=3.65u
+ PD=0.8u
M$2032 264 287 3 3 sg13_lv_pmos L=0.13u W=1.12u AS=0.3864p AD=0.2128p PS=2.93u
+ PD=1.5u
M$2033 3 264 227 3 sg13_lv_pmos L=0.13u W=1.12u AS=0.2128p AD=0.3808p PS=1.5u
+ PD=2.92u
M$2035 3 289 265 3 sg13_lv_pmos L=0.13u W=1.12u AS=0.3808p AD=0.2128p PS=2.92u
+ PD=1.5u
M$2036 265 30 3 3 sg13_lv_pmos L=0.13u W=1.12u AS=0.2128p AD=0.3808p PS=1.5u
+ PD=2.92u
M$2039 3 291 266 3 sg13_lv_pmos L=0.13u W=0.84u AS=0.4536p AD=0.1596p PS=2.76u
+ PD=1.22u
M$2040 3 290 266 3 sg13_lv_pmos L=0.13u W=0.84u AS=0.2891p AD=0.1596p PS=1.695u
+ PD=1.22u
M$2041 3 291 298 3 sg13_lv_pmos L=0.13u W=1.12u AS=0.2891p AD=0.1428p PS=1.695u
+ PD=1.375u
M$2042 298 290 267 3 sg13_lv_pmos L=0.13u W=1.12u AS=0.1428p AD=0.2408p
+ PS=1.375u PD=1.55u
M$2043 267 266 3 3 sg13_lv_pmos L=0.13u W=1.12u AS=0.2408p AD=0.3808p PS=1.55u
+ PD=2.92u
M$2044 3 30 268 3 sg13_lv_pmos L=0.13u W=1.12u AS=0.3808p AD=0.2128p PS=2.92u
+ PD=1.5u
M$2045 268 227 3 3 sg13_lv_pmos L=0.13u W=1.12u AS=0.2128p AD=0.3808p PS=1.5u
+ PD=2.92u
M$2046 3 267 258 3 sg13_lv_pmos L=0.13u W=1.12u AS=0.3808p AD=0.2128p PS=2.92u
+ PD=1.5u
M$2047 258 292 3 3 sg13_lv_pmos L=0.13u W=1.12u AS=0.2128p AD=0.2128p PS=1.5u
+ PD=1.5u
M$2048 3 268 258 3 sg13_lv_pmos L=0.13u W=1.12u AS=0.2128p AD=0.3808p PS=1.5u
+ PD=2.92u
M$2049 3 258 269 3 sg13_lv_pmos L=0.13u W=0.84u AS=0.2618p AD=0.2856p PS=1.63u
+ PD=2.36u
M$2050 3 269 299 3 sg13_lv_pmos L=0.13u W=1.12u AS=0.2618p AD=0.1176p PS=1.63u
+ PD=1.33u
M$2051 299 348 270 3 sg13_lv_pmos L=0.13u W=1.12u AS=0.1176p AD=0.3808p
+ PS=1.33u PD=2.92u
M$2052 271 525 3 3 sg13_lv_pmos L=0.13u W=0.84u AS=0.2856p AD=0.2114p PS=2.36u
+ PD=1.54u
M$2053 3 271 30 3 sg13_lv_pmos L=0.13u W=1.12u AS=0.2114p AD=0.42p PS=1.54u
+ PD=2.99u
M$2057 272 104 3 3 sg13_lv_pmos L=0.13u W=1.12u AS=0.3808p AD=0.3808p PS=2.92u
+ PD=2.92u
M$2059 273 213 3 3 sg13_lv_pmos L=0.13u W=2.24u AS=0.5936p AD=0.4256p PS=4.42u
+ PD=3u
M$2060 3 18 273 3 sg13_lv_pmos L=0.13u W=2.24u AS=0.4256p AD=0.4256p PS=3u PD=3u
M$2063 273 223 274 3 sg13_lv_pmos L=0.13u W=2.24u AS=0.4256p AD=0.5936p PS=3u
+ PD=4.42u
M$2065 275 276 3 3 sg13_lv_pmos L=0.13u W=1.12u AS=0.3808p AD=0.3808p PS=2.92u
+ PD=2.92u
M$2066 276 223 277 3 sg13_lv_pmos L=0.13u W=1u AS=0.35p AD=0.2125p PS=2.7u
+ PD=1.425u
M$2067 277 18 3 3 sg13_lv_pmos L=0.13u W=1u AS=0.2125p AD=0.19p PS=1.425u
+ PD=1.38u
M$2068 3 213 277 3 sg13_lv_pmos L=0.13u W=1u AS=0.19p AD=0.34p PS=1.38u PD=2.68u
M$2069 3 217 232 3 sg13_lv_pmos L=0.13u W=1.12u AS=0.3808p AD=0.2128p PS=2.92u
+ PD=1.5u
M$2070 232 202 3 3 sg13_lv_pmos L=0.13u W=1.12u AS=0.2128p AD=0.3808p PS=1.5u
+ PD=2.92u
M$2071 278 82 279 3 sg13_lv_pmos L=0.13u W=1.12u AS=0.3808p AD=0.2128p PS=2.92u
+ PD=1.5u
M$2072 279 18 3 3 sg13_lv_pmos L=0.13u W=1.12u AS=0.2128p AD=0.2128p PS=1.5u
+ PD=1.5u
M$2073 3 151 279 3 sg13_lv_pmos L=0.13u W=1.12u AS=0.2128p AD=0.3808p PS=1.5u
+ PD=2.92u
M$2075 3 104 260 3 sg13_lv_pmos L=0.13u W=1.12u AS=0.3808p AD=0.3808p PS=2.92u
+ PD=2.92u
M$2076 3 246 259 3 sg13_lv_pmos L=0.13u W=0.42u AS=0.1428p AD=0.0798p PS=1.52u
+ PD=0.8u
M$2077 3 260 259 3 sg13_lv_pmos L=0.13u W=0.42u AS=0.3623875p AD=0.0798p
+ PS=2.605u PD=0.8u
M$2078 3 281 280 3 sg13_lv_pmos L=0.13u W=1u AS=0.3623875p AD=0.34p PS=2.605u
+ PD=2.68u
M$2079 3 293 282 3 sg13_lv_pmos L=0.13u W=1.12u AS=0.41165p AD=0.3864p PS=2.12u
+ PD=2.93u
M$2080 3 118 293 3 sg13_lv_pmos L=0.13u W=1.12u AS=0.41165p AD=0.4088p PS=2.12u
+ PD=2.97u
M$2081 280 293 294 3 sg13_lv_pmos L=0.13u W=1u AS=0.34p AD=0.2048p PS=2.68u
+ PD=1.63u
M$2082 294 282 296 3 sg13_lv_pmos L=0.13u W=0.42u AS=0.2048p AD=0.09345p
+ PS=1.63u PD=0.865u
M$2083 3 295 296 3 sg13_lv_pmos L=0.13u W=0.42u AS=0.204p AD=0.09345p PS=1.835u
+ PD=0.865u
M$2084 3 260 295 3 sg13_lv_pmos L=0.13u W=0.42u AS=0.204p AD=0.0798p PS=1.835u
+ PD=0.8u
M$2085 3 294 295 3 sg13_lv_pmos L=0.13u W=0.42u AS=0.4659p AD=0.0798p PS=3.65u
+ PD=0.8u
M$2086 283 294 3 3 sg13_lv_pmos L=0.13u W=1.12u AS=0.3864p AD=0.2128p PS=2.93u
+ PD=1.5u
M$2087 3 283 229 3 sg13_lv_pmos L=0.13u W=1.12u AS=0.2128p AD=0.3808p PS=1.5u
+ PD=2.92u
M$2088 3 96 320 3 sg13_lv_pmos L=0.13u W=1.12u AS=0.3808p AD=0.3808p PS=2.92u
+ PD=2.92u
M$2089 3 257 262 3 sg13_lv_pmos L=0.13u W=0.42u AS=0.1563p AD=0.147p PS=1.22u
+ PD=1.54u
M$2090 3 261 285 3 sg13_lv_pmos L=0.13u W=0.42u AS=0.1563p AD=0.063p PS=1.22u
+ PD=0.72u
M$2091 285 286 262 3 sg13_lv_pmos L=0.13u W=0.42u AS=0.063p AD=0.0798p PS=0.72u
+ PD=0.8u
M$2092 262 263 256 3 sg13_lv_pmos L=0.13u W=0.42u AS=0.0798p AD=0.1428p PS=0.8u
+ PD=1.52u
M$2093 375 323 3 3 sg13_lv_pmos L=0.13u W=1.12u AS=0.3864p AD=0.41165p PS=2.93u
+ PD=2.12u
M$2094 3 210 323 3 sg13_lv_pmos L=0.13u W=1.12u AS=0.41165p AD=0.4088p PS=2.12u
+ PD=2.97u
M$2095 343 375 387 3 sg13_lv_pmos L=0.13u W=0.42u AS=0.2048p AD=0.09345p
+ PS=1.63u PD=0.865u
M$2096 387 325 3 3 sg13_lv_pmos L=0.13u W=0.42u AS=0.09345p AD=0.204p PS=0.865u
+ PD=1.835u
M$2097 3 320 325 3 sg13_lv_pmos L=0.13u W=0.42u AS=0.204p AD=0.0798p PS=1.835u
+ PD=0.8u
M$2098 325 343 3 3 sg13_lv_pmos L=0.13u W=0.42u AS=0.0798p AD=0.4659p PS=0.8u
+ PD=3.65u
M$2099 322 323 343 3 sg13_lv_pmos L=0.13u W=1u AS=0.34p AD=0.2048p PS=2.68u
+ PD=1.63u
M$2100 326 343 3 3 sg13_lv_pmos L=0.13u W=1.12u AS=0.3864p AD=0.2128p PS=2.93u
+ PD=1.5u
M$2101 3 326 289 3 sg13_lv_pmos L=0.13u W=1.12u AS=0.2128p AD=0.3808p PS=1.5u
+ PD=2.92u
M$2102 383 289 3 3 sg13_lv_pmos L=0.13u W=1.12u AS=0.3808p AD=0.2128p PS=2.92u
+ PD=1.5u
M$2103 3 30 383 3 sg13_lv_pmos L=0.13u W=1.12u AS=0.2128p AD=0.2128p PS=1.5u
+ PD=1.5u
M$2104 383 344 290 3 sg13_lv_pmos L=0.13u W=1.12u AS=0.2128p AD=0.3808p PS=1.5u
+ PD=2.92u
M$2105 3 290 345 3 sg13_lv_pmos L=0.13u W=1.12u AS=0.3808p AD=0.2128p PS=2.92u
+ PD=1.5u
M$2106 345 291 3 3 sg13_lv_pmos L=0.13u W=1.12u AS=0.2128p AD=0.3808p PS=1.5u
+ PD=2.92u
M$2107 376 345 3 3 sg13_lv_pmos L=0.13u W=1.12u AS=0.3808p AD=0.2128p PS=2.92u
+ PD=1.5u
M$2108 3 265 376 3 sg13_lv_pmos L=0.13u W=1.12u AS=0.2128p AD=0.2128p PS=1.5u
+ PD=1.5u
M$2109 376 347 346 3 sg13_lv_pmos L=0.13u W=1.12u AS=0.2128p AD=0.3808p PS=1.5u
+ PD=2.92u
M$2110 3 347 327 3 sg13_lv_pmos L=0.13u W=1.12u AS=0.3808p AD=0.2128p PS=2.92u
+ PD=1.5u
M$2111 327 345 3 3 sg13_lv_pmos L=0.13u W=1.12u AS=0.2128p AD=0.2128p PS=1.5u
+ PD=1.5u
M$2112 3 265 327 3 sg13_lv_pmos L=0.13u W=1.12u AS=0.2128p AD=0.3808p PS=1.5u
+ PD=2.92u
M$2113 348 267 377 3 sg13_lv_pmos L=0.13u W=1.12u AS=0.3808p AD=0.2128p
+ PS=2.92u PD=1.5u
M$2114 377 268 3 3 sg13_lv_pmos L=0.13u W=1.12u AS=0.2128p AD=0.2128p PS=1.5u
+ PD=1.5u
M$2115 3 292 377 3 sg13_lv_pmos L=0.13u W=1.12u AS=0.2128p AD=0.3808p PS=1.5u
+ PD=2.92u
M$2116 349 348 378 3 sg13_lv_pmos L=0.13u W=1.12u AS=0.3808p AD=0.2128p
+ PS=2.92u PD=1.5u
M$2117 378 275 3 3 sg13_lv_pmos L=0.13u W=1.12u AS=0.2128p AD=0.2128p PS=1.5u
+ PD=1.5u
M$2118 3 270 378 3 sg13_lv_pmos L=0.13u W=1.12u AS=0.2128p AD=0.3808p PS=1.5u
+ PD=2.92u
M$2119 3 274 350 3 sg13_lv_pmos L=0.13u W=0.84u AS=0.4536p AD=0.1596p PS=2.76u
+ PD=1.22u
M$2120 3 270 350 3 sg13_lv_pmos L=0.13u W=0.84u AS=0.2891p AD=0.1596p PS=1.695u
+ PD=1.22u
M$2121 3 274 389 3 sg13_lv_pmos L=0.13u W=1.12u AS=0.2891p AD=0.1428p PS=1.695u
+ PD=1.375u
M$2122 389 270 328 3 sg13_lv_pmos L=0.13u W=1.12u AS=0.1428p AD=0.2408p
+ PS=1.375u PD=1.55u
M$2123 328 350 3 3 sg13_lv_pmos L=0.13u W=1.12u AS=0.2408p AD=0.3808p PS=1.55u
+ PD=2.92u
M$2124 380 331 3 3 sg13_lv_pmos L=0.13u W=1.12u AS=0.3864p AD=0.41165p PS=2.93u
+ PD=2.12u
M$2125 3 118 331 3 sg13_lv_pmos L=0.13u W=1.12u AS=0.41165p AD=0.4088p PS=2.12u
+ PD=2.97u
M$2126 353 380 390 3 sg13_lv_pmos L=0.13u W=0.42u AS=0.2048p AD=0.09345p
+ PS=1.63u PD=0.865u
M$2127 390 333 3 3 sg13_lv_pmos L=0.13u W=0.42u AS=0.09345p AD=0.204p PS=0.865u
+ PD=1.835u
M$2128 3 272 333 3 sg13_lv_pmos L=0.13u W=0.42u AS=0.204p AD=0.0798p PS=1.835u
+ PD=0.8u
M$2129 333 353 3 3 sg13_lv_pmos L=0.13u W=0.42u AS=0.0798p AD=0.4659p PS=0.8u
+ PD=3.65u
M$2130 330 331 353 3 sg13_lv_pmos L=0.13u W=1u AS=0.34p AD=0.2048p PS=2.68u
+ PD=1.63u
M$2131 334 353 3 3 sg13_lv_pmos L=0.13u W=1.12u AS=0.3864p AD=0.2128p PS=2.93u
+ PD=1.5u
M$2132 3 334 291 3 sg13_lv_pmos L=0.13u W=1.12u AS=0.2128p AD=0.3808p PS=1.5u
+ PD=2.92u
M$2133 3 118 335 3 sg13_lv_pmos L=0.13u W=1.12u AS=0.3808p AD=0.3808p PS=2.92u
+ PD=2.92u
M$2134 3 260 281 3 sg13_lv_pmos L=0.13u W=0.42u AS=0.1563p AD=0.147p PS=1.22u
+ PD=1.54u
M$2135 3 280 284 3 sg13_lv_pmos L=0.13u W=0.42u AS=0.1563p AD=0.063p PS=1.22u
+ PD=0.72u
M$2136 284 293 281 3 sg13_lv_pmos L=0.13u W=0.42u AS=0.063p AD=0.0798p PS=0.72u
+ PD=0.8u
M$2137 281 282 259 3 sg13_lv_pmos L=0.13u W=0.42u AS=0.0798p AD=0.1428p PS=0.8u
+ PD=1.52u
M$2138 382 338 3 3 sg13_lv_pmos L=0.13u W=1.12u AS=0.3864p AD=0.41165p PS=2.93u
+ PD=2.12u
M$2139 3 423 338 3 sg13_lv_pmos L=0.13u W=1.12u AS=0.41165p AD=0.4088p PS=2.12u
+ PD=2.97u
M$2140 356 382 385 3 sg13_lv_pmos L=0.13u W=0.42u AS=0.2048p AD=0.09345p
+ PS=1.63u PD=0.865u
M$2141 385 340 3 3 sg13_lv_pmos L=0.13u W=0.42u AS=0.09345p AD=0.204p PS=0.865u
+ PD=1.835u
M$2142 3 354 340 3 sg13_lv_pmos L=0.13u W=0.42u AS=0.204p AD=0.0798p PS=1.835u
+ PD=0.8u
M$2143 340 356 3 3 sg13_lv_pmos L=0.13u W=0.42u AS=0.0798p AD=0.4659p PS=0.8u
+ PD=3.65u
M$2144 337 338 356 3 sg13_lv_pmos L=0.13u W=1u AS=0.34p AD=0.2048p PS=2.68u
+ PD=1.63u
M$2145 341 356 3 3 sg13_lv_pmos L=0.13u W=1.12u AS=0.3864p AD=0.2128p PS=2.93u
+ PD=1.5u
M$2146 3 341 247 3 sg13_lv_pmos L=0.13u W=1.12u AS=0.2128p AD=0.3808p PS=1.5u
+ PD=2.92u
M$2151 3 396 321 3 sg13_lv_pmos L=0.13u W=0.42u AS=0.1428p AD=0.0798p PS=1.52u
+ PD=0.8u
M$2152 3 320 321 3 sg13_lv_pmos L=0.13u W=0.42u AS=0.3623875p AD=0.0798p
+ PS=2.605u PD=0.8u
M$2153 3 374 322 3 sg13_lv_pmos L=0.13u W=1u AS=0.3623875p AD=0.34p PS=2.605u
+ PD=2.68u
M$2154 374 320 3 3 sg13_lv_pmos L=0.13u W=0.42u AS=0.147p AD=0.1563p PS=1.54u
+ PD=1.22u
M$2155 3 322 384 3 sg13_lv_pmos L=0.13u W=0.42u AS=0.1563p AD=0.063p PS=1.22u
+ PD=0.72u
M$2156 384 323 374 3 sg13_lv_pmos L=0.13u W=0.42u AS=0.063p AD=0.0798p PS=0.72u
+ PD=0.8u
M$2157 374 375 321 3 sg13_lv_pmos L=0.13u W=0.42u AS=0.0798p AD=0.1428p PS=0.8u
+ PD=1.52u
M$2166 3 289 388 3 sg13_lv_pmos L=0.13u W=1u AS=0.36p AD=0.1225p PS=2.72u
+ PD=1.245u
M$2167 388 30 344 3 sg13_lv_pmos L=0.13u W=1u AS=0.1225p AD=0.34p PS=1.245u
+ PD=2.68u
M$2168 393 265 3 3 sg13_lv_pmos L=0.13u W=0.84u AS=0.2856p AD=0.1596p PS=2.36u
+ PD=1.22u
M$2169 3 345 393 3 sg13_lv_pmos L=0.13u W=0.84u AS=0.1596p AD=0.1596p PS=1.22u
+ PD=1.22u
M$2170 3 347 393 3 sg13_lv_pmos L=0.13u W=0.84u AS=0.36195p AD=0.1596p PS=1.84u
+ PD=1.22u
M$2171 3 393 394 3 sg13_lv_pmos L=0.13u W=1.12u AS=0.36195p AD=0.3808p PS=1.84u
+ PD=2.92u
M$2172 3 399 395 3 sg13_lv_pmos L=0.15u W=1.12u AS=0.3808p AD=0.2128p PS=2.92u
+ PD=1.5u
M$2173 395 400 404 3 sg13_lv_pmos L=0.15u W=1.12u AS=0.2128p AD=0.2128p PS=1.5u
+ PD=1.5u
M$2174 404 274 3 3 sg13_lv_pmos L=0.15u W=1.12u AS=0.2128p AD=0.3808p PS=1.5u
+ PD=2.92u
M$2180 3 328 329 3 sg13_lv_pmos L=0.13u W=0.42u AS=0.1428p AD=0.0798p PS=1.52u
+ PD=0.8u
M$2181 3 272 329 3 sg13_lv_pmos L=0.13u W=0.42u AS=0.3623875p AD=0.0798p
+ PS=2.605u PD=0.8u
M$2182 3 379 330 3 sg13_lv_pmos L=0.13u W=1u AS=0.3623875p AD=0.34p PS=2.605u
+ PD=2.68u
M$2185 379 272 3 3 sg13_lv_pmos L=0.13u W=0.42u AS=0.147p AD=0.1563p PS=1.54u
+ PD=1.22u
M$2186 3 330 391 3 sg13_lv_pmos L=0.13u W=0.42u AS=0.1563p AD=0.063p PS=1.22u
+ PD=0.72u
M$2187 391 331 379 3 sg13_lv_pmos L=0.13u W=0.42u AS=0.063p AD=0.0798p PS=0.72u
+ PD=0.8u
M$2188 379 380 329 3 sg13_lv_pmos L=0.13u W=0.42u AS=0.0798p AD=0.1428p PS=0.8u
+ PD=1.52u
M$2206 3 335 336 3 sg13_lv_pmos L=0.13u W=0.42u AS=0.1428p AD=0.0798p PS=1.52u
+ PD=0.8u
M$2207 3 354 336 3 sg13_lv_pmos L=0.13u W=0.42u AS=0.3623875p AD=0.0798p
+ PS=2.605u PD=0.8u
M$2208 3 381 337 3 sg13_lv_pmos L=0.13u W=1u AS=0.3623875p AD=0.34p PS=2.605u
+ PD=2.68u
M$2209 3 104 354 3 sg13_lv_pmos L=0.13u W=1.12u AS=0.3808p AD=0.3808p PS=2.92u
+ PD=2.92u
M$2210 381 354 3 3 sg13_lv_pmos L=0.13u W=0.42u AS=0.147p AD=0.1563p PS=1.54u
+ PD=1.22u
M$2211 3 337 386 3 sg13_lv_pmos L=0.13u W=0.42u AS=0.1563p AD=0.063p PS=1.22u
+ PD=0.72u
M$2212 386 338 381 3 sg13_lv_pmos L=0.13u W=0.42u AS=0.063p AD=0.0798p PS=0.72u
+ PD=0.8u
M$2213 381 382 336 3 sg13_lv_pmos L=0.13u W=0.42u AS=0.0798p AD=0.1428p PS=0.8u
+ PD=1.52u
M$2220 396 405 3 3 sg13_lv_pmos L=0.13u W=1.12u AS=0.6048p AD=0.2198p PS=3.32u
+ PD=1.52u
M$2221 3 392 401 3 sg13_lv_pmos L=0.13u W=1u AS=0.2198p AD=0.2975p PS=1.52u
+ PD=1.595u
M$2222 401 227 405 3 sg13_lv_pmos L=0.13u W=1u AS=0.2975p AD=0.2225p PS=1.595u
+ PD=1.445u
M$2223 405 289 402 3 sg13_lv_pmos L=0.13u W=1u AS=0.2225p AD=0.3325p PS=1.445u
+ PD=1.665u
M$2224 402 97 3 3 sg13_lv_pmos L=0.13u W=1u AS=0.3325p AD=0.253p PS=1.665u
+ PD=1.53u
M$2225 3 97 392 3 sg13_lv_pmos L=0.13u W=0.84u AS=0.253p AD=0.2856p PS=1.53u
+ PD=2.36u
M$2226 3 414 413 3 sg13_lv_pmos L=0.13u W=6.72u AS=1.4448p AD=1.2768p PS=10.42u
+ PD=9u
M$2232 3 413 415 3 sg13_lv_pmos L=0.13u W=17.92u AS=3.4048p AD=3.5896p PS=24u
+ PD=25.45u
M$2249 3 394 403 3 sg13_lv_pmos L=0.13u W=1.12u AS=0.4032p AD=0.1176p PS=2.96u
+ PD=1.33u
M$2250 403 346 397 3 sg13_lv_pmos L=0.13u W=1.12u AS=0.1176p AD=0.3808p
+ PS=1.33u PD=2.92u
M$2251 398 327 3 3 sg13_lv_pmos L=0.13u W=1.12u AS=0.3808p AD=0.2128p PS=2.92u
+ PD=1.5u
M$2252 3 348 398 3 sg13_lv_pmos L=0.13u W=1.12u AS=0.2128p AD=0.2128p PS=1.5u
+ PD=1.5u
M$2253 398 346 399 3 sg13_lv_pmos L=0.13u W=1.12u AS=0.2128p AD=0.3808p PS=1.5u
+ PD=2.92u
M$2254 3 397 420 3 sg13_lv_pmos L=0.13u W=0.84u AS=0.4536p AD=0.1596p PS=2.76u
+ PD=1.22u
M$2255 3 349 420 3 sg13_lv_pmos L=0.13u W=0.84u AS=0.2891p AD=0.1596p PS=1.695u
+ PD=1.22u
M$2256 3 397 429 3 sg13_lv_pmos L=0.13u W=1.12u AS=0.2891p AD=0.1428p PS=1.695u
+ PD=1.375u
M$2257 429 349 416 3 sg13_lv_pmos L=0.13u W=1.12u AS=0.1428p AD=0.2408p
+ PS=1.375u PD=1.55u
M$2258 416 420 3 3 sg13_lv_pmos L=0.13u W=1.12u AS=0.2408p AD=0.3808p PS=1.55u
+ PD=2.92u
M$2259 3 270 400 3 sg13_lv_pmos L=0.13u W=1.12u AS=0.3808p AD=0.2128p PS=2.92u
+ PD=1.5u
M$2260 400 397 3 3 sg13_lv_pmos L=0.13u W=1.12u AS=0.2128p AD=0.3808p PS=1.5u
+ PD=2.92u
M$2261 417 422 428 3 sg13_lv_pmos L=0.13u W=1.12u AS=0.3808p AD=0.1176p
+ PS=2.92u PD=1.33u
M$2262 428 423 3 3 sg13_lv_pmos L=0.13u W=1.12u AS=0.1176p AD=0.4032p PS=1.33u
+ PD=2.96u
M$2263 418 424 427 3 sg13_lv_pmos L=0.13u W=1.12u AS=0.3808p AD=0.2128p
+ PS=2.92u PD=1.5u
M$2264 427 423 3 3 sg13_lv_pmos L=0.13u W=1.12u AS=0.2128p AD=0.2128p PS=1.5u
+ PD=1.5u
M$2265 3 422 427 3 sg13_lv_pmos L=0.13u W=1.12u AS=0.2128p AD=0.3808p PS=1.5u
+ PD=2.92u
M$2266 3 463 419 3 sg13_lv_pmos L=0.13u W=1.12u AS=0.3808p AD=0.3808p PS=2.92u
+ PD=2.92u
M$2300 433 432 3 3 sg13_lv_pmos L=0.13u W=0.84u AS=0.2856p AD=0.2114p PS=2.36u
+ PD=1.54u
M$2301 3 433 97 3 sg13_lv_pmos L=0.13u W=1.12u AS=0.2114p AD=0.42p PS=1.54u
+ PD=2.99u
M$2303 434 435 3 3 sg13_lv_pmos L=0.13u W=1.12u AS=0.6048p AD=0.2198p PS=3.32u
+ PD=1.52u
M$2304 3 430 450 3 sg13_lv_pmos L=0.13u W=1u AS=0.2198p AD=0.2975p PS=1.52u
+ PD=1.595u
M$2305 450 289 435 3 sg13_lv_pmos L=0.13u W=1u AS=0.2975p AD=0.2225p PS=1.595u
+ PD=1.445u
M$2306 435 457 451 3 sg13_lv_pmos L=0.13u W=1u AS=0.2225p AD=0.3325p PS=1.445u
+ PD=1.665u
M$2307 451 97 3 3 sg13_lv_pmos L=0.13u W=1u AS=0.3325p AD=0.253p PS=1.665u
+ PD=1.53u
M$2308 3 97 430 3 sg13_lv_pmos L=0.13u W=0.84u AS=0.253p AD=0.2856p PS=1.53u
+ PD=2.36u
M$2318 3 459 436 3 sg13_lv_pmos L=0.13u W=0.84u AS=0.4536p AD=0.1596p PS=2.76u
+ PD=1.22u
M$2319 3 458 436 3 sg13_lv_pmos L=0.13u W=0.84u AS=0.2891p AD=0.1596p PS=1.695u
+ PD=1.22u
M$2320 3 459 453 3 sg13_lv_pmos L=0.13u W=1.12u AS=0.2891p AD=0.1428p PS=1.695u
+ PD=1.375u
M$2321 453 458 347 3 sg13_lv_pmos L=0.13u W=1.12u AS=0.1428p AD=0.2408p
+ PS=1.375u PD=1.55u
M$2322 347 436 3 3 sg13_lv_pmos L=0.13u W=1.12u AS=0.2408p AD=0.3808p PS=1.55u
+ PD=2.92u
M$2340 437 460 438 3 sg13_lv_pmos L=0.13u W=1.12u AS=0.3808p AD=0.2128p
+ PS=2.92u PD=1.5u
M$2341 438 423 3 3 sg13_lv_pmos L=0.13u W=1.12u AS=0.2128p AD=0.2128p PS=1.5u
+ PD=1.5u
M$2342 3 422 438 3 sg13_lv_pmos L=0.13u W=1.12u AS=0.2128p AD=0.3808p PS=1.5u
+ PD=2.92u
M$2343 3 460 456 3 sg13_lv_pmos L=0.13u W=1.12u AS=0.3808p AD=0.2464p PS=2.92u
+ PD=1.56u
M$2344 456 461 455 3 sg13_lv_pmos L=0.13u W=1.12u AS=0.2464p AD=0.2128p
+ PS=1.56u PD=1.5u
M$2345 455 417 439 3 sg13_lv_pmos L=0.13u W=1.12u AS=0.2128p AD=0.3808p PS=1.5u
+ PD=2.92u
M$2346 440 462 441 3 sg13_lv_pmos L=0.13u W=1.12u AS=0.3808p AD=0.2128p
+ PS=2.92u PD=1.5u
M$2347 441 422 3 3 sg13_lv_pmos L=0.13u W=1.12u AS=0.2128p AD=0.2128p PS=1.5u
+ PD=1.5u
M$2348 3 460 441 3 sg13_lv_pmos L=0.13u W=1.12u AS=0.2128p AD=0.3808p PS=1.5u
+ PD=2.92u
M$2349 3 463 431 3 sg13_lv_pmos L=0.13u W=1.12u AS=0.3808p AD=0.3808p PS=2.92u
+ PD=2.92u
M$2350 3 418 442 3 sg13_lv_pmos L=0.13u W=0.42u AS=0.1428p AD=0.0798p PS=1.52u
+ PD=0.8u
M$2351 3 419 442 3 sg13_lv_pmos L=0.13u W=0.42u AS=0.3623875p AD=0.0798p
+ PS=2.605u PD=0.8u
M$2352 3 443 444 3 sg13_lv_pmos L=0.13u W=1u AS=0.3623875p AD=0.34p PS=2.605u
+ PD=2.68u
M$2353 3 419 443 3 sg13_lv_pmos L=0.13u W=0.42u AS=0.1563p AD=0.147p PS=1.22u
+ PD=1.54u
M$2354 3 444 454 3 sg13_lv_pmos L=0.13u W=0.42u AS=0.1563p AD=0.063p PS=1.22u
+ PD=0.72u
M$2355 454 446 443 3 sg13_lv_pmos L=0.13u W=0.42u AS=0.063p AD=0.0798p PS=0.72u
+ PD=0.8u
M$2356 443 445 442 3 sg13_lv_pmos L=0.13u W=0.42u AS=0.0798p AD=0.1428p PS=0.8u
+ PD=1.52u
M$2357 3 446 445 3 sg13_lv_pmos L=0.13u W=1.12u AS=0.41165p AD=0.3864p PS=2.12u
+ PD=2.93u
M$2358 3 461 446 3 sg13_lv_pmos L=0.13u W=1.12u AS=0.41165p AD=0.4088p PS=2.12u
+ PD=2.97u
M$2359 444 446 447 3 sg13_lv_pmos L=0.13u W=1u AS=0.34p AD=0.2048p PS=2.68u
+ PD=1.63u
M$2360 447 445 452 3 sg13_lv_pmos L=0.13u W=0.42u AS=0.2048p AD=0.09345p
+ PS=1.63u PD=0.865u
M$2361 3 448 452 3 sg13_lv_pmos L=0.13u W=0.42u AS=0.204p AD=0.09345p PS=1.835u
+ PD=0.865u
M$2362 3 419 448 3 sg13_lv_pmos L=0.13u W=0.42u AS=0.204p AD=0.0798p PS=1.835u
+ PD=0.8u
M$2363 3 447 448 3 sg13_lv_pmos L=0.13u W=0.42u AS=0.4659p AD=0.0798p PS=3.65u
+ PD=0.8u
M$2364 449 447 3 3 sg13_lv_pmos L=0.13u W=1.12u AS=0.3864p AD=0.2128p PS=2.93u
+ PD=1.5u
M$2365 3 449 423 3 sg13_lv_pmos L=0.13u W=1.12u AS=0.2128p AD=0.3808p PS=1.5u
+ PD=2.92u
M$2367 3 96 524 3 sg13_lv_pmos L=0.13u W=1.12u AS=0.3808p AD=0.3808p PS=2.92u
+ PD=2.92u
M$2368 3 434 483 3 sg13_lv_pmos L=0.13u W=0.42u AS=0.1428p AD=0.0798p PS=1.52u
+ PD=0.8u
M$2369 3 524 483 3 sg13_lv_pmos L=0.13u W=0.42u AS=0.3623875p AD=0.0798p
+ PS=2.605u PD=0.8u
M$2370 3 523 475 3 sg13_lv_pmos L=0.13u W=1u AS=0.3623875p AD=0.34p PS=2.605u
+ PD=2.68u
M$2371 536 476 3 3 sg13_lv_pmos L=0.13u W=1.12u AS=0.3864p AD=0.41165p PS=2.93u
+ PD=2.12u
M$2372 3 595 476 3 sg13_lv_pmos L=0.13u W=1.12u AS=0.41165p AD=0.4088p PS=2.12u
+ PD=2.97u
M$2373 486 536 541 3 sg13_lv_pmos L=0.13u W=0.42u AS=0.2048p AD=0.09345p
+ PS=1.63u PD=0.865u
M$2374 541 487 3 3 sg13_lv_pmos L=0.13u W=0.42u AS=0.09345p AD=0.204p PS=0.865u
+ PD=1.835u
M$2375 3 524 487 3 sg13_lv_pmos L=0.13u W=0.42u AS=0.204p AD=0.0798p PS=1.835u
+ PD=0.8u
M$2376 487 486 3 3 sg13_lv_pmos L=0.13u W=0.42u AS=0.0798p AD=0.4659p PS=0.8u
+ PD=3.65u
M$2377 475 476 486 3 sg13_lv_pmos L=0.13u W=1u AS=0.34p AD=0.2048p PS=2.68u
+ PD=1.63u
M$2378 488 486 3 3 sg13_lv_pmos L=0.13u W=1.12u AS=0.3864p AD=0.2128p PS=2.93u
+ PD=1.5u
M$2379 3 488 457 3 sg13_lv_pmos L=0.13u W=1.12u AS=0.2128p AD=0.3808p PS=1.5u
+ PD=2.92u
M$2380 3 457 489 3 sg13_lv_pmos L=0.13u W=1.12u AS=0.3808p AD=0.2128p PS=2.92u
+ PD=1.5u
M$2381 489 525 3 3 sg13_lv_pmos L=0.13u W=1.12u AS=0.2128p AD=0.3808p PS=1.5u
+ PD=2.92u
M$2382 3 457 547 3 sg13_lv_pmos L=0.13u W=1u AS=0.36p AD=0.1225p PS=2.72u
+ PD=1.245u
M$2383 547 525 490 3 sg13_lv_pmos L=0.13u W=1u AS=0.1225p AD=0.34p PS=1.245u
+ PD=2.68u
M$2384 544 457 3 3 sg13_lv_pmos L=0.13u W=1.12u AS=0.3808p AD=0.2128p PS=2.92u
+ PD=1.5u
M$2385 3 525 544 3 sg13_lv_pmos L=0.13u W=1.12u AS=0.2128p AD=0.2128p PS=1.5u
+ PD=1.5u
M$2386 544 490 458 3 sg13_lv_pmos L=0.13u W=1.12u AS=0.2128p AD=0.3808p PS=1.5u
+ PD=2.92u
M$2388 3 565 491 3 sg13_lv_pmos L=0.13u W=1.12u AS=0.3808p AD=0.2128p PS=2.92u
+ PD=1.5u
M$2389 491 492 3 3 sg13_lv_pmos L=0.13u W=1.12u AS=0.2128p AD=0.2128p PS=1.5u
+ PD=1.5u
M$2390 3 489 491 3 sg13_lv_pmos L=0.13u W=1.12u AS=0.2128p AD=0.3808p PS=1.5u
+ PD=2.92u
M$2391 3 458 492 3 sg13_lv_pmos L=0.13u W=1.12u AS=0.3808p AD=0.2128p PS=2.92u
+ PD=1.5u
M$2392 492 459 3 3 sg13_lv_pmos L=0.13u W=1.12u AS=0.2128p AD=0.3808p PS=1.5u
+ PD=2.92u
M$2397 3 463 527 3 sg13_lv_pmos L=0.13u W=1.12u AS=0.3808p AD=0.3808p PS=2.92u
+ PD=2.92u
M$2398 3 416 493 3 sg13_lv_pmos L=0.13u W=0.42u AS=0.1428p AD=0.0798p PS=1.52u
+ PD=0.8u
M$2399 3 527 493 3 sg13_lv_pmos L=0.13u W=0.42u AS=0.3623875p AD=0.0798p
+ PS=2.605u PD=0.8u
M$2400 3 526 477 3 sg13_lv_pmos L=0.13u W=1u AS=0.3623875p AD=0.34p PS=2.605u
+ PD=2.68u
M$2401 537 478 3 3 sg13_lv_pmos L=0.13u W=1.12u AS=0.3864p AD=0.41165p PS=2.93u
+ PD=2.12u
M$2402 3 118 478 3 sg13_lv_pmos L=0.13u W=1.12u AS=0.41165p AD=0.4088p PS=2.12u
+ PD=2.97u
M$2403 496 537 543 3 sg13_lv_pmos L=0.13u W=0.42u AS=0.2048p AD=0.09345p
+ PS=1.63u PD=0.865u
M$2404 543 497 3 3 sg13_lv_pmos L=0.13u W=0.42u AS=0.09345p AD=0.204p PS=0.865u
+ PD=1.835u
M$2405 3 527 497 3 sg13_lv_pmos L=0.13u W=0.42u AS=0.204p AD=0.0798p PS=1.835u
+ PD=0.8u
M$2406 497 496 3 3 sg13_lv_pmos L=0.13u W=0.42u AS=0.0798p AD=0.4659p PS=0.8u
+ PD=3.65u
M$2407 477 478 496 3 sg13_lv_pmos L=0.13u W=1u AS=0.34p AD=0.2048p PS=2.68u
+ PD=1.63u
M$2408 498 496 3 3 sg13_lv_pmos L=0.13u W=1.12u AS=0.3864p AD=0.2128p PS=2.93u
+ PD=1.5u
M$2409 3 498 459 3 sg13_lv_pmos L=0.13u W=1.12u AS=0.2128p AD=0.3808p PS=1.5u
+ PD=2.92u
M$2410 3 463 529 3 sg13_lv_pmos L=0.13u W=1.12u AS=0.3808p AD=0.3808p PS=2.92u
+ PD=2.92u
M$2411 3 437 499 3 sg13_lv_pmos L=0.13u W=0.42u AS=0.1428p AD=0.0798p PS=1.52u
+ PD=0.8u
M$2412 3 529 499 3 sg13_lv_pmos L=0.13u W=0.42u AS=0.3623875p AD=0.0798p
+ PS=2.605u PD=0.8u
M$2413 3 528 479 3 sg13_lv_pmos L=0.13u W=1u AS=0.3623875p AD=0.34p PS=2.605u
+ PD=2.68u
M$2414 538 480 3 3 sg13_lv_pmos L=0.13u W=1.12u AS=0.3864p AD=0.41165p PS=2.93u
+ PD=2.12u
M$2415 3 461 480 3 sg13_lv_pmos L=0.13u W=1.12u AS=0.41165p AD=0.4088p PS=2.12u
+ PD=2.97u
M$2416 502 538 542 3 sg13_lv_pmos L=0.13u W=0.42u AS=0.2048p AD=0.09345p
+ PS=1.63u PD=0.865u
M$2417 542 503 3 3 sg13_lv_pmos L=0.13u W=0.42u AS=0.09345p AD=0.204p PS=0.865u
+ PD=1.835u
M$2418 3 529 503 3 sg13_lv_pmos L=0.13u W=0.42u AS=0.204p AD=0.0798p PS=1.835u
+ PD=0.8u
M$2419 503 502 3 3 sg13_lv_pmos L=0.13u W=0.42u AS=0.0798p AD=0.4659p PS=0.8u
+ PD=3.65u
M$2420 479 480 502 3 sg13_lv_pmos L=0.13u W=1u AS=0.34p AD=0.2048p PS=2.68u
+ PD=1.63u
M$2421 504 502 3 3 sg13_lv_pmos L=0.13u W=1.12u AS=0.3864p AD=0.2128p PS=2.93u
+ PD=1.5u
M$2422 3 504 460 3 sg13_lv_pmos L=0.13u W=1.12u AS=0.2128p AD=0.3808p PS=1.5u
+ PD=2.92u
M$2423 3 440 505 3 sg13_lv_pmos L=0.13u W=0.42u AS=0.1428p AD=0.0798p PS=1.52u
+ PD=0.8u
M$2424 3 431 505 3 sg13_lv_pmos L=0.13u W=0.42u AS=0.3623875p AD=0.0798p
+ PS=2.605u PD=0.8u
M$2425 3 530 481 3 sg13_lv_pmos L=0.13u W=1u AS=0.3623875p AD=0.34p PS=2.605u
+ PD=2.68u
M$2426 539 482 3 3 sg13_lv_pmos L=0.13u W=1.12u AS=0.3864p AD=0.41165p PS=2.93u
+ PD=2.12u
M$2427 3 461 482 3 sg13_lv_pmos L=0.13u W=1.12u AS=0.41165p AD=0.4088p PS=2.12u
+ PD=2.97u
M$2428 508 539 540 3 sg13_lv_pmos L=0.13u W=0.42u AS=0.2048p AD=0.09345p
+ PS=1.63u PD=0.865u
M$2429 540 509 3 3 sg13_lv_pmos L=0.13u W=0.42u AS=0.09345p AD=0.204p PS=0.865u
+ PD=1.835u
M$2430 3 431 509 3 sg13_lv_pmos L=0.13u W=0.42u AS=0.204p AD=0.0798p PS=1.835u
+ PD=0.8u
M$2431 509 508 3 3 sg13_lv_pmos L=0.13u W=0.42u AS=0.0798p AD=0.4659p PS=0.8u
+ PD=3.65u
M$2432 481 482 508 3 sg13_lv_pmos L=0.13u W=1u AS=0.34p AD=0.2048p PS=2.68u
+ PD=1.63u
M$2433 510 508 3 3 sg13_lv_pmos L=0.13u W=1.12u AS=0.3864p AD=0.2128p PS=2.93u
+ PD=1.5u
M$2434 3 510 422 3 sg13_lv_pmos L=0.13u W=1.12u AS=0.2128p AD=0.3808p PS=1.5u
+ PD=2.92u
M$2435 550 96 3 3 sg13_lv_pmos L=0.13u W=1.12u AS=0.3808p AD=0.3808p PS=2.92u
+ PD=2.92u
M$2436 3 570 552 3 sg13_lv_pmos L=0.13u W=0.84u AS=0.2114p AD=0.2856p PS=1.54u
+ PD=2.36u
M$2437 96 552 3 3 sg13_lv_pmos L=0.13u W=1.12u AS=0.42p AD=0.2114p PS=2.99u
+ PD=1.54u
M$2438 523 524 3 3 sg13_lv_pmos L=0.13u W=0.42u AS=0.147p AD=0.1563p PS=1.54u
+ PD=1.22u
M$2439 3 475 545 3 sg13_lv_pmos L=0.13u W=0.42u AS=0.1563p AD=0.063p PS=1.22u
+ PD=0.72u
M$2440 545 476 523 3 sg13_lv_pmos L=0.13u W=0.42u AS=0.063p AD=0.0798p PS=0.72u
+ PD=0.8u
M$2441 523 536 483 3 sg13_lv_pmos L=0.13u W=0.42u AS=0.0798p AD=0.1428p PS=0.8u
+ PD=1.52u
M$2442 559 557 3 3 sg13_lv_pmos L=0.13u W=1.12u AS=0.3864p AD=0.2128p PS=2.93u
+ PD=1.5u
M$2443 3 559 560 3 sg13_lv_pmos L=0.13u W=1.12u AS=0.2128p AD=0.3808p PS=1.5u
+ PD=2.92u
M$2444 3 560 577 3 sg13_lv_pmos L=0.13u W=1u AS=0.36p AD=0.1225p PS=2.72u
+ PD=1.245u
M$2445 577 525 561 3 sg13_lv_pmos L=0.13u W=1u AS=0.1225p AD=0.34p PS=1.245u
+ PD=2.68u
M$2446 562 560 3 3 sg13_lv_pmos L=0.13u W=1.12u AS=0.3808p AD=0.2128p PS=2.92u
+ PD=1.5u
M$2447 3 525 562 3 sg13_lv_pmos L=0.13u W=1.12u AS=0.2128p AD=0.2128p PS=1.5u
+ PD=1.5u
M$2448 562 561 563 3 sg13_lv_pmos L=0.13u W=1.12u AS=0.2128p AD=0.3808p PS=1.5u
+ PD=2.92u
M$2450 3 574 564 3 sg13_lv_pmos L=0.13u W=0.84u AS=0.4536p AD=0.1596p PS=2.76u
+ PD=1.22u
M$2451 3 563 564 3 sg13_lv_pmos L=0.13u W=0.84u AS=0.2891p AD=0.1596p PS=1.695u
+ PD=1.22u
M$2452 3 574 578 3 sg13_lv_pmos L=0.13u W=1.12u AS=0.2891p AD=0.1428p PS=1.695u
+ PD=1.375u
M$2453 578 563 565 3 sg13_lv_pmos L=0.13u W=1.12u AS=0.1428p AD=0.2408p
+ PS=1.375u PD=1.55u
M$2454 565 564 3 3 sg13_lv_pmos L=0.13u W=1.12u AS=0.2408p AD=0.3808p PS=1.55u
+ PD=2.92u
M$2455 566 565 567 3 sg13_lv_pmos L=0.13u W=1.12u AS=0.3808p AD=0.2128p
+ PS=2.92u PD=1.5u
M$2456 567 489 3 3 sg13_lv_pmos L=0.13u W=1.12u AS=0.2128p AD=0.2128p PS=1.5u
+ PD=1.5u
M$2457 3 492 567 3 sg13_lv_pmos L=0.13u W=1.12u AS=0.2128p AD=0.3808p PS=1.5u
+ PD=2.92u
M$2466 526 527 3 3 sg13_lv_pmos L=0.13u W=0.42u AS=0.147p AD=0.1563p PS=1.54u
+ PD=1.22u
M$2467 3 477 549 3 sg13_lv_pmos L=0.13u W=0.42u AS=0.1563p AD=0.063p PS=1.22u
+ PD=0.72u
M$2468 549 478 526 3 sg13_lv_pmos L=0.13u W=0.42u AS=0.063p AD=0.0798p PS=0.72u
+ PD=0.8u
M$2469 526 537 493 3 sg13_lv_pmos L=0.13u W=0.42u AS=0.0798p AD=0.1428p PS=0.8u
+ PD=1.52u
M$2478 528 529 3 3 sg13_lv_pmos L=0.13u W=0.42u AS=0.147p AD=0.1563p PS=1.54u
+ PD=1.22u
M$2479 3 479 548 3 sg13_lv_pmos L=0.13u W=0.42u AS=0.1563p AD=0.063p PS=1.22u
+ PD=0.72u
M$2480 548 480 528 3 sg13_lv_pmos L=0.13u W=0.42u AS=0.063p AD=0.0798p PS=0.72u
+ PD=0.8u
M$2481 528 538 499 3 sg13_lv_pmos L=0.13u W=0.42u AS=0.0798p AD=0.1428p PS=0.8u
+ PD=1.52u
M$2483 3 525 580 3 sg13_lv_pmos L=0.15u W=1.12u AS=0.3808p AD=0.2128p PS=2.92u
+ PD=1.5u
M$2484 580 575 551 3 sg13_lv_pmos L=0.15u W=1.12u AS=0.2128p AD=0.2128p PS=1.5u
+ PD=1.5u
M$2485 551 439 3 3 sg13_lv_pmos L=0.15u W=1.12u AS=0.2128p AD=0.3808p PS=1.5u
+ PD=2.92u
M$2486 3 422 579 3 sg13_lv_pmos L=0.15u W=1.12u AS=0.3808p AD=0.2128p PS=2.92u
+ PD=1.5u
M$2487 579 460 462 3 sg13_lv_pmos L=0.15u W=1.12u AS=0.2128p AD=0.2128p PS=1.5u
+ PD=1.5u
M$2488 462 575 3 3 sg13_lv_pmos L=0.15u W=1.12u AS=0.2128p AD=0.3808p PS=1.5u
+ PD=2.92u
M$2489 3 423 575 3 sg13_lv_pmos L=0.13u W=1.12u AS=0.3808p AD=0.2128p PS=2.92u
+ PD=1.5u
M$2490 575 422 3 3 sg13_lv_pmos L=0.13u W=1.12u AS=0.2128p AD=0.3808p PS=1.5u
+ PD=2.92u
M$2491 568 460 3 3 sg13_lv_pmos L=0.13u W=1.12u AS=0.3808p AD=0.2128p PS=2.92u
+ PD=1.5u
M$2492 3 422 568 3 sg13_lv_pmos L=0.13u W=1.12u AS=0.2128p AD=0.2128p PS=1.5u
+ PD=1.5u
M$2493 568 423 424 3 sg13_lv_pmos L=0.13u W=1.12u AS=0.2128p AD=0.3808p PS=1.5u
+ PD=2.92u
M$2496 530 431 3 3 sg13_lv_pmos L=0.13u W=0.42u AS=0.147p AD=0.1563p PS=1.54u
+ PD=1.22u
M$2497 3 481 546 3 sg13_lv_pmos L=0.13u W=0.42u AS=0.1563p AD=0.063p PS=1.22u
+ PD=0.72u
M$2498 546 482 530 3 sg13_lv_pmos L=0.13u W=0.42u AS=0.063p AD=0.0798p PS=0.72u
+ PD=0.8u
M$2499 530 539 505 3 sg13_lv_pmos L=0.13u W=0.42u AS=0.0798p AD=0.1428p PS=0.8u
+ PD=1.52u
M$2505 3 571 553 3 sg13_lv_pmos L=0.13u W=0.42u AS=0.1428p AD=0.0798p PS=1.52u
+ PD=0.8u
M$2506 3 550 553 3 sg13_lv_pmos L=0.13u W=0.42u AS=0.3623875p AD=0.0798p
+ PS=2.605u PD=0.8u
M$2507 3 555 554 3 sg13_lv_pmos L=0.13u W=1u AS=0.3623875p AD=0.34p PS=2.605u
+ PD=2.68u
M$2508 3 97 605 3 sg13_lv_pmos L=0.13u W=0.84u AS=0.253p AD=0.2856p PS=1.53u
+ PD=2.36u
M$2509 3 605 623 3 sg13_lv_pmos L=0.13u W=1u AS=0.2198p AD=0.2975p PS=1.52u
+ PD=1.595u
M$2510 623 457 593 3 sg13_lv_pmos L=0.13u W=1u AS=0.2975p AD=0.2225p PS=1.595u
+ PD=1.445u
M$2511 593 560 624 3 sg13_lv_pmos L=0.13u W=1u AS=0.2225p AD=0.3325p PS=1.445u
+ PD=1.665u
M$2512 624 97 3 3 sg13_lv_pmos L=0.13u W=1u AS=0.3325p AD=0.253p PS=1.665u
+ PD=1.53u
M$2513 571 593 3 3 sg13_lv_pmos L=0.13u W=1.12u AS=0.6048p AD=0.2198p PS=3.32u
+ PD=1.52u
M$2514 3 550 555 3 sg13_lv_pmos L=0.13u W=0.42u AS=0.1563p AD=0.147p PS=1.22u
+ PD=1.54u
M$2515 3 554 569 3 sg13_lv_pmos L=0.13u W=0.42u AS=0.1563p AD=0.063p PS=1.22u
+ PD=0.72u
M$2516 569 573 555 3 sg13_lv_pmos L=0.13u W=0.42u AS=0.063p AD=0.0798p PS=0.72u
+ PD=0.8u
M$2517 555 556 553 3 sg13_lv_pmos L=0.13u W=0.42u AS=0.0798p AD=0.1428p PS=0.8u
+ PD=1.52u
M$2518 3 573 556 3 sg13_lv_pmos L=0.13u W=1.12u AS=0.41165p AD=0.3864p PS=2.12u
+ PD=2.93u
M$2519 3 595 573 3 sg13_lv_pmos L=0.13u W=1.12u AS=0.41165p AD=0.4088p PS=2.12u
+ PD=2.97u
M$2520 594 595 3 3 sg13_lv_pmos L=0.13u W=1.12u AS=0.3808p AD=0.3808p PS=2.92u
+ PD=2.92u
M$2521 3 596 595 3 sg13_lv_pmos L=0.13u W=17.92u AS=3.5896p AD=3.4048p
+ PS=25.45u PD=24u
M$2537 3 415 596 3 sg13_lv_pmos L=0.13u W=6.72u AS=1.2768p AD=1.4448p PS=9u
+ PD=10.42u
M$2543 554 573 557 3 sg13_lv_pmos L=0.13u W=1u AS=0.34p AD=0.2048p PS=2.68u
+ PD=1.63u
M$2544 557 556 576 3 sg13_lv_pmos L=0.13u W=0.42u AS=0.2048p AD=0.09345p
+ PS=1.63u PD=0.865u
M$2545 3 558 576 3 sg13_lv_pmos L=0.13u W=0.42u AS=0.204p AD=0.09345p PS=1.835u
+ PD=0.865u
M$2546 3 550 558 3 sg13_lv_pmos L=0.13u W=0.42u AS=0.204p AD=0.0798p PS=1.835u
+ PD=0.8u
M$2547 3 557 558 3 sg13_lv_pmos L=0.13u W=0.42u AS=0.4659p AD=0.0798p PS=3.65u
+ PD=0.8u
M$2548 3 563 606 3 sg13_lv_pmos L=0.13u W=1.12u AS=0.3808p AD=0.2128p PS=2.92u
+ PD=1.5u
M$2549 606 574 3 3 sg13_lv_pmos L=0.13u W=1.12u AS=0.2128p AD=0.3808p PS=1.5u
+ PD=2.92u
M$2550 607 491 3 3 sg13_lv_pmos L=0.13u W=0.84u AS=0.2856p AD=0.2618p PS=2.36u
+ PD=1.63u
M$2551 3 607 625 3 sg13_lv_pmos L=0.13u W=1.12u AS=0.2618p AD=0.1176p PS=1.63u
+ PD=1.33u
M$2552 625 566 597 3 sg13_lv_pmos L=0.13u W=1.12u AS=0.1176p AD=0.3808p
+ PS=1.33u PD=2.92u
M$2553 622 395 3 3 sg13_lv_pmos L=0.13u W=1.12u AS=0.3808p AD=0.2128p PS=2.92u
+ PD=1.5u
M$2554 3 597 622 3 sg13_lv_pmos L=0.13u W=1.12u AS=0.2128p AD=0.2128p PS=1.5u
+ PD=1.5u
M$2555 622 608 609 3 sg13_lv_pmos L=0.13u W=1.12u AS=0.2128p AD=0.3808p PS=1.5u
+ PD=2.92u
M$2556 3 463 598 3 sg13_lv_pmos L=0.13u W=1.12u AS=0.3808p AD=0.3808p PS=2.92u
+ PD=2.92u
M$2557 621 601 3 3 sg13_lv_pmos L=0.13u W=1.12u AS=0.3864p AD=0.41165p PS=2.93u
+ PD=2.12u
M$2558 3 247 601 3 sg13_lv_pmos L=0.13u W=1.12u AS=0.41165p AD=0.4088p PS=2.12u
+ PD=2.97u
M$2559 611 621 628 3 sg13_lv_pmos L=0.13u W=0.42u AS=0.2048p AD=0.09345p
+ PS=1.63u PD=0.865u
M$2560 628 603 3 3 sg13_lv_pmos L=0.13u W=0.42u AS=0.09345p AD=0.204p PS=0.865u
+ PD=1.835u
M$2561 3 598 603 3 sg13_lv_pmos L=0.13u W=0.42u AS=0.204p AD=0.0798p PS=1.835u
+ PD=0.8u
M$2562 603 611 3 3 sg13_lv_pmos L=0.13u W=0.42u AS=0.0798p AD=0.4659p PS=0.8u
+ PD=3.65u
M$2563 600 601 611 3 sg13_lv_pmos L=0.13u W=1u AS=0.34p AD=0.2048p PS=2.68u
+ PD=1.63u
M$2564 604 611 3 3 sg13_lv_pmos L=0.13u W=1.12u AS=0.3864p AD=0.2128p PS=2.93u
+ PD=1.5u
M$2565 3 604 574 3 sg13_lv_pmos L=0.13u W=1.12u AS=0.2128p AD=0.3808p PS=1.5u
+ PD=2.92u
M$2566 525 612 3 3 sg13_lv_pmos L=0.13u W=1.12u AS=0.42p AD=0.2114p PS=2.99u
+ PD=1.54u
M$2567 3 723 612 3 sg13_lv_pmos L=0.13u W=0.84u AS=0.2114p AD=0.2856p PS=1.54u
+ PD=2.36u
M$2592 3 395 626 3 sg13_lv_pmos L=0.13u W=1u AS=0.36p AD=0.1225p PS=2.72u
+ PD=1.245u
M$2593 626 597 608 3 sg13_lv_pmos L=0.13u W=1u AS=0.1225p AD=0.34p PS=1.245u
+ PD=2.68u
M$2596 3 609 599 3 sg13_lv_pmos L=0.13u W=0.42u AS=0.1428p AD=0.0798p PS=1.52u
+ PD=0.8u
M$2597 3 598 599 3 sg13_lv_pmos L=0.13u W=0.42u AS=0.3623875p AD=0.0798p
+ PS=2.605u PD=0.8u
M$2598 3 620 600 3 sg13_lv_pmos L=0.13u W=1u AS=0.3623875p AD=0.34p PS=2.605u
+ PD=2.68u
M$2601 620 598 3 3 sg13_lv_pmos L=0.13u W=0.42u AS=0.147p AD=0.1563p PS=1.54u
+ PD=1.22u
M$2602 3 600 627 3 sg13_lv_pmos L=0.13u W=0.42u AS=0.1563p AD=0.063p PS=1.22u
+ PD=0.72u
M$2603 627 601 620 3 sg13_lv_pmos L=0.13u W=0.42u AS=0.063p AD=0.0798p PS=0.72u
+ PD=0.8u
M$2604 620 621 599 3 sg13_lv_pmos L=0.13u W=0.42u AS=0.0798p AD=0.1428p PS=0.8u
+ PD=1.52u
M$2644 3 97 647 3 sg13_lv_pmos L=0.13u W=0.84u AS=0.253p AD=0.2856p PS=1.53u
+ PD=2.36u
M$2645 3 647 677 3 sg13_lv_pmos L=0.13u W=1u AS=0.2198p AD=0.2975p PS=1.52u
+ PD=1.595u
M$2646 677 560 633 3 sg13_lv_pmos L=0.13u W=1u AS=0.2975p AD=0.2225p PS=1.595u
+ PD=1.445u
M$2647 633 646 678 3 sg13_lv_pmos L=0.13u W=1u AS=0.2225p AD=0.3325p PS=1.445u
+ PD=1.665u
M$2648 678 97 3 3 sg13_lv_pmos L=0.13u W=1u AS=0.3325p AD=0.253p PS=1.665u
+ PD=1.53u
M$2649 632 633 3 3 sg13_lv_pmos L=0.13u W=1.12u AS=0.6048p AD=0.2198p PS=3.32u
+ PD=1.52u
M$2655 3 560 634 3 sg13_lv_pmos L=0.13u W=1.12u AS=0.3808p AD=0.2128p PS=2.92u
+ PD=1.5u
M$2656 634 525 3 3 sg13_lv_pmos L=0.13u W=1.12u AS=0.2128p AD=0.3808p PS=1.5u
+ PD=2.92u
M$2657 673 606 3 3 sg13_lv_pmos L=0.13u W=1.12u AS=0.3808p AD=0.2128p PS=2.92u
+ PD=1.5u
M$2658 3 634 673 3 sg13_lv_pmos L=0.13u W=1.12u AS=0.2128p AD=0.2128p PS=1.5u
+ PD=1.5u
M$2659 673 671 648 3 sg13_lv_pmos L=0.13u W=1.12u AS=0.2128p AD=0.3808p PS=1.5u
+ PD=2.92u
M$2660 3 671 635 3 sg13_lv_pmos L=0.13u W=1.12u AS=0.3808p AD=0.2128p PS=2.92u
+ PD=1.5u
M$2661 635 606 3 3 sg13_lv_pmos L=0.13u W=1.12u AS=0.2128p AD=0.2128p PS=1.5u
+ PD=1.5u
M$2662 3 634 635 3 sg13_lv_pmos L=0.13u W=1.12u AS=0.2128p AD=0.3808p PS=1.5u
+ PD=2.92u
M$2663 649 635 3 3 sg13_lv_pmos L=0.13u W=0.84u AS=0.2856p AD=0.2618p PS=2.36u
+ PD=1.63u
M$2664 3 649 680 3 sg13_lv_pmos L=0.13u W=1.12u AS=0.2618p AD=0.1176p PS=1.63u
+ PD=1.33u
M$2665 680 648 636 3 sg13_lv_pmos L=0.13u W=1.12u AS=0.1176p AD=0.3808p
+ PS=1.33u PD=2.92u
M$2666 3 635 674 3 sg13_lv_pmos L=0.13u W=1.12u AS=0.3808p AD=0.2128p PS=2.92u
+ PD=1.5u
M$2667 674 566 3 3 sg13_lv_pmos L=0.13u W=1.12u AS=0.2128p AD=0.3808p PS=1.5u
+ PD=2.92u
M$2668 675 651 674 3 sg13_lv_pmos L=0.13u W=1.12u AS=0.3808p AD=0.2128p
+ PS=2.92u PD=1.5u
M$2669 674 395 675 3 sg13_lv_pmos L=0.13u W=1.12u AS=0.2128p AD=0.2128p PS=1.5u
+ PD=1.5u
M$2670 675 648 650 3 sg13_lv_pmos L=0.13u W=1.12u AS=0.2128p AD=0.3808p PS=1.5u
+ PD=2.92u
M$2671 629 566 630 3 sg13_lv_pmos L=0.13u W=1.12u AS=0.3808p AD=0.2128p
+ PS=2.92u PD=1.5u
M$2672 630 395 3 3 sg13_lv_pmos L=0.13u W=1.12u AS=0.2128p AD=0.2128p PS=1.5u
+ PD=1.5u
M$2673 3 597 630 3 sg13_lv_pmos L=0.13u W=1.12u AS=0.2128p AD=0.3808p PS=1.5u
+ PD=2.92u
M$2674 651 652 3 3 sg13_lv_pmos L=0.13u W=1.12u AS=0.3808p AD=0.1918p PS=2.92u
+ PD=1.5u
M$2675 3 636 652 3 sg13_lv_pmos L=0.13u W=0.84u AS=0.1918p AD=0.1596p PS=1.5u
+ PD=1.22u
M$2676 652 597 3 3 sg13_lv_pmos L=0.13u W=0.84u AS=0.1596p AD=0.2856p PS=1.22u
+ PD=2.36u
M$2690 3 463 637 3 sg13_lv_pmos L=0.13u W=1.12u AS=0.3808p AD=0.3808p PS=2.92u
+ PD=2.92u
M$2691 653 654 3 3 sg13_lv_pmos L=0.13u W=1.12u AS=0.3808p AD=0.1918p PS=2.92u
+ PD=1.5u
M$2692 3 551 654 3 sg13_lv_pmos L=0.13u W=0.84u AS=0.1918p AD=0.1596p PS=1.5u
+ PD=1.22u
M$2693 654 638 3 3 sg13_lv_pmos L=0.13u W=0.84u AS=0.1596p AD=0.2856p PS=1.22u
+ PD=2.36u
M$2695 3 104 639 3 sg13_lv_pmos L=0.13u W=1.12u AS=0.3808p AD=0.3808p PS=2.92u
+ PD=2.92u
M$2696 3 638 640 3 sg13_lv_pmos L=0.13u W=0.42u AS=0.1428p AD=0.0798p PS=1.52u
+ PD=0.8u
M$2697 3 639 640 3 sg13_lv_pmos L=0.13u W=0.42u AS=0.3623875p AD=0.0798p
+ PS=2.605u PD=0.8u
M$2698 3 672 641 3 sg13_lv_pmos L=0.13u W=1u AS=0.3623875p AD=0.34p PS=2.605u
+ PD=2.68u
M$2699 656 642 3 3 sg13_lv_pmos L=0.13u W=1.12u AS=0.3864p AD=0.41165p PS=2.93u
+ PD=2.12u
M$2700 3 730 642 3 sg13_lv_pmos L=0.13u W=1.12u AS=0.41165p AD=0.4088p PS=2.12u
+ PD=2.97u
M$2701 657 656 676 3 sg13_lv_pmos L=0.13u W=0.42u AS=0.2048p AD=0.09345p
+ PS=1.63u PD=0.865u
M$2702 676 644 3 3 sg13_lv_pmos L=0.13u W=0.42u AS=0.09345p AD=0.204p PS=0.865u
+ PD=1.835u
M$2703 3 639 644 3 sg13_lv_pmos L=0.13u W=0.42u AS=0.204p AD=0.0798p PS=1.835u
+ PD=0.8u
M$2704 644 657 3 3 sg13_lv_pmos L=0.13u W=0.42u AS=0.0798p AD=0.4659p PS=0.8u
+ PD=3.65u
M$2705 641 642 657 3 sg13_lv_pmos L=0.13u W=1u AS=0.34p AD=0.2048p PS=2.68u
+ PD=1.63u
M$2706 645 657 3 3 sg13_lv_pmos L=0.13u W=1.12u AS=0.3864p AD=0.2128p PS=2.93u
+ PD=1.5u
M$2707 3 645 461 3 sg13_lv_pmos L=0.13u W=1.12u AS=0.2128p AD=0.3808p PS=1.5u
+ PD=2.92u
M$2710 3 718 681 3 sg13_lv_pmos L=0.13u W=1.12u AS=0.3808p AD=0.3808p PS=2.92u
+ PD=2.92u
M$2711 3 719 688 3 sg13_lv_pmos L=0.13u W=0.42u AS=0.1428p AD=0.0798p PS=1.52u
+ PD=0.8u
M$2712 3 717 688 3 sg13_lv_pmos L=0.13u W=0.42u AS=0.3623875p AD=0.0798p
+ PS=2.605u PD=0.8u
M$2713 3 690 689 3 sg13_lv_pmos L=0.13u W=1u AS=0.3623875p AD=0.34p PS=2.605u
+ PD=2.68u
M$2714 3 717 690 3 sg13_lv_pmos L=0.13u W=0.42u AS=0.1563p AD=0.147p PS=1.22u
+ PD=1.54u
M$2715 3 689 714 3 sg13_lv_pmos L=0.13u W=0.42u AS=0.1563p AD=0.063p PS=1.22u
+ PD=0.72u
M$2716 714 721 690 3 sg13_lv_pmos L=0.13u W=0.42u AS=0.063p AD=0.0798p PS=0.72u
+ PD=0.8u
M$2717 690 691 688 3 sg13_lv_pmos L=0.13u W=0.42u AS=0.0798p AD=0.1428p PS=0.8u
+ PD=1.52u
M$2718 3 721 691 3 sg13_lv_pmos L=0.13u W=1.12u AS=0.41165p AD=0.3864p PS=2.12u
+ PD=2.93u
M$2719 3 595 721 3 sg13_lv_pmos L=0.13u W=1.12u AS=0.41165p AD=0.4088p PS=2.12u
+ PD=2.97u
M$2720 689 721 722 3 sg13_lv_pmos L=0.13u W=1u AS=0.34p AD=0.2048p PS=2.68u
+ PD=1.63u
M$2721 722 691 734 3 sg13_lv_pmos L=0.13u W=0.42u AS=0.2048p AD=0.09345p
+ PS=1.63u PD=0.865u
M$2722 3 692 734 3 sg13_lv_pmos L=0.13u W=0.42u AS=0.204p AD=0.09345p PS=1.835u
+ PD=0.865u
M$2723 3 717 692 3 sg13_lv_pmos L=0.13u W=0.42u AS=0.204p AD=0.0798p PS=1.835u
+ PD=0.8u
M$2724 3 722 692 3 sg13_lv_pmos L=0.13u W=0.42u AS=0.4659p AD=0.0798p PS=3.65u
+ PD=0.8u
M$2725 693 722 3 3 sg13_lv_pmos L=0.13u W=1.12u AS=0.3864p AD=0.2128p PS=2.93u
+ PD=1.5u
M$2726 3 693 694 3 sg13_lv_pmos L=0.13u W=1.12u AS=0.2128p AD=0.3808p PS=1.5u
+ PD=2.92u
M$2727 3 646 695 3 sg13_lv_pmos L=0.13u W=0.84u AS=0.2618p AD=0.2856p PS=1.63u
+ PD=2.36u
M$2728 3 695 736 3 sg13_lv_pmos L=0.13u W=1.12u AS=0.2618p AD=0.1176p PS=1.63u
+ PD=1.33u
M$2729 736 723 696 3 sg13_lv_pmos L=0.13u W=1.12u AS=0.1176p AD=0.3808p
+ PS=1.33u PD=2.92u
M$2730 697 696 698 3 sg13_lv_pmos L=0.13u W=1.12u AS=0.3808p AD=0.2128p
+ PS=2.92u PD=1.5u
M$2731 698 724 3 3 sg13_lv_pmos L=0.13u W=1.12u AS=0.2128p AD=0.2128p PS=1.5u
+ PD=1.5u
M$2732 3 725 698 3 sg13_lv_pmos L=0.13u W=1.12u AS=0.2128p AD=0.3808p PS=1.5u
+ PD=2.92u
M$2737 3 636 699 3 sg13_lv_pmos L=0.13u W=0.84u AS=0.4536p AD=0.1596p PS=2.76u
+ PD=1.22u
M$2738 3 629 699 3 sg13_lv_pmos L=0.13u W=0.84u AS=0.2891p AD=0.1596p PS=1.695u
+ PD=1.22u
M$2739 3 636 737 3 sg13_lv_pmos L=0.13u W=1.12u AS=0.2891p AD=0.1428p PS=1.695u
+ PD=1.375u
M$2740 737 629 700 3 sg13_lv_pmos L=0.13u W=1.12u AS=0.1428p AD=0.2408p
+ PS=1.375u PD=1.55u
M$2741 700 699 3 3 sg13_lv_pmos L=0.13u W=1.12u AS=0.2408p AD=0.3808p PS=1.55u
+ PD=2.92u
M$2742 3 700 701 3 sg13_lv_pmos L=0.13u W=0.42u AS=0.1428p AD=0.0798p PS=1.52u
+ PD=0.8u
M$2743 3 682 701 3 sg13_lv_pmos L=0.13u W=0.42u AS=0.3623875p AD=0.0798p
+ PS=2.605u PD=0.8u
M$2744 3 703 702 3 sg13_lv_pmos L=0.13u W=1u AS=0.3623875p AD=0.34p PS=2.605u
+ PD=2.68u
M$2745 3 682 703 3 sg13_lv_pmos L=0.13u W=0.42u AS=0.1563p AD=0.147p PS=1.22u
+ PD=1.54u
M$2746 3 702 716 3 sg13_lv_pmos L=0.13u W=0.42u AS=0.1563p AD=0.063p PS=1.22u
+ PD=0.72u
M$2747 716 727 703 3 sg13_lv_pmos L=0.13u W=0.42u AS=0.063p AD=0.0798p PS=0.72u
+ PD=0.8u
M$2748 703 704 701 3 sg13_lv_pmos L=0.13u W=0.42u AS=0.0798p AD=0.1428p PS=0.8u
+ PD=1.52u
M$2749 3 727 704 3 sg13_lv_pmos L=0.13u W=1.12u AS=0.41165p AD=0.3864p PS=2.12u
+ PD=2.93u
M$2750 3 247 727 3 sg13_lv_pmos L=0.13u W=1.12u AS=0.41165p AD=0.4088p PS=2.12u
+ PD=2.97u
M$2751 702 727 728 3 sg13_lv_pmos L=0.13u W=1u AS=0.34p AD=0.2048p PS=2.68u
+ PD=1.63u
M$2752 728 704 738 3 sg13_lv_pmos L=0.13u W=0.42u AS=0.2048p AD=0.09345p
+ PS=1.63u PD=0.865u
M$2753 3 705 738 3 sg13_lv_pmos L=0.13u W=0.42u AS=0.204p AD=0.09345p PS=1.835u
+ PD=0.865u
M$2754 3 682 705 3 sg13_lv_pmos L=0.13u W=0.42u AS=0.204p AD=0.0798p PS=1.835u
+ PD=0.8u
M$2755 3 728 705 3 sg13_lv_pmos L=0.13u W=0.42u AS=0.4659p AD=0.0798p PS=3.65u
+ PD=0.8u
M$2756 706 728 3 3 sg13_lv_pmos L=0.13u W=1.12u AS=0.3864p AD=0.2128p PS=2.93u
+ PD=1.5u
M$2757 3 706 724 3 sg13_lv_pmos L=0.13u W=1.12u AS=0.2128p AD=0.3808p PS=1.5u
+ PD=2.92u
M$2760 683 729 3 3 sg13_lv_pmos L=0.13u W=1.12u AS=0.3808p AD=0.3808p PS=2.92u
+ PD=2.92u
M$2761 3 463 684 3 sg13_lv_pmos L=0.13u W=1.12u AS=0.3808p AD=0.3808p PS=2.92u
+ PD=2.92u
M$2763 685 730 3 3 sg13_lv_pmos L=0.13u W=1.12u AS=0.3808p AD=0.3808p PS=2.92u
+ PD=2.92u
M$2764 3 653 707 3 sg13_lv_pmos L=0.13u W=0.42u AS=0.1428p AD=0.0798p PS=1.52u
+ PD=0.8u
M$2765 3 637 707 3 sg13_lv_pmos L=0.13u W=0.42u AS=0.3623875p AD=0.0798p
+ PS=2.605u PD=0.8u
M$2766 3 709 708 3 sg13_lv_pmos L=0.13u W=1u AS=0.3623875p AD=0.34p PS=2.605u
+ PD=2.68u
M$2767 3 637 709 3 sg13_lv_pmos L=0.13u W=0.42u AS=0.1563p AD=0.147p PS=1.22u
+ PD=1.54u
M$2768 3 708 715 3 sg13_lv_pmos L=0.13u W=0.42u AS=0.1563p AD=0.063p PS=1.22u
+ PD=0.72u
M$2769 715 732 709 3 sg13_lv_pmos L=0.13u W=0.42u AS=0.063p AD=0.0798p PS=0.72u
+ PD=0.8u
M$2770 709 710 707 3 sg13_lv_pmos L=0.13u W=0.42u AS=0.0798p AD=0.1428p PS=0.8u
+ PD=1.52u
M$2771 3 732 710 3 sg13_lv_pmos L=0.13u W=1.12u AS=0.41165p AD=0.3864p PS=2.12u
+ PD=2.93u
M$2772 3 730 732 3 sg13_lv_pmos L=0.13u W=1.12u AS=0.41165p AD=0.4088p PS=2.12u
+ PD=2.97u
M$2773 708 732 733 3 sg13_lv_pmos L=0.13u W=1u AS=0.34p AD=0.2048p PS=2.68u
+ PD=1.63u
M$2774 733 710 735 3 sg13_lv_pmos L=0.13u W=0.42u AS=0.2048p AD=0.09345p
+ PS=1.63u PD=0.865u
M$2775 3 711 735 3 sg13_lv_pmos L=0.13u W=0.42u AS=0.204p AD=0.09345p PS=1.835u
+ PD=0.865u
M$2776 3 637 711 3 sg13_lv_pmos L=0.13u W=0.42u AS=0.204p AD=0.0798p PS=1.835u
+ PD=0.8u
M$2777 3 733 711 3 sg13_lv_pmos L=0.13u W=0.42u AS=0.4659p AD=0.0798p PS=3.65u
+ PD=0.8u
M$2778 672 639 3 3 sg13_lv_pmos L=0.13u W=0.42u AS=0.147p AD=0.1563p PS=1.54u
+ PD=1.22u
M$2779 3 641 679 3 sg13_lv_pmos L=0.13u W=0.42u AS=0.1563p AD=0.063p PS=1.22u
+ PD=0.72u
M$2780 679 642 672 3 sg13_lv_pmos L=0.13u W=0.42u AS=0.063p AD=0.0798p PS=0.72u
+ PD=0.8u
M$2781 672 656 640 3 sg13_lv_pmos L=0.13u W=0.42u AS=0.0798p AD=0.1428p PS=0.8u
+ PD=1.52u
M$2782 712 733 3 3 sg13_lv_pmos L=0.13u W=1.12u AS=0.3864p AD=0.2128p PS=2.93u
+ PD=1.5u
M$2783 3 712 713 3 sg13_lv_pmos L=0.13u W=1.12u AS=0.2128p AD=0.3808p PS=1.5u
+ PD=2.92u
M$2784 3 104 686 3 sg13_lv_pmos L=0.13u W=1.12u AS=0.3808p AD=0.3808p PS=2.92u
+ PD=2.92u
M$2785 3 713 687 3 sg13_lv_pmos L=0.13u W=1.12u AS=0.3808p AD=0.3808p PS=2.92u
+ PD=2.92u
M$2790 717 718 3 3 sg13_lv_pmos L=0.13u W=1.12u AS=0.3808p AD=0.3808p PS=2.92u
+ PD=2.92u
M$2791 718 761 3 3 sg13_lv_pmos L=0.13u W=1.12u AS=0.42p AD=0.2114p PS=2.99u
+ PD=1.54u
M$2792 3 570 761 3 sg13_lv_pmos L=0.13u W=0.84u AS=0.2114p AD=0.2856p PS=1.54u
+ PD=2.36u
M$2793 816 755 3 3 sg13_lv_pmos L=0.13u W=1.12u AS=0.3864p AD=0.41165p PS=2.93u
+ PD=2.12u
M$2794 3 595 755 3 sg13_lv_pmos L=0.13u W=1.12u AS=0.41165p AD=0.4088p PS=2.12u
+ PD=2.97u
M$2795 765 816 823 3 sg13_lv_pmos L=0.13u W=0.42u AS=0.2048p AD=0.09345p
+ PS=1.63u PD=0.865u
M$2796 823 766 3 3 sg13_lv_pmos L=0.13u W=0.42u AS=0.09345p AD=0.204p PS=0.865u
+ PD=1.835u
M$2797 3 681 766 3 sg13_lv_pmos L=0.13u W=0.42u AS=0.204p AD=0.0798p PS=1.835u
+ PD=0.8u
M$2798 766 765 3 3 sg13_lv_pmos L=0.13u W=0.42u AS=0.0798p AD=0.4659p PS=0.8u
+ PD=3.65u
M$2799 754 755 765 3 sg13_lv_pmos L=0.13u W=1u AS=0.34p AD=0.2048p PS=2.68u
+ PD=1.63u
M$2800 767 765 3 3 sg13_lv_pmos L=0.13u W=1.12u AS=0.3864p AD=0.2128p PS=2.93u
+ PD=1.5u
M$2801 3 767 646 3 sg13_lv_pmos L=0.13u W=1.12u AS=0.2128p AD=0.3808p PS=1.5u
+ PD=2.92u
M$2802 820 694 3 3 sg13_lv_pmos L=0.13u W=1.12u AS=0.3808p AD=0.2128p PS=2.92u
+ PD=1.5u
M$2803 3 697 820 3 sg13_lv_pmos L=0.13u W=1.12u AS=0.2128p AD=0.2128p PS=1.5u
+ PD=1.5u
M$2804 820 768 769 3 sg13_lv_pmos L=0.13u W=1.12u AS=0.2128p AD=0.3808p PS=1.5u
+ PD=2.92u
M$2805 3 724 770 3 sg13_lv_pmos L=0.13u W=0.84u AS=0.4536p AD=0.1596p PS=2.76u
+ PD=1.22u
M$2806 3 725 770 3 sg13_lv_pmos L=0.13u W=0.84u AS=0.2891p AD=0.1596p PS=1.695u
+ PD=1.22u
M$2807 3 724 826 3 sg13_lv_pmos L=0.13u W=1.12u AS=0.2891p AD=0.1428p PS=1.695u
+ PD=1.375u
M$2808 826 725 671 3 sg13_lv_pmos L=0.13u W=1.12u AS=0.1428p AD=0.2408p
+ PS=1.375u PD=1.55u
M$2809 671 770 3 3 sg13_lv_pmos L=0.13u W=1.12u AS=0.2408p AD=0.3808p PS=1.55u
+ PD=2.92u
M$2810 3 650 772 3 sg13_lv_pmos L=0.13u W=0.84u AS=0.4536p AD=0.1596p PS=2.76u
+ PD=1.22u
M$2811 3 769 772 3 sg13_lv_pmos L=0.13u W=0.84u AS=0.2891p AD=0.1596p PS=1.695u
+ PD=1.22u
M$2812 3 650 827 3 sg13_lv_pmos L=0.13u W=1.12u AS=0.2891p AD=0.1428p PS=1.695u
+ PD=1.375u
M$2813 827 769 774 3 sg13_lv_pmos L=0.13u W=1.12u AS=0.1428p AD=0.2408p
+ PS=1.375u PD=1.55u
M$2814 774 772 3 3 sg13_lv_pmos L=0.13u W=1.12u AS=0.2408p AD=0.3808p PS=1.55u
+ PD=2.92u
M$2815 3 718 682 3 sg13_lv_pmos L=0.13u W=1.12u AS=0.3808p AD=0.3808p PS=2.92u
+ PD=2.92u
M$2816 3 718 775 3 sg13_lv_pmos L=0.13u W=1.12u AS=0.3808p AD=0.3808p PS=2.92u
+ PD=2.92u
M$2817 817 757 3 3 sg13_lv_pmos L=0.13u W=1.12u AS=0.3864p AD=0.41165p PS=2.93u
+ PD=2.12u
M$2818 3 247 757 3 sg13_lv_pmos L=0.13u W=1.12u AS=0.41165p AD=0.4088p PS=2.12u
+ PD=2.97u
M$2819 779 817 830 3 sg13_lv_pmos L=0.13u W=0.42u AS=0.2048p AD=0.09345p
+ PS=1.63u PD=0.865u
M$2820 830 780 3 3 sg13_lv_pmos L=0.13u W=0.42u AS=0.09345p AD=0.204p PS=0.865u
+ PD=1.835u
M$2821 3 775 780 3 sg13_lv_pmos L=0.13u W=0.42u AS=0.204p AD=0.0798p PS=1.835u
+ PD=0.8u
M$2822 780 779 3 3 sg13_lv_pmos L=0.13u W=0.42u AS=0.0798p AD=0.4659p PS=0.8u
+ PD=3.65u
M$2823 756 757 779 3 sg13_lv_pmos L=0.13u W=1u AS=0.34p AD=0.2048p PS=2.68u
+ PD=1.63u
M$2824 781 779 3 3 sg13_lv_pmos L=0.13u W=1.12u AS=0.3864p AD=0.2128p PS=2.93u
+ PD=1.5u
M$2825 3 781 723 3 sg13_lv_pmos L=0.13u W=1.12u AS=0.2128p AD=0.3808p PS=1.5u
+ PD=2.92u
M$2826 782 463 3 3 sg13_lv_pmos L=0.13u W=1.12u AS=0.3808p AD=0.3808p PS=2.92u
+ PD=2.92u
M$2827 818 759 3 3 sg13_lv_pmos L=0.13u W=1.12u AS=0.3864p AD=0.41165p PS=2.93u
+ PD=2.12u
M$2828 3 729 759 3 sg13_lv_pmos L=0.13u W=1.12u AS=0.41165p AD=0.4088p PS=2.12u
+ PD=2.97u
M$2829 786 818 829 3 sg13_lv_pmos L=0.13u W=0.42u AS=0.2048p AD=0.09345p
+ PS=1.63u PD=0.865u
M$2830 829 787 3 3 sg13_lv_pmos L=0.13u W=0.42u AS=0.09345p AD=0.204p PS=0.865u
+ PD=1.835u
M$2831 3 684 787 3 sg13_lv_pmos L=0.13u W=0.42u AS=0.204p AD=0.0798p PS=1.835u
+ PD=0.8u
M$2832 787 786 3 3 sg13_lv_pmos L=0.13u W=0.42u AS=0.0798p AD=0.4659p PS=0.8u
+ PD=3.65u
M$2833 758 759 786 3 sg13_lv_pmos L=0.13u W=1u AS=0.34p AD=0.2048p PS=2.68u
+ PD=1.63u
M$2834 788 786 3 3 sg13_lv_pmos L=0.13u W=1.12u AS=0.3864p AD=0.2128p PS=2.93u
+ PD=1.5u
M$2835 3 788 730 3 sg13_lv_pmos L=0.13u W=1.12u AS=0.2128p AD=0.3808p PS=1.5u
+ PD=2.92u
M$2836 638 789 3 3 sg13_lv_pmos L=0.13u W=1.12u AS=0.3808p AD=0.2128p PS=2.92u
+ PD=1.5u
M$2837 3 810 789 3 sg13_lv_pmos L=0.13u W=1.12u AS=0.2128p AD=0.3864p PS=1.5u
+ PD=2.93u
M$2838 3 810 790 3 sg13_lv_pmos L=0.13u W=0.42u AS=0.4659p AD=0.0798p PS=3.65u
+ PD=0.8u
M$2839 790 686 3 3 sg13_lv_pmos L=0.13u W=0.42u AS=0.0798p AD=0.204p PS=0.8u
+ PD=1.835u
M$2840 3 790 824 3 sg13_lv_pmos L=0.13u W=0.42u AS=0.204p AD=0.09345p PS=1.835u
+ PD=0.865u
M$2841 824 793 810 3 sg13_lv_pmos L=0.13u W=0.42u AS=0.09345p AD=0.2048p
+ PS=0.865u PD=1.63u
M$2842 810 792 760 3 sg13_lv_pmos L=0.13u W=1u AS=0.2048p AD=0.34p PS=1.63u
+ PD=2.68u
M$2843 792 730 3 3 sg13_lv_pmos L=0.13u W=1.12u AS=0.4088p AD=0.41165p PS=2.97u
+ PD=2.12u
M$2844 3 792 793 3 sg13_lv_pmos L=0.13u W=1.12u AS=0.41165p AD=0.3864p PS=2.12u
+ PD=2.93u
M$2845 3 632 762 3 sg13_lv_pmos L=0.13u W=0.42u AS=0.1428p AD=0.0798p PS=1.52u
+ PD=0.8u
M$2846 3 681 762 3 sg13_lv_pmos L=0.13u W=0.42u AS=0.3623875p AD=0.0798p
+ PS=2.605u PD=0.8u
M$2847 3 807 754 3 sg13_lv_pmos L=0.13u W=1u AS=0.3623875p AD=0.34p PS=2.605u
+ PD=2.68u
M$2848 807 681 3 3 sg13_lv_pmos L=0.13u W=0.42u AS=0.147p AD=0.1563p PS=1.54u
+ PD=1.22u
M$2849 3 754 821 3 sg13_lv_pmos L=0.13u W=0.42u AS=0.1563p AD=0.063p PS=1.22u
+ PD=0.72u
M$2850 821 755 807 3 sg13_lv_pmos L=0.13u W=0.42u AS=0.063p AD=0.0798p PS=0.72u
+ PD=0.8u
M$2851 807 816 762 3 sg13_lv_pmos L=0.13u W=0.42u AS=0.0798p AD=0.1428p PS=0.8u
+ PD=1.52u
M$2856 3 694 825 3 sg13_lv_pmos L=0.13u W=1u AS=0.36p AD=0.1225p PS=2.72u
+ PD=1.245u
M$2857 825 697 768 3 sg13_lv_pmos L=0.13u W=1u AS=0.1225p AD=0.34p PS=1.245u
+ PD=2.68u
M$2869 3 774 776 3 sg13_lv_pmos L=0.13u W=0.42u AS=0.1428p AD=0.0798p PS=1.52u
+ PD=0.8u
M$2870 3 775 776 3 sg13_lv_pmos L=0.13u W=0.42u AS=0.3623875p AD=0.0798p
+ PS=2.605u PD=0.8u
M$2871 3 808 756 3 sg13_lv_pmos L=0.13u W=1u AS=0.3623875p AD=0.34p PS=2.605u
+ PD=2.68u
M$2872 808 775 3 3 sg13_lv_pmos L=0.13u W=0.42u AS=0.147p AD=0.1563p PS=1.54u
+ PD=1.22u
M$2873 3 756 828 3 sg13_lv_pmos L=0.13u W=0.42u AS=0.1563p AD=0.063p PS=1.22u
+ PD=0.72u
M$2874 828 757 808 3 sg13_lv_pmos L=0.13u W=0.42u AS=0.063p AD=0.0798p PS=0.72u
+ PD=0.8u
M$2875 808 817 776 3 sg13_lv_pmos L=0.13u W=0.42u AS=0.0798p AD=0.1428p PS=0.8u
+ PD=1.52u
M$2878 3 685 783 3 sg13_lv_pmos L=0.13u W=0.42u AS=0.1428p AD=0.0798p PS=1.52u
+ PD=0.8u
M$2879 3 684 783 3 sg13_lv_pmos L=0.13u W=0.42u AS=0.3623875p AD=0.0798p
+ PS=2.605u PD=0.8u
M$2880 3 809 758 3 sg13_lv_pmos L=0.13u W=1u AS=0.3623875p AD=0.34p PS=2.605u
+ PD=2.68u
M$2881 809 684 3 3 sg13_lv_pmos L=0.13u W=0.42u AS=0.147p AD=0.1563p PS=1.54u
+ PD=1.22u
M$2882 3 758 831 3 sg13_lv_pmos L=0.13u W=0.42u AS=0.1563p AD=0.063p PS=1.22u
+ PD=0.72u
M$2883 831 759 809 3 sg13_lv_pmos L=0.13u W=0.42u AS=0.063p AD=0.0798p PS=0.72u
+ PD=0.8u
M$2884 809 818 783 3 sg13_lv_pmos L=0.13u W=0.42u AS=0.0798p AD=0.1428p PS=0.8u
+ PD=1.52u
M$2898 811 793 812 3 sg13_lv_pmos L=0.13u W=0.42u AS=0.1428p AD=0.0798p
+ PS=1.52u PD=0.8u
M$2899 812 792 822 3 sg13_lv_pmos L=0.13u W=0.42u AS=0.0798p AD=0.063p PS=0.8u
+ PD=0.72u
M$2900 822 760 3 3 sg13_lv_pmos L=0.13u W=0.42u AS=0.063p AD=0.1563p PS=0.72u
+ PD=1.22u
M$2901 3 686 812 3 sg13_lv_pmos L=0.13u W=0.42u AS=0.1563p AD=0.147p PS=1.22u
+ PD=1.54u
M$2902 3 686 811 3 sg13_lv_pmos L=0.13u W=0.42u AS=0.3623875p AD=0.0798p
+ PS=2.605u PD=0.8u
M$2903 811 687 3 3 sg13_lv_pmos L=0.13u W=0.42u AS=0.0798p AD=0.1428p PS=0.8u
+ PD=1.52u
M$2904 760 812 3 3 sg13_lv_pmos L=0.13u W=1u AS=0.34p AD=0.3623875p PS=2.68u
+ PD=2.605u
M$2910 833 819 3 3 sg13_lv_pmos L=0.13u W=0.84u AS=0.2856p AD=0.2114p PS=2.36u
+ PD=1.54u
M$2911 3 833 570 3 sg13_lv_pmos L=0.13u W=1.12u AS=0.2114p AD=0.42p PS=1.54u
+ PD=2.99u
M$2915 719 849 3 3 sg13_lv_pmos L=0.13u W=1.12u AS=0.6048p AD=0.2198p PS=3.32u
+ PD=1.52u
M$2916 3 832 844 3 sg13_lv_pmos L=0.13u W=1u AS=0.2198p AD=0.2975p PS=1.52u
+ PD=1.595u
M$2917 844 646 849 3 sg13_lv_pmos L=0.13u W=1u AS=0.2975p AD=0.2225p PS=1.595u
+ PD=1.445u
M$2918 849 694 845 3 sg13_lv_pmos L=0.13u W=1u AS=0.2225p AD=0.3325p PS=1.445u
+ PD=1.665u
M$2919 845 97 3 3 sg13_lv_pmos L=0.13u W=1u AS=0.3325p AD=0.253p PS=1.665u
+ PD=1.53u
M$2920 3 97 832 3 sg13_lv_pmos L=0.13u W=0.84u AS=0.253p AD=0.2856p PS=1.53u
+ PD=2.36u
M$2927 3 646 834 3 sg13_lv_pmos L=0.13u W=0.84u AS=0.4536p AD=0.1596p PS=2.76u
+ PD=1.22u
M$2928 3 723 834 3 sg13_lv_pmos L=0.13u W=0.84u AS=0.2891p AD=0.1596p PS=1.695u
+ PD=1.22u
M$2929 3 646 846 3 sg13_lv_pmos L=0.13u W=1.12u AS=0.2891p AD=0.1428p PS=1.695u
+ PD=1.375u
M$2930 846 723 725 3 sg13_lv_pmos L=0.13u W=1.12u AS=0.1428p AD=0.2408p
+ PS=1.375u PD=1.55u
M$2931 725 834 3 3 sg13_lv_pmos L=0.13u W=1.12u AS=0.2408p AD=0.3808p PS=1.55u
+ PD=2.92u
M$2948 835 570 3 3 sg13_lv_pmos L=0.13u W=0.84u AS=0.2856p AD=0.2114p PS=2.36u
+ PD=1.54u
M$2949 3 835 104 3 sg13_lv_pmos L=0.13u W=1.12u AS=0.2114p AD=0.42p PS=1.54u
+ PD=2.99u
M$2950 3 683 836 3 sg13_lv_pmos L=0.13u W=0.42u AS=0.1428p AD=0.0798p PS=1.52u
+ PD=0.8u
M$2951 3 782 836 3 sg13_lv_pmos L=0.13u W=0.42u AS=0.3623875p AD=0.0798p
+ PS=2.605u PD=0.8u
M$2952 3 837 838 3 sg13_lv_pmos L=0.13u W=1u AS=0.3623875p AD=0.34p PS=2.605u
+ PD=2.68u
M$2953 3 782 837 3 sg13_lv_pmos L=0.13u W=0.42u AS=0.1563p AD=0.147p PS=1.22u
+ PD=1.54u
M$2954 3 838 847 3 sg13_lv_pmos L=0.13u W=0.42u AS=0.1563p AD=0.063p PS=1.22u
+ PD=0.72u
M$2955 847 840 837 3 sg13_lv_pmos L=0.13u W=0.42u AS=0.063p AD=0.0798p PS=0.72u
+ PD=0.8u
M$2956 837 839 836 3 sg13_lv_pmos L=0.13u W=0.42u AS=0.0798p AD=0.1428p PS=0.8u
+ PD=1.52u
M$2957 463 859 3 3 sg13_lv_pmos L=0.13u W=1.12u AS=0.42p AD=0.2114p PS=2.99u
+ PD=1.54u
M$2958 3 104 859 3 sg13_lv_pmos L=0.13u W=0.84u AS=0.2114p AD=0.2856p PS=1.54u
+ PD=2.36u
M$2961 3 840 839 3 sg13_lv_pmos L=0.13u W=1.12u AS=0.41165p AD=0.3864p PS=2.12u
+ PD=2.93u
M$2962 3 1 840 3 sg13_lv_pmos L=0.13u W=1.12u AS=0.41165p AD=0.4088p PS=2.12u
+ PD=2.97u
M$2965 838 840 841 3 sg13_lv_pmos L=0.13u W=1u AS=0.34p AD=0.2048p PS=2.68u
+ PD=1.63u
M$2966 841 839 848 3 sg13_lv_pmos L=0.13u W=0.42u AS=0.2048p AD=0.09345p
+ PS=1.63u PD=0.865u
M$2967 3 842 848 3 sg13_lv_pmos L=0.13u W=0.42u AS=0.204p AD=0.09345p PS=1.835u
+ PD=0.865u
M$2968 3 782 842 3 sg13_lv_pmos L=0.13u W=0.42u AS=0.204p AD=0.0798p PS=1.835u
+ PD=0.8u
M$2969 3 841 842 3 sg13_lv_pmos L=0.13u W=0.42u AS=0.4659p AD=0.0798p PS=3.65u
+ PD=0.8u
M$2972 843 841 3 3 sg13_lv_pmos L=0.13u W=1.12u AS=0.3864p AD=0.2128p PS=2.93u
+ PD=1.5u
M$2973 3 843 729 3 sg13_lv_pmos L=0.13u W=1.12u AS=0.2128p AD=0.3808p PS=1.5u
+ PD=2.92u
M$2988 863 912 863 3 sg13_lv_pmos L=4u W=88u AS=17.92p AD=17.92p PS=104.96u
+ PD=104.96u
M$2999 860 912 860 3 sg13_lv_pmos L=4u W=88u AS=17.92p AD=17.92p PS=104.96u
+ PD=104.96u
M$3021 3 860 863 3 sg13_lv_pmos L=0.5u W=110.5u AS=22.27p AD=22.27p PS=124.24u
+ PD=124.24u
M$3034 860 863 3 3 sg13_lv_pmos L=0.5u W=110.5u AS=22.27p AD=22.27p PS=124.24u
+ PD=124.24u
M$3047 3 1 860 3 sg13_lv_pmos L=0.13u W=2.24u AS=0.5936p AD=0.5992p PS=4.42u
+ PD=4.43u
M$3060 881 865 877 877 sg13_lv_pmos L=0.13u W=1.12u AS=0.3864p AD=0.431025p
+ PS=2.93u PD=2.145u
M$3061 877 60 865 877 sg13_lv_pmos L=0.13u W=1.12u AS=0.431025p AD=0.3808p
+ PS=2.145u PD=2.92u
M$3062 877 871 872 877 sg13_lv_pmos L=0.13u W=2.24u AS=0.5964p AD=0.5964p
+ PS=4.425u PD=4.425u
M$3064 877 872 879 877 sg13_lv_pmos L=0.13u W=2.24u AS=0.616p AD=0.4312p
+ PS=4.46u PD=3.01u
M$3066 877 890 879 877 sg13_lv_pmos L=0.13u W=2.24u AS=0.4312p AD=0.6048p
+ PS=3.01u PD=4.44u
M$3068 877 877 866 877 sg13_lv_pmos L=0.13u W=0.42u AS=0.1428p AD=0.0798p
+ PS=1.52u PD=0.8u
M$3069 877 879 866 877 sg13_lv_pmos L=0.13u W=0.42u AS=0.3623875p AD=0.0798p
+ PS=2.605u PD=0.8u
M$3070 877 878 864 877 sg13_lv_pmos L=0.13u W=1u AS=0.3623875p AD=0.34p
+ PS=2.605u PD=2.68u
M$3071 878 879 877 877 sg13_lv_pmos L=0.13u W=0.42u AS=0.147p AD=0.1563p
+ PS=1.54u PD=1.22u
M$3072 877 864 882 877 sg13_lv_pmos L=0.13u W=0.42u AS=0.1563p AD=0.0546p
+ PS=1.22u PD=0.68u
M$3073 882 865 878 877 sg13_lv_pmos L=0.13u W=0.42u AS=0.0546p AD=0.0798p
+ PS=0.68u PD=0.8u
M$3074 878 881 866 877 sg13_lv_pmos L=0.13u W=0.42u AS=0.0798p AD=0.1428p
+ PS=0.8u PD=1.52u
M$3075 869 881 883 877 sg13_lv_pmos L=0.13u W=0.42u AS=0.19115p AD=0.0525p
+ PS=1.565u PD=0.67u
M$3076 883 880 877 877 sg13_lv_pmos L=0.13u W=0.42u AS=0.0525p AD=0.25605p
+ PS=0.67u PD=1.935u
M$3077 877 879 880 877 sg13_lv_pmos L=0.13u W=0.42u AS=0.25605p AD=0.0798p
+ PS=1.935u PD=0.8u
M$3078 877 869 880 877 sg13_lv_pmos L=0.13u W=0.42u AS=0.2014p AD=0.0798p
+ PS=1.53u PD=0.8u
M$3079 877 869 871 877 sg13_lv_pmos L=0.13u W=1u AS=0.2083p AD=0.34p PS=1.5u
+ PD=2.68u
M$3080 877 869 870 877 sg13_lv_pmos L=0.13u W=2.24u AS=0.4142p AD=0.4211p
+ PS=3.03u PD=3u
M$3082 864 865 869 877 sg13_lv_pmos L=0.13u W=1u AS=0.34p AD=0.19115p PS=2.68u
+ PD=1.565u
M$3083 877 877 884 877 sg13_lv_pmos L=0.13u W=0.42u AS=0.1428p AD=0.0798p
+ PS=1.52u PD=0.8u
M$3084 877 879 884 877 sg13_lv_pmos L=0.13u W=0.42u AS=0.3623875p AD=0.0798p
+ PS=2.605u PD=0.8u
M$3085 877 892 885 877 sg13_lv_pmos L=0.13u W=1u AS=0.3623875p AD=0.34p
+ PS=2.605u PD=2.68u
M$3086 892 879 877 877 sg13_lv_pmos L=0.13u W=0.42u AS=0.147p AD=0.1563p
+ PS=1.54u PD=1.22u
M$3087 877 885 901 877 sg13_lv_pmos L=0.13u W=0.42u AS=0.1563p AD=0.0546p
+ PS=1.22u PD=0.68u
M$3088 901 886 892 877 sg13_lv_pmos L=0.13u W=0.42u AS=0.0546p AD=0.0798p
+ PS=0.68u PD=0.8u
M$3089 892 900 884 877 sg13_lv_pmos L=0.13u W=0.42u AS=0.0798p AD=0.1428p
+ PS=0.8u PD=1.52u
M$3090 900 886 877 877 sg13_lv_pmos L=0.13u W=1.12u AS=0.3864p AD=0.431025p
+ PS=2.93u PD=2.145u
M$3091 877 894 886 877 sg13_lv_pmos L=0.13u W=1.12u AS=0.431025p AD=0.3808p
+ PS=2.145u PD=2.92u
M$3092 895 900 902 877 sg13_lv_pmos L=0.13u W=0.42u AS=0.19115p AD=0.0525p
+ PS=1.565u PD=0.67u
M$3093 902 896 877 877 sg13_lv_pmos L=0.13u W=0.42u AS=0.0525p AD=0.25605p
+ PS=0.67u PD=1.935u
M$3094 877 879 896 877 sg13_lv_pmos L=0.13u W=0.42u AS=0.25605p AD=0.0798p
+ PS=1.935u PD=0.8u
M$3095 877 895 896 877 sg13_lv_pmos L=0.13u W=0.42u AS=0.2014p AD=0.0798p
+ PS=1.53u PD=0.8u
M$3096 877 895 889 877 sg13_lv_pmos L=0.13u W=1u AS=0.2083p AD=0.34p PS=1.5u
+ PD=2.68u
M$3097 877 895 888 877 sg13_lv_pmos L=0.13u W=2.24u AS=0.4142p AD=0.4211p
+ PS=3.03u PD=3u
M$3099 885 886 895 877 sg13_lv_pmos L=0.13u W=1u AS=0.34p AD=0.19115p PS=2.68u
+ PD=1.565u
M$3100 877 889 890 877 sg13_lv_pmos L=0.13u W=2.24u AS=0.5964p AD=0.5964p
+ PS=4.425u PD=4.425u
M$3102 877 890 891 877 sg13_lv_pmos L=0.13u W=2.24u AS=0.5936p AD=0.5992p
+ PS=4.42u PD=4.43u
M$3104 3 1 905 3 sg13_lv_pmos L=2u W=10u AS=3.4p AD=3.4p PS=20.68u PD=20.68u
M$3105 905 906 906 3 sg13_lv_pmos L=2u W=10u AS=3.4p AD=3.4p PS=20.68u PD=20.68u
M$3106 3 1 907 3 sg13_lv_pmos L=2u W=10u AS=3.4p AD=3.4p PS=20.68u PD=20.68u
M$3107 907 906 909 3 sg13_lv_pmos L=2u W=10u AS=3.4p AD=3.4p PS=20.68u PD=20.68u
M$3108 3 891 910 3 sg13_lv_pmos L=2u W=10u AS=3.4p AD=3.4p PS=20.68u PD=20.68u
M$3109 910 906 904 3 sg13_lv_pmos L=2u W=10u AS=3.4p AD=3.4p PS=20.68u PD=20.68u
R$3131 904 903 rsil w=0.5u l=2500u ps=0 b=0 m=1
R$3144 904 912 rsil w=0.5u l=1000u ps=0 b=0 m=1
R$3145 860 863 rhigh w=1u l=0.79u ps=0 b=0 m=1
C$3146 904 1 cap_cmim w=15u l=20u A=300p P=70u m=4
C$3147 863 860 cap_cmim w=4.26u l=4.26u A=18.1476p P=17.04u m=12
C$3149 912 1 cap_cmim w=60u l=60u A=3600p P=240u m=1
C$3150 903 1 cap_cmim w=40u l=40u A=1600p P=160u m=4
.ENDS LC_VCO_PLL
