* Extracted by KLayout with SG13G2 LVS runset on : 22/03/2026 17:22

.SUBCKT LC_VCO 1 2 3 4 6 7
M$1 4 6 5 4 sg13_lv_nmos L=0.15u W=60u AS=11.55p AD=11.55p PS=84.1u PD=84.1u
M$61 5 7 3 4 sg13_lv_nmos L=0.5u W=24u AS=4.86p AD=4.86p PS=30.86u PD=30.86u
M$73 5 3 7 4 sg13_lv_nmos L=0.5u W=24u AS=4.86p AD=4.86p PS=30.86u PD=30.86u
M$85 6 6 4 4 sg13_lv_nmos L=0.15u W=1u AS=0.34p AD=0.34p PS=2.68u PD=2.68u
M$86 3 2 3 1 sg13_lv_pmos L=4u W=88u AS=17.92p AD=17.92p PS=104.96u PD=104.96u
M$108 1 3 7 1 sg13_lv_pmos L=0.5u W=110.5u AS=22.27p AD=22.27p PS=124.24u
+ PD=124.24u
M$121 3 7 1 1 sg13_lv_pmos L=0.5u W=110.5u AS=22.27p AD=22.27p PS=124.24u
+ PD=124.24u
M$134 7 2 7 1 sg13_lv_pmos L=4u W=88u AS=17.92p AD=17.92p PS=104.96u PD=104.96u
R$156 3 7 rhigh w=1u l=0.79u ps=0 b=0 m=1
C$157 7 3 cap_cmim w=4.26u l=4.26u A=18.1476p P=17.04u m=12
.ENDS LC_VCO
