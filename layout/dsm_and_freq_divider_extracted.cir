* Extracted by KLayout with SG13G2 LVS runset on : 01/04/2026 19:07

.SUBCKT dsm_and_freq_divider 1 2 3 4 8 9 11 14 17 20 22 23 29 30 31 32 33 41 59
+ 65 74 78 81 86 87 89 90 106 107 108 111 112 114 115 132 148 151 162 165 166
+ 167 168 202 203 210 212 213 215 217 218 220 222 223 227 229 232 246 247 257
+ 258 260 265 267 268 270 272 274 275 277 286 287 288 289 320 327 328 335 345
+ 346 347 348 349 354 394 395 396 397 399 400 414 415 416 417 418 419 422 423
+ 424 431 434 436 437 439 443 444 445 446 460 461 462 463 483 490 492 493 500
+ 530 531 550 551 560 563 565 566 570 571 574 575 596 597 599 601 603 604 629
+ 632 634 635 636 637 638 639 646 648 649 651 669 670 683 685 690 692 693 696
+ 701 702 703 708 709 710 714 715 719 720 721 725 726 735 769 774 781 808 819
+ 850
M$1 1 4 2 1 sg13_lv_nmos L=0.13u W=0.74u AS=0.2516p AD=0.2516p PS=2.16u PD=2.16u
M$2 1 3 1 1 sg13_lv_nmos L=1u W=217.14u AS=58.8966p AD=58.8966p PS=615.2u
+ PD=615.2u
M$50 5 26 6 1 sg13_lv_nmos L=0.13u W=0.42u AS=0.1296p AD=0.0798p PS=1.52u
+ PD=0.8u
M$51 6 25 42 1 sg13_lv_nmos L=0.13u W=0.42u AS=0.0798p AD=0.2373p PS=0.8u
+ PD=1.97u
M$52 25 26 1 1 sg13_lv_nmos L=0.13u W=0.74u AS=0.2516p AD=0.317325p PS=2.16u
+ PD=1.805u
M$53 1 210 26 1 sg13_lv_nmos L=0.13u W=0.74u AS=0.317325p AD=0.2516p PS=1.805u
+ PD=2.16u
M$54 43 26 27 1 sg13_lv_nmos L=0.13u W=0.42u AS=0.1428p AD=0.12665p PS=1.52u
+ PD=1.145u
M$55 27 25 24 1 sg13_lv_nmos L=0.13u W=0.74u AS=0.12665p AD=0.3473p PS=1.145u
+ PD=2.71u
M$56 7 27 1 1 sg13_lv_nmos L=0.13u W=0.74u AS=0.2516p AD=0.1406p PS=2.16u
+ PD=1.12u
M$57 1 7 8 1 sg13_lv_nmos L=0.13u W=0.74u AS=0.1406p AD=0.2516p PS=1.12u
+ PD=2.16u
M$60 9 10 44 1 sg13_lv_nmos L=0.13u W=0.74u AS=0.2516p AD=0.1406p PS=2.16u
+ PD=1.12u
M$61 44 11 1 1 sg13_lv_nmos L=0.13u W=0.74u AS=0.1406p AD=0.1898p PS=1.12u
+ PD=1.36u
M$62 1 65 44 1 sg13_lv_nmos L=0.13u W=0.74u AS=0.1898p AD=0.2516p PS=1.36u
+ PD=2.16u
M$63 10 11 48 1 sg13_lv_nmos L=0.13u W=0.64u AS=0.2176p AD=0.0784p PS=1.96u
+ PD=0.885u
M$64 48 65 1 1 sg13_lv_nmos L=0.13u W=0.64u AS=0.0784p AD=0.2272p PS=0.885u
+ PD=1.99u
M$65 1 29 13 1 sg13_lv_nmos L=0.13u W=0.55u AS=0.15245p AD=0.174625p PS=1.17u
+ PD=1.185u
M$66 13 30 1 1 sg13_lv_nmos L=0.13u W=0.55u AS=0.174625p AD=0.374p PS=1.185u
+ PD=2.46u
M$67 1 13 11 1 sg13_lv_nmos L=0.13u W=0.74u AS=0.3108p AD=0.1628p PS=2.32u
+ PD=1.18u
M$68 11 29 49 1 sg13_lv_nmos L=0.13u W=0.74u AS=0.1628p AD=0.0888p PS=1.18u
+ PD=0.98u
M$69 49 30 1 1 sg13_lv_nmos L=0.13u W=0.74u AS=0.0888p AD=0.15245p PS=0.98u
+ PD=1.17u
M$70 1 30 14 1 sg13_lv_nmos L=0.13u W=0.74u AS=0.2516p AD=0.1406p PS=2.16u
+ PD=1.12u
M$71 14 29 1 1 sg13_lv_nmos L=0.13u W=0.74u AS=0.1406p AD=0.2516p PS=1.12u
+ PD=2.16u
M$72 1 165 50 1 sg13_lv_nmos L=0.13u W=0.74u AS=0.2516p AD=0.09435p PS=2.16u
+ PD=0.995u
M$73 50 2 16 1 sg13_lv_nmos L=0.13u W=0.74u AS=0.09435p AD=0.1406p PS=0.995u
+ PD=1.12u
M$74 16 31 1 1 sg13_lv_nmos L=0.13u W=0.74u AS=0.1406p AD=0.3811p PS=1.12u
+ PD=2.51u
M$75 1 16 17 1 sg13_lv_nmos L=0.13u W=1.48u AS=0.3922p AD=0.3922p PS=3.28u
+ PD=3.28u
M$77 1 14 31 1 sg13_lv_nmos L=0.13u W=0.74u AS=0.2516p AD=0.1406p PS=2.16u
+ PD=1.12u
M$78 31 166 1 1 sg13_lv_nmos L=0.13u W=0.74u AS=0.1406p AD=0.2516p PS=1.12u
+ PD=2.16u
M$81 1 8 18 1 sg13_lv_nmos L=0.13u W=0.55u AS=0.374p AD=0.174625p PS=2.46u
+ PD=1.185u
M$82 18 30 1 1 sg13_lv_nmos L=0.13u W=0.55u AS=0.174625p AD=0.15245p PS=1.185u
+ PD=1.17u
M$83 1 8 51 1 sg13_lv_nmos L=0.13u W=0.74u AS=0.15245p AD=0.0888p PS=1.17u
+ PD=0.98u
M$84 51 30 20 1 sg13_lv_nmos L=0.13u W=0.74u AS=0.0888p AD=0.1628p PS=0.98u
+ PD=1.18u
M$85 20 18 1 1 sg13_lv_nmos L=0.13u W=0.74u AS=0.1628p AD=0.3108p PS=1.18u
+ PD=2.32u
M$86 1 20 52 1 sg13_lv_nmos L=0.13u W=0.74u AS=0.2516p AD=0.1406p PS=2.16u
+ PD=1.12u
M$87 52 32 22 1 sg13_lv_nmos L=0.13u W=0.74u AS=0.1406p AD=0.1406p PS=1.12u
+ PD=1.12u
M$88 22 33 1 1 sg13_lv_nmos L=0.13u W=0.74u AS=0.1406p AD=0.2516p PS=1.12u
+ PD=2.16u
M$105 1 74 23 1 sg13_lv_nmos L=0.13u W=0.74u AS=0.2516p AD=0.2516p PS=2.16u
+ PD=2.16u
M$106 1 74 106 1 sg13_lv_nmos L=0.13u W=0.74u AS=0.2516p AD=0.2516p PS=2.16u
+ PD=2.16u
M$108 1 107 75 1 sg13_lv_nmos L=0.13u W=0.55u AS=0.18945p AD=0.187p PS=1.27u
+ PD=1.78u
M$109 1 107 92 1 sg13_lv_nmos L=0.13u W=0.74u AS=0.18945p AD=0.13135p PS=1.27u
+ PD=1.095u
M$110 92 65 60 1 sg13_lv_nmos L=0.13u W=0.74u AS=0.13135p AD=0.1628p PS=1.095u
+ PD=1.18u
M$111 60 8 93 1 sg13_lv_nmos L=0.13u W=0.74u AS=0.1628p AD=0.3367p PS=1.18u
+ PD=1.65u
M$112 93 75 1 1 sg13_lv_nmos L=0.13u W=0.74u AS=0.3367p AD=0.148p PS=1.65u
+ PD=1.14u
M$113 1 60 41 1 sg13_lv_nmos L=0.13u W=0.74u AS=0.148p AD=0.4033p PS=1.14u
+ PD=2.57u
M$114 1 6 24 1 sg13_lv_nmos L=0.13u W=0.74u AS=0.1626p AD=0.2516p PS=1.415u
+ PD=2.16u
M$115 5 41 45 1 sg13_lv_nmos L=0.13u W=0.42u AS=0.1428p AD=0.0609p PS=1.52u
+ PD=0.71u
M$116 1 23 45 1 sg13_lv_nmos L=0.13u W=0.42u AS=0.1626p AD=0.0609p PS=1.415u
+ PD=0.71u
M$117 1 23 46 1 sg13_lv_nmos L=0.13u W=0.42u AS=0.1701p AD=0.0378p PS=1.65u
+ PD=0.6u
M$118 46 24 42 1 sg13_lv_nmos L=0.13u W=0.42u AS=0.0378p AD=0.1428p PS=0.6u
+ PD=1.52u
M$119 61 108 94 1 sg13_lv_nmos L=0.13u W=0.42u AS=0.1428p AD=0.0609p PS=1.52u
+ PD=0.71u
M$120 94 106 1 1 sg13_lv_nmos L=0.13u W=0.42u AS=0.0609p AD=0.1626p PS=0.71u
+ PD=1.415u
M$121 1 109 53 1 sg13_lv_nmos L=0.13u W=0.74u AS=0.1626p AD=0.2516p PS=1.415u
+ PD=2.16u
M$122 1 106 95 1 sg13_lv_nmos L=0.13u W=0.42u AS=0.1701p AD=0.0378p PS=1.65u
+ PD=0.6u
M$123 95 53 76 1 sg13_lv_nmos L=0.13u W=0.42u AS=0.0378p AD=0.1428p PS=0.6u
+ PD=1.52u
M$124 43 28 1 1 sg13_lv_nmos L=0.13u W=0.42u AS=0.1428p AD=0.0798p PS=1.52u
+ PD=0.8u
M$125 1 23 47 1 sg13_lv_nmos L=0.13u W=0.42u AS=0.0798p AD=0.0378p PS=0.8u
+ PD=0.6u
M$126 47 27 28 1 sg13_lv_nmos L=0.13u W=0.42u AS=0.0378p AD=0.1428p PS=0.6u
+ PD=1.52u
M$127 77 54 62 1 sg13_lv_nmos L=0.13u W=0.42u AS=0.12665p AD=0.1428p PS=1.145u
+ PD=1.52u
M$128 53 116 77 1 sg13_lv_nmos L=0.13u W=0.74u AS=0.3473p AD=0.12665p PS=2.71u
+ PD=1.145u
M$129 62 63 1 1 sg13_lv_nmos L=0.13u W=0.42u AS=0.1428p AD=0.0798p PS=1.52u
+ PD=0.8u
M$130 1 106 97 1 sg13_lv_nmos L=0.13u W=0.42u AS=0.0798p AD=0.0378p PS=0.8u
+ PD=0.6u
M$131 97 77 63 1 sg13_lv_nmos L=0.13u W=0.42u AS=0.0378p AD=0.1428p PS=0.6u
+ PD=1.52u
M$132 64 77 1 1 sg13_lv_nmos L=0.13u W=0.74u AS=0.2516p AD=0.1406p PS=2.16u
+ PD=1.12u
M$133 1 64 65 1 sg13_lv_nmos L=0.13u W=0.74u AS=0.1406p AD=0.2516p PS=1.12u
+ PD=2.16u
M$135 1 74 78 1 sg13_lv_nmos L=0.13u W=0.74u AS=0.2516p AD=0.2516p PS=2.16u
+ PD=2.16u
M$136 66 9 99 1 sg13_lv_nmos L=0.13u W=0.42u AS=0.1428p AD=0.0609p PS=1.52u
+ PD=0.71u
M$137 99 78 1 1 sg13_lv_nmos L=0.13u W=0.42u AS=0.0609p AD=0.1626p PS=0.71u
+ PD=1.415u
M$138 1 110 55 1 sg13_lv_nmos L=0.13u W=0.74u AS=0.1626p AD=0.2516p PS=1.415u
+ PD=2.16u
M$139 1 78 100 1 sg13_lv_nmos L=0.13u W=0.42u AS=0.1701p AD=0.0378p PS=1.65u
+ PD=0.6u
M$140 100 55 79 1 sg13_lv_nmos L=0.13u W=0.42u AS=0.0378p AD=0.1428p PS=0.6u
+ PD=1.52u
M$142 80 56 67 1 sg13_lv_nmos L=0.13u W=0.42u AS=0.12665p AD=0.1428p PS=1.145u
+ PD=1.52u
M$143 55 117 80 1 sg13_lv_nmos L=0.13u W=0.74u AS=0.3473p AD=0.12665p PS=2.71u
+ PD=1.145u
M$144 67 68 1 1 sg13_lv_nmos L=0.13u W=0.42u AS=0.1428p AD=0.0798p PS=1.52u
+ PD=0.8u
M$145 1 78 102 1 sg13_lv_nmos L=0.13u W=0.42u AS=0.0798p AD=0.0378p PS=0.8u
+ PD=0.6u
M$146 102 80 68 1 sg13_lv_nmos L=0.13u W=0.42u AS=0.0378p AD=0.1428p PS=0.6u
+ PD=1.52u
M$147 69 80 1 1 sg13_lv_nmos L=0.13u W=0.74u AS=0.2516p AD=0.1406p PS=2.16u
+ PD=1.12u
M$148 1 69 29 1 sg13_lv_nmos L=0.13u W=0.74u AS=0.1406p AD=0.2516p PS=1.12u
+ PD=2.16u
M$149 81 111 1 1 sg13_lv_nmos L=0.13u W=0.74u AS=0.2516p AD=0.2516p PS=2.16u
+ PD=2.16u
M$150 70 112 104 1 sg13_lv_nmos L=0.13u W=0.42u AS=0.1428p AD=0.0609p PS=1.52u
+ PD=0.71u
M$151 104 81 1 1 sg13_lv_nmos L=0.13u W=0.42u AS=0.0609p AD=0.1626p PS=0.71u
+ PD=1.415u
M$152 1 113 57 1 sg13_lv_nmos L=0.13u W=0.74u AS=0.1626p AD=0.2516p PS=1.415u
+ PD=2.16u
M$153 1 81 105 1 sg13_lv_nmos L=0.13u W=0.42u AS=0.1701p AD=0.0378p PS=1.65u
+ PD=0.6u
M$154 105 57 82 1 sg13_lv_nmos L=0.13u W=0.42u AS=0.0378p AD=0.1428p PS=0.6u
+ PD=1.52u
M$156 83 58 71 1 sg13_lv_nmos L=0.13u W=0.42u AS=0.12665p AD=0.1428p PS=1.145u
+ PD=1.52u
M$157 57 118 83 1 sg13_lv_nmos L=0.13u W=0.74u AS=0.3473p AD=0.12665p PS=2.71u
+ PD=1.145u
M$158 71 72 1 1 sg13_lv_nmos L=0.13u W=0.42u AS=0.1428p AD=0.0798p PS=1.52u
+ PD=0.8u
M$159 1 81 103 1 sg13_lv_nmos L=0.13u W=0.42u AS=0.0798p AD=0.0378p PS=0.8u
+ PD=0.6u
M$160 103 83 72 1 sg13_lv_nmos L=0.13u W=0.42u AS=0.0378p AD=0.1428p PS=0.6u
+ PD=1.52u
M$161 73 83 1 1 sg13_lv_nmos L=0.13u W=0.74u AS=0.2516p AD=0.1406p PS=2.16u
+ PD=1.12u
M$162 1 73 32 1 sg13_lv_nmos L=0.13u W=0.74u AS=0.1406p AD=0.2516p PS=1.12u
+ PD=2.16u
M$163 1 22 87 1 sg13_lv_nmos L=0.13u W=0.74u AS=0.2516p AD=0.1406p PS=2.16u
+ PD=1.12u
M$164 87 167 1 1 sg13_lv_nmos L=0.13u W=0.74u AS=0.1406p AD=0.2516p PS=1.12u
+ PD=2.16u
M$165 1 111 90 1 sg13_lv_nmos L=0.13u W=0.74u AS=0.2516p AD=0.2516p PS=2.16u
+ PD=2.16u
M$166 1 115 91 1 sg13_lv_nmos L=0.13u W=0.55u AS=0.14875p AD=0.187p PS=1.16u
+ PD=1.78u
M$167 1 91 59 1 sg13_lv_nmos L=0.13u W=0.74u AS=0.14875p AD=0.2886p PS=1.16u
+ PD=2.26u
M$168 61 54 109 1 sg13_lv_nmos L=0.13u W=0.42u AS=0.1296p AD=0.0798p PS=1.52u
+ PD=0.8u
M$169 109 116 76 1 sg13_lv_nmos L=0.13u W=0.42u AS=0.0798p AD=0.2373p PS=0.8u
+ PD=1.97u
M$170 135 164 137 1 sg13_lv_nmos L=0.13u W=0.42u AS=0.1296p AD=0.0798p PS=1.52u
+ PD=0.8u
M$171 137 138 163 1 sg13_lv_nmos L=0.13u W=0.42u AS=0.0798p AD=0.2373p PS=0.8u
+ PD=1.97u
M$172 1 54 116 1 sg13_lv_nmos L=0.13u W=0.74u AS=0.317325p AD=0.2516p PS=1.805u
+ PD=2.16u
M$173 1 210 54 1 sg13_lv_nmos L=0.13u W=0.74u AS=0.317325p AD=0.2516p PS=1.805u
+ PD=2.16u
M$174 66 56 110 1 sg13_lv_nmos L=0.13u W=0.42u AS=0.1296p AD=0.0798p PS=1.52u
+ PD=0.8u
M$175 110 117 79 1 sg13_lv_nmos L=0.13u W=0.42u AS=0.0798p AD=0.2373p PS=0.8u
+ PD=1.97u
M$176 1 56 117 1 sg13_lv_nmos L=0.13u W=0.74u AS=0.317325p AD=0.2516p PS=1.805u
+ PD=2.16u
M$177 1 115 56 1 sg13_lv_nmos L=0.13u W=0.74u AS=0.317325p AD=0.2516p PS=1.805u
+ PD=2.16u
M$178 1 4 197 1 sg13_lv_nmos L=0.13u W=0.64u AS=0.2272p AD=0.0784p PS=1.99u
+ PD=0.885u
M$179 197 165 143 1 sg13_lv_nmos L=0.13u W=0.64u AS=0.0784p AD=0.2176p
+ PS=0.885u PD=1.96u
M$180 70 58 113 1 sg13_lv_nmos L=0.13u W=0.42u AS=0.1296p AD=0.0798p PS=1.52u
+ PD=0.8u
M$181 113 118 82 1 sg13_lv_nmos L=0.13u W=0.42u AS=0.0798p AD=0.2373p PS=0.8u
+ PD=1.97u
M$182 1 58 118 1 sg13_lv_nmos L=0.13u W=0.74u AS=0.317325p AD=0.2516p PS=1.805u
+ PD=2.16u
M$183 1 115 58 1 sg13_lv_nmos L=0.13u W=0.74u AS=0.317325p AD=0.2516p PS=1.805u
+ PD=2.16u
M$184 146 20 198 1 sg13_lv_nmos L=0.13u W=0.64u AS=0.2176p AD=0.0784p PS=1.96u
+ PD=0.885u
M$185 198 32 1 1 sg13_lv_nmos L=0.13u W=0.64u AS=0.0784p AD=0.2272p PS=0.885u
+ PD=1.99u
M$186 84 8 101 1 sg13_lv_nmos L=0.13u W=0.64u AS=0.2176p AD=0.1216p PS=1.96u
+ PD=1.02u
M$187 1 30 101 1 sg13_lv_nmos L=0.13u W=0.64u AS=0.1331p AD=0.1216p PS=1.12u
+ PD=1.02u
M$188 1 84 33 1 sg13_lv_nmos L=0.13u W=0.74u AS=0.1331p AD=0.2516p PS=1.12u
+ PD=2.16u
M$189 147 114 196 1 sg13_lv_nmos L=0.13u W=0.64u AS=0.2176p AD=0.1216p PS=1.96u
+ PD=1.02u
M$190 196 530 1 1 sg13_lv_nmos L=0.13u W=0.64u AS=0.1216p AD=0.1331p PS=1.02u
+ PD=1.12u
M$191 1 147 148 1 sg13_lv_nmos L=0.13u W=0.74u AS=0.1331p AD=0.2516p PS=1.12u
+ PD=2.16u
M$192 1 114 85 1 sg13_lv_nmos L=0.13u W=0.55u AS=0.374p AD=0.174625p PS=2.46u
+ PD=1.185u
M$193 1 530 85 1 sg13_lv_nmos L=0.13u W=0.55u AS=0.15245p AD=0.174625p PS=1.17u
+ PD=1.185u
M$194 1 114 98 1 sg13_lv_nmos L=0.13u W=0.74u AS=0.15245p AD=0.0888p PS=1.17u
+ PD=0.98u
M$195 98 530 86 1 sg13_lv_nmos L=0.13u W=0.74u AS=0.0888p AD=0.1628p PS=0.98u
+ PD=1.18u
M$196 86 85 1 1 sg13_lv_nmos L=0.13u W=0.74u AS=0.1628p AD=0.3108p PS=1.18u
+ PD=2.32u
M$197 1 17 88 1 sg13_lv_nmos L=0.13u W=0.55u AS=0.374p AD=0.174625p PS=2.46u
+ PD=1.185u
M$198 1 151 88 1 sg13_lv_nmos L=0.13u W=0.55u AS=0.15245p AD=0.174625p PS=1.17u
+ PD=1.185u
M$199 1 17 96 1 sg13_lv_nmos L=0.13u W=0.74u AS=0.15245p AD=0.0888p PS=1.17u
+ PD=0.98u
M$200 96 151 89 1 sg13_lv_nmos L=0.13u W=0.74u AS=0.0888p AD=0.1628p PS=0.98u
+ PD=1.18u
M$201 89 88 1 1 sg13_lv_nmos L=0.13u W=0.74u AS=0.1628p AD=0.3108p PS=1.18u
+ PD=2.32u
M$202 152 86 192 1 sg13_lv_nmos L=0.13u W=0.64u AS=0.2176p AD=0.0784p PS=1.96u
+ PD=0.885u
M$203 192 168 1 1 sg13_lv_nmos L=0.13u W=0.64u AS=0.0784p AD=0.2272p PS=0.885u
+ PD=1.99u
M$207 153 170 155 1 sg13_lv_nmos L=0.13u W=0.42u AS=0.1296p AD=0.0798p PS=1.52u
+ PD=0.8u
M$208 155 156 169 1 sg13_lv_nmos L=0.13u W=0.42u AS=0.0798p AD=0.2373p PS=0.8u
+ PD=1.97u
M$212 138 164 1 1 sg13_lv_nmos L=0.13u W=0.74u AS=0.2516p AD=0.317325p PS=2.16u
+ PD=1.805u
M$213 1 210 164 1 sg13_lv_nmos L=0.13u W=0.74u AS=0.317325p AD=0.2516p
+ PS=1.805u PD=2.16u
M$214 180 164 139 1 sg13_lv_nmos L=0.13u W=0.42u AS=0.1428p AD=0.12665p
+ PS=1.52u PD=1.145u
M$215 139 138 136 1 sg13_lv_nmos L=0.13u W=0.74u AS=0.12665p AD=0.3473p
+ PS=1.145u PD=2.71u
M$216 1 166 145 1 sg13_lv_nmos L=0.13u W=0.55u AS=0.15245p AD=0.174625p
+ PS=1.17u PD=1.185u
M$217 145 14 1 1 sg13_lv_nmos L=0.13u W=0.55u AS=0.174625p AD=0.374p PS=1.185u
+ PD=2.46u
M$218 1 145 165 1 sg13_lv_nmos L=0.13u W=0.74u AS=0.3108p AD=0.1628p PS=2.32u
+ PD=1.18u
M$219 165 166 199 1 sg13_lv_nmos L=0.13u W=0.74u AS=0.1628p AD=0.0888p PS=1.18u
+ PD=0.98u
M$220 199 14 1 1 sg13_lv_nmos L=0.13u W=0.74u AS=0.0888p AD=0.15245p PS=0.98u
+ PD=1.17u
M$221 1 22 149 1 sg13_lv_nmos L=0.13u W=0.55u AS=0.374p AD=0.174625p PS=2.46u
+ PD=1.185u
M$222 149 167 1 1 sg13_lv_nmos L=0.13u W=0.55u AS=0.174625p AD=0.15245p
+ PS=1.185u PD=1.17u
M$223 1 22 194 1 sg13_lv_nmos L=0.13u W=0.74u AS=0.15245p AD=0.0888p PS=1.17u
+ PD=0.98u
M$224 194 167 151 1 sg13_lv_nmos L=0.13u W=0.74u AS=0.0888p AD=0.1628p PS=0.98u
+ PD=1.18u
M$225 151 149 1 1 sg13_lv_nmos L=0.13u W=0.74u AS=0.1628p AD=0.3108p PS=1.18u
+ PD=2.32u
M$226 156 170 1 1 sg13_lv_nmos L=0.13u W=0.74u AS=0.2516p AD=0.317325p PS=2.16u
+ PD=1.805u
M$227 1 115 170 1 sg13_lv_nmos L=0.13u W=0.74u AS=0.317325p AD=0.2516p
+ PS=1.805u PD=2.16u
M$228 184 170 157 1 sg13_lv_nmos L=0.13u W=0.42u AS=0.1428p AD=0.12665p
+ PS=1.52u PD=1.145u
M$229 157 156 154 1 sg13_lv_nmos L=0.13u W=0.74u AS=0.12665p AD=0.3473p
+ PS=1.145u PD=2.71u
M$232 133 107 1 1 sg13_lv_nmos L=0.13u W=0.55u AS=0.187p AD=0.18945p PS=1.78u
+ PD=1.27u
M$233 1 107 186 1 sg13_lv_nmos L=0.13u W=0.74u AS=0.18945p AD=0.13135p PS=1.27u
+ PD=1.095u
M$234 186 162 134 1 sg13_lv_nmos L=0.13u W=0.74u AS=0.13135p AD=0.1628p
+ PS=1.095u PD=1.18u
M$235 134 65 187 1 sg13_lv_nmos L=0.13u W=0.74u AS=0.1628p AD=0.3367p PS=1.18u
+ PD=1.65u
M$236 187 133 1 1 sg13_lv_nmos L=0.13u W=0.74u AS=0.3367p AD=0.148p PS=1.65u
+ PD=1.14u
M$237 1 134 108 1 sg13_lv_nmos L=0.13u W=0.74u AS=0.148p AD=0.4033p PS=1.14u
+ PD=2.57u
M$238 141 139 1 1 sg13_lv_nmos L=0.13u W=0.74u AS=0.2516p AD=0.1406p PS=2.16u
+ PD=1.12u
M$239 1 141 114 1 sg13_lv_nmos L=0.13u W=0.74u AS=0.1406p AD=0.2516p PS=1.12u
+ PD=2.16u
M$243 142 11 1 1 sg13_lv_nmos L=0.13u W=0.55u AS=0.187p AD=0.14505p PS=1.78u
+ PD=1.15u
M$244 1 65 195 1 sg13_lv_nmos L=0.13u W=0.74u AS=0.14505p AD=0.1406p PS=1.15u
+ PD=1.12u
M$245 195 142 4 1 sg13_lv_nmos L=0.13u W=0.74u AS=0.1406p AD=0.333p PS=1.12u
+ PD=2.38u
M$247 181 4 1 1 sg13_lv_nmos L=0.13u W=0.74u AS=0.2516p AD=0.1898p PS=2.16u
+ PD=1.36u
M$248 1 165 181 1 sg13_lv_nmos L=0.13u W=0.74u AS=0.1898p AD=0.1406p PS=1.36u
+ PD=1.12u
M$249 181 143 112 1 sg13_lv_nmos L=0.13u W=0.74u AS=0.1406p AD=0.2516p PS=1.12u
+ PD=2.16u
M$254 166 146 182 1 sg13_lv_nmos L=0.13u W=0.74u AS=0.2516p AD=0.1406p PS=2.16u
+ PD=1.12u
M$255 182 20 1 1 sg13_lv_nmos L=0.13u W=0.74u AS=0.1406p AD=0.1898p PS=1.12u
+ PD=1.36u
M$256 1 32 182 1 sg13_lv_nmos L=0.13u W=0.74u AS=0.1898p AD=0.2516p PS=1.36u
+ PD=2.16u
M$259 167 152 183 1 sg13_lv_nmos L=0.13u W=0.74u AS=0.2516p AD=0.1406p PS=2.16u
+ PD=1.12u
M$260 183 86 1 1 sg13_lv_nmos L=0.13u W=0.74u AS=0.1406p AD=0.1898p PS=1.12u
+ PD=1.36u
M$261 1 168 183 1 sg13_lv_nmos L=0.13u W=0.74u AS=0.1898p AD=0.2516p PS=1.36u
+ PD=2.16u
M$262 159 157 1 1 sg13_lv_nmos L=0.13u W=0.74u AS=0.2516p AD=0.1406p PS=2.16u
+ PD=1.12u
M$263 1 159 168 1 sg13_lv_nmos L=0.13u W=0.74u AS=0.1406p AD=0.2516p PS=1.12u
+ PD=2.16u
M$266 1 107 200 1 sg13_lv_nmos L=0.13u W=0.55u AS=0.18945p AD=0.187p PS=1.27u
+ PD=1.78u
M$267 1 107 204 1 sg13_lv_nmos L=0.13u W=0.74u AS=0.18945p AD=0.13135p PS=1.27u
+ PD=1.095u
M$268 204 8 201 1 sg13_lv_nmos L=0.13u W=0.74u AS=0.13135p AD=0.1628p PS=1.095u
+ PD=1.18u
M$269 201 114 205 1 sg13_lv_nmos L=0.13u W=0.74u AS=0.1628p AD=0.3367p PS=1.18u
+ PD=1.65u
M$270 205 200 1 1 sg13_lv_nmos L=0.13u W=0.74u AS=0.3367p AD=0.148p PS=1.65u
+ PD=1.14u
M$271 1 201 202 1 sg13_lv_nmos L=0.13u W=0.74u AS=0.148p AD=0.4033p PS=1.14u
+ PD=2.57u
M$272 1 137 136 1 sg13_lv_nmos L=0.13u W=0.74u AS=0.1626p AD=0.2516p PS=1.415u
+ PD=2.16u
M$273 135 202 188 1 sg13_lv_nmos L=0.13u W=0.42u AS=0.1428p AD=0.0609p PS=1.52u
+ PD=0.71u
M$274 1 132 188 1 sg13_lv_nmos L=0.13u W=0.42u AS=0.1626p AD=0.0609p PS=1.415u
+ PD=0.71u
M$275 1 74 132 1 sg13_lv_nmos L=0.13u W=0.74u AS=0.2516p AD=0.2516p PS=2.16u
+ PD=2.16u
M$278 1 132 189 1 sg13_lv_nmos L=0.13u W=0.42u AS=0.1701p AD=0.0378p PS=1.65u
+ PD=0.6u
M$279 189 136 163 1 sg13_lv_nmos L=0.13u W=0.42u AS=0.0378p AD=0.1428p PS=0.6u
+ PD=1.52u
M$284 180 140 1 1 sg13_lv_nmos L=0.13u W=0.42u AS=0.1428p AD=0.0798p PS=1.52u
+ PD=0.8u
M$285 1 132 193 1 sg13_lv_nmos L=0.13u W=0.42u AS=0.0798p AD=0.0378p PS=0.8u
+ PD=0.6u
M$286 193 139 140 1 sg13_lv_nmos L=0.13u W=0.42u AS=0.0378p AD=0.1428p PS=0.6u
+ PD=1.52u
M$309 1 148 203 1 sg13_lv_nmos L=0.13u W=0.74u AS=0.2516p AD=0.1406p PS=2.16u
+ PD=1.12u
M$310 203 168 206 1 sg13_lv_nmos L=0.13u W=0.74u AS=0.1406p AD=0.1406p PS=1.12u
+ PD=1.12u
M$311 206 86 1 1 sg13_lv_nmos L=0.13u W=0.74u AS=0.1406p AD=0.2516p PS=1.12u
+ PD=2.16u
M$316 1 155 154 1 sg13_lv_nmos L=0.13u W=0.74u AS=0.1626p AD=0.2516p PS=1.415u
+ PD=2.16u
M$317 153 89 191 1 sg13_lv_nmos L=0.13u W=0.42u AS=0.1428p AD=0.0609p PS=1.52u
+ PD=0.71u
M$318 1 90 191 1 sg13_lv_nmos L=0.13u W=0.42u AS=0.1626p AD=0.0609p PS=1.415u
+ PD=0.71u
M$321 1 90 190 1 sg13_lv_nmos L=0.13u W=0.42u AS=0.1701p AD=0.0378p PS=1.65u
+ PD=0.6u
M$322 190 154 169 1 sg13_lv_nmos L=0.13u W=0.42u AS=0.0378p AD=0.1428p PS=0.6u
+ PD=1.52u
M$327 184 158 1 1 sg13_lv_nmos L=0.13u W=0.42u AS=0.1428p AD=0.0798p PS=1.52u
+ PD=0.8u
M$328 1 90 185 1 sg13_lv_nmos L=0.13u W=0.42u AS=0.0798p AD=0.0378p PS=0.8u
+ PD=0.6u
M$329 185 157 158 1 sg13_lv_nmos L=0.13u W=0.42u AS=0.0378p AD=0.1428p PS=0.6u
+ PD=1.52u
M$339 1 211 210 1 sg13_lv_nmos L=0.13u W=11.84u AS=2.3606p AD=2.2496p PS=18.96u
+ PD=17.92u
M$355 1 415 211 1 sg13_lv_nmos L=0.13u W=4.44u AS=0.8436p AD=0.9546p PS=6.72u
+ PD=7.76u
M$379 1 217 212 1 sg13_lv_nmos L=0.13u W=0.74u AS=0.2516p AD=0.1406p PS=2.16u
+ PD=1.12u
M$380 212 203 1 1 sg13_lv_nmos L=0.13u W=0.74u AS=0.1406p AD=0.2516p PS=1.12u
+ PD=2.16u
M$381 1 215 219 1 sg13_lv_nmos L=0.13u W=0.64u AS=0.1331p AD=0.1216p PS=1.12u
+ PD=1.02u
M$382 219 151 214 1 sg13_lv_nmos L=0.13u W=0.64u AS=0.1216p AD=0.2176p PS=1.02u
+ PD=1.96u
M$383 213 214 1 1 sg13_lv_nmos L=0.13u W=0.74u AS=0.2516p AD=0.1331p PS=2.16u
+ PD=1.12u
M$394 1 218 225 1 sg13_lv_nmos L=0.13u W=0.55u AS=0.14875p AD=0.187p PS=1.16u
+ PD=1.78u
M$395 1 225 162 1 sg13_lv_nmos L=0.13u W=0.74u AS=0.14875p AD=0.2886p PS=1.16u
+ PD=2.26u
M$397 220 221 1 1 sg13_lv_nmos L=0.13u W=0.74u AS=0.4033p AD=0.148p PS=2.57u
+ PD=1.14u
M$398 1 226 237 1 sg13_lv_nmos L=0.13u W=0.74u AS=0.148p AD=0.3367p PS=1.14u
+ PD=1.65u
M$399 237 227 221 1 sg13_lv_nmos L=0.13u W=0.74u AS=0.3367p AD=0.1628p PS=1.65u
+ PD=1.18u
M$400 221 114 238 1 sg13_lv_nmos L=0.13u W=0.74u AS=0.1628p AD=0.13135p
+ PS=1.18u PD=1.095u
M$401 238 107 1 1 sg13_lv_nmos L=0.13u W=0.74u AS=0.13135p AD=0.18945p
+ PS=1.095u PD=1.27u
M$402 1 107 226 1 sg13_lv_nmos L=0.13u W=0.55u AS=0.18945p AD=0.187p PS=1.27u
+ PD=1.78u
M$417 1 227 228 1 sg13_lv_nmos L=0.13u W=0.55u AS=0.374p AD=0.174625p PS=2.46u
+ PD=1.185u
M$418 1 30 228 1 sg13_lv_nmos L=0.13u W=0.55u AS=0.15245p AD=0.174625p PS=1.17u
+ PD=1.185u
M$419 1 227 239 1 sg13_lv_nmos L=0.13u W=0.74u AS=0.15245p AD=0.0888p PS=1.17u
+ PD=0.98u
M$420 239 30 222 1 sg13_lv_nmos L=0.13u W=0.74u AS=0.0888p AD=0.1628p PS=0.98u
+ PD=1.18u
M$421 222 228 1 1 sg13_lv_nmos L=0.13u W=0.74u AS=0.1628p AD=0.3108p PS=1.18u
+ PD=2.32u
M$424 1 222 240 1 sg13_lv_nmos L=0.13u W=0.74u AS=0.2516p AD=0.1406p PS=2.16u
+ PD=1.12u
M$425 240 229 289 1 sg13_lv_nmos L=0.13u W=0.74u AS=0.1406p AD=0.2516p PS=1.12u
+ PD=2.16u
M$428 1 229 242 1 sg13_lv_nmos L=0.13u W=0.64u AS=0.2272p AD=0.0784p PS=1.99u
+ PD=0.885u
M$429 242 222 230 1 sg13_lv_nmos L=0.13u W=0.64u AS=0.0784p AD=0.2176p
+ PS=0.885u PD=1.96u
M$430 1 229 231 1 sg13_lv_nmos L=0.13u W=0.74u AS=0.1898p AD=0.2516p PS=1.36u
+ PD=2.16u
M$431 1 222 231 1 sg13_lv_nmos L=0.13u W=0.74u AS=0.1898p AD=0.1406p PS=1.36u
+ PD=1.12u
M$432 231 230 217 1 sg13_lv_nmos L=0.13u W=0.74u AS=0.1406p AD=0.2516p PS=1.12u
+ PD=2.16u
M$435 1 224 223 1 sg13_lv_nmos L=0.13u W=1.48u AS=0.3922p AD=0.3922p PS=3.28u
+ PD=3.28u
M$437 1 212 224 1 sg13_lv_nmos L=0.13u W=0.74u AS=0.3811p AD=0.1406p PS=2.51u
+ PD=1.12u
M$438 224 87 244 1 sg13_lv_nmos L=0.13u W=0.74u AS=0.1406p AD=0.09435p PS=1.12u
+ PD=0.995u
M$439 244 232 1 1 sg13_lv_nmos L=0.13u W=0.74u AS=0.09435p AD=0.2516p PS=0.995u
+ PD=2.16u
M$440 1 203 233 1 sg13_lv_nmos L=0.13u W=0.55u AS=0.374p AD=0.174625p PS=2.46u
+ PD=1.185u
M$441 1 217 233 1 sg13_lv_nmos L=0.13u W=0.55u AS=0.15245p AD=0.174625p
+ PS=1.17u PD=1.185u
M$442 1 203 243 1 sg13_lv_nmos L=0.13u W=0.74u AS=0.15245p AD=0.0888p PS=1.17u
+ PD=0.98u
M$443 243 217 215 1 sg13_lv_nmos L=0.13u W=0.74u AS=0.0888p AD=0.1628p PS=0.98u
+ PD=1.18u
M$444 215 233 1 1 sg13_lv_nmos L=0.13u W=0.74u AS=0.1628p AD=0.3108p PS=1.18u
+ PD=2.32u
M$445 1 215 241 1 sg13_lv_nmos L=0.13u W=0.64u AS=0.2272p AD=0.0784p PS=1.99u
+ PD=0.885u
M$446 241 277 234 1 sg13_lv_nmos L=0.13u W=0.64u AS=0.0784p AD=0.2176p
+ PS=0.885u PD=1.96u
M$447 1 215 235 1 sg13_lv_nmos L=0.13u W=0.74u AS=0.1898p AD=0.2516p PS=1.36u
+ PD=2.16u
M$448 1 277 235 1 sg13_lv_nmos L=0.13u W=0.74u AS=0.1898p AD=0.1406p PS=1.36u
+ PD=1.12u
M$449 235 234 246 1 sg13_lv_nmos L=0.13u W=0.74u AS=0.1406p AD=0.2516p PS=1.12u
+ PD=2.16u
M$454 115 236 1 1 sg13_lv_nmos L=0.13u W=0.74u AS=0.2886p AD=0.14875p PS=2.26u
+ PD=1.16u
M$455 1 247 236 1 sg13_lv_nmos L=0.13u W=0.55u AS=0.14875p AD=0.187p PS=1.16u
+ PD=1.78u
M$460 1 74 257 1 sg13_lv_nmos L=0.13u W=0.74u AS=0.2516p AD=0.2516p PS=2.16u
+ PD=2.16u
M$461 256 283 262 1 sg13_lv_nmos L=0.13u W=0.42u AS=0.1296p AD=0.0798p PS=1.52u
+ PD=0.8u
M$462 262 263 300 1 sg13_lv_nmos L=0.13u W=0.42u AS=0.0798p AD=0.2373p PS=0.8u
+ PD=1.97u
M$463 263 283 1 1 sg13_lv_nmos L=0.13u W=0.74u AS=0.2516p AD=0.317325p PS=2.16u
+ PD=1.805u
M$464 1 210 283 1 sg13_lv_nmos L=0.13u W=0.74u AS=0.317325p AD=0.2516p
+ PS=1.805u PD=2.16u
M$465 301 283 284 1 sg13_lv_nmos L=0.13u W=0.42u AS=0.1428p AD=0.12665p
+ PS=1.52u PD=1.145u
M$466 284 263 261 1 sg13_lv_nmos L=0.13u W=0.74u AS=0.12665p AD=0.3473p
+ PS=1.145u PD=2.71u
M$467 264 284 1 1 sg13_lv_nmos L=0.13u W=0.74u AS=0.2516p AD=0.1406p PS=2.16u
+ PD=1.12u
M$468 1 264 227 1 sg13_lv_nmos L=0.13u W=0.74u AS=0.1406p AD=0.2516p PS=1.12u
+ PD=2.16u
M$470 265 286 313 1 sg13_lv_nmos L=0.13u W=0.74u AS=0.2516p AD=0.1406p PS=2.16u
+ PD=1.12u
M$471 313 30 1 1 sg13_lv_nmos L=0.13u W=0.74u AS=0.1406p AD=0.2516p PS=1.12u
+ PD=2.16u
M$474 1 288 316 1 sg13_lv_nmos L=0.13u W=0.64u AS=0.2272p AD=0.0784p PS=1.99u
+ PD=0.885u
M$475 316 287 266 1 sg13_lv_nmos L=0.13u W=0.64u AS=0.0784p AD=0.2176p
+ PS=0.885u PD=1.96u
M$476 302 288 1 1 sg13_lv_nmos L=0.13u W=0.74u AS=0.2516p AD=0.1898p PS=2.16u
+ PD=1.36u
M$477 1 287 302 1 sg13_lv_nmos L=0.13u W=0.74u AS=0.1898p AD=0.1406p PS=1.36u
+ PD=1.12u
M$478 302 266 267 1 sg13_lv_nmos L=0.13u W=0.74u AS=0.1406p AD=0.2516p PS=1.12u
+ PD=2.16u
M$479 1 30 317 1 sg13_lv_nmos L=0.13u W=0.74u AS=0.2516p AD=0.1406p PS=2.16u
+ PD=1.12u
M$480 317 227 268 1 sg13_lv_nmos L=0.13u W=0.74u AS=0.1406p AD=0.2516p PS=1.12u
+ PD=2.16u
M$481 1 267 318 1 sg13_lv_nmos L=0.13u W=0.74u AS=0.2886p AD=0.1406p PS=2.26u
+ PD=1.12u
M$482 318 289 319 1 sg13_lv_nmos L=0.13u W=0.74u AS=0.1406p AD=0.1406p PS=1.12u
+ PD=1.12u
M$483 319 268 258 1 sg13_lv_nmos L=0.13u W=0.74u AS=0.1406p AD=0.2516p PS=1.12u
+ PD=2.16u
M$484 269 258 1 1 sg13_lv_nmos L=0.13u W=0.55u AS=0.187p AD=0.17255p PS=1.78u
+ PD=1.25u
M$485 1 269 270 1 sg13_lv_nmos L=0.13u W=0.74u AS=0.17255p AD=0.1406p PS=1.25u
+ PD=1.12u
M$486 270 348 1 1 sg13_lv_nmos L=0.13u W=0.74u AS=0.1406p AD=0.2516p PS=1.12u
+ PD=2.16u
M$487 271 530 1 1 sg13_lv_nmos L=0.13u W=0.55u AS=0.187p AD=0.14875p PS=1.78u
+ PD=1.16u
M$488 1 271 30 1 sg13_lv_nmos L=0.13u W=0.74u AS=0.14875p AD=0.2886p PS=1.16u
+ PD=2.26u
M$492 272 111 1 1 sg13_lv_nmos L=0.13u W=0.74u AS=0.2516p AD=0.2516p PS=2.16u
+ PD=2.16u
M$494 1 213 303 1 sg13_lv_nmos L=0.13u W=1.48u AS=0.3922p AD=0.2812p PS=3.28u
+ PD=2.24u
M$495 303 17 274 1 sg13_lv_nmos L=0.13u W=1.48u AS=0.2812p AD=0.2812p PS=2.24u
+ PD=2.24u
M$498 1 223 274 1 sg13_lv_nmos L=0.13u W=1.48u AS=0.2812p AD=0.3922p PS=2.24u
+ PD=3.28u
M$500 1 223 290 1 sg13_lv_nmos L=0.13u W=0.64u AS=0.15745p AD=0.1216p PS=1.175u
+ PD=1.02u
M$501 290 17 315 1 sg13_lv_nmos L=0.13u W=0.64u AS=0.1216p AD=0.0816p PS=1.02u
+ PD=0.895u
M$502 315 213 1 1 sg13_lv_nmos L=0.13u W=0.64u AS=0.0816p AD=0.2176p PS=0.895u
+ PD=1.96u
M$503 275 290 1 1 sg13_lv_nmos L=0.13u W=0.74u AS=0.2351p AD=0.15745p PS=2.16u
+ PD=1.175u
M$504 1 217 314 1 sg13_lv_nmos L=0.13u W=0.74u AS=0.2516p AD=0.1406p PS=2.16u
+ PD=1.12u
M$505 314 203 232 1 sg13_lv_nmos L=0.13u W=0.74u AS=0.1406p AD=0.2516p PS=1.12u
+ PD=2.16u
M$506 1 87 277 1 sg13_lv_nmos L=0.13u W=0.74u AS=0.2516p AD=0.1406p PS=2.16u
+ PD=1.12u
M$507 277 17 312 1 sg13_lv_nmos L=0.13u W=0.74u AS=0.1406p AD=0.1406p PS=1.12u
+ PD=1.12u
M$508 312 151 1 1 sg13_lv_nmos L=0.13u W=0.74u AS=0.1406p AD=0.2516p PS=1.12u
+ PD=2.16u
M$510 1 111 260 1 sg13_lv_nmos L=0.13u W=0.74u AS=0.2516p AD=0.2516p PS=2.16u
+ PD=2.16u
M$511 259 291 280 1 sg13_lv_nmos L=0.13u W=0.42u AS=0.1296p AD=0.0798p PS=1.52u
+ PD=0.8u
M$512 280 281 304 1 sg13_lv_nmos L=0.13u W=0.42u AS=0.0798p AD=0.2373p PS=0.8u
+ PD=1.97u
M$513 281 291 1 1 sg13_lv_nmos L=0.13u W=0.74u AS=0.2516p AD=0.317325p PS=2.16u
+ PD=1.805u
M$514 1 115 291 1 sg13_lv_nmos L=0.13u W=0.74u AS=0.317325p AD=0.2516p
+ PS=1.805u PD=2.16u
M$515 305 291 292 1 sg13_lv_nmos L=0.13u W=0.42u AS=0.1428p AD=0.12665p
+ PS=1.52u PD=1.145u
M$516 292 281 279 1 sg13_lv_nmos L=0.13u W=0.74u AS=0.12665p AD=0.3473p
+ PS=1.145u PD=2.71u
M$517 282 292 1 1 sg13_lv_nmos L=0.13u W=0.74u AS=0.2516p AD=0.1406p PS=2.16u
+ PD=1.12u
M$518 1 282 229 1 sg13_lv_nmos L=0.13u W=0.74u AS=0.1406p AD=0.2516p PS=1.12u
+ PD=2.16u
M$521 1 74 320 1 sg13_lv_nmos L=0.13u W=0.74u AS=0.2516p AD=0.2516p PS=2.16u
+ PD=2.16u
M$522 321 396 358 1 sg13_lv_nmos L=0.13u W=0.42u AS=0.1428p AD=0.0609p PS=1.52u
+ PD=0.71u
M$523 358 320 1 1 sg13_lv_nmos L=0.13u W=0.42u AS=0.0609p AD=0.1626p PS=0.71u
+ PD=1.415u
M$524 1 374 322 1 sg13_lv_nmos L=0.13u W=0.74u AS=0.1626p AD=0.2516p PS=1.415u
+ PD=2.16u
M$525 1 262 261 1 sg13_lv_nmos L=0.13u W=0.74u AS=0.1626p AD=0.2516p PS=1.415u
+ PD=2.16u
M$526 256 220 307 1 sg13_lv_nmos L=0.13u W=0.42u AS=0.1428p AD=0.0609p PS=1.52u
+ PD=0.71u
M$527 1 257 307 1 sg13_lv_nmos L=0.13u W=0.42u AS=0.1626p AD=0.0609p PS=1.415u
+ PD=0.71u
M$528 1 320 359 1 sg13_lv_nmos L=0.13u W=0.42u AS=0.1701p AD=0.0378p PS=1.65u
+ PD=0.6u
M$529 359 322 342 1 sg13_lv_nmos L=0.13u W=0.42u AS=0.0378p AD=0.1428p PS=0.6u
+ PD=1.52u
M$530 1 257 308 1 sg13_lv_nmos L=0.13u W=0.42u AS=0.1701p AD=0.0378p PS=1.65u
+ PD=0.6u
M$531 308 261 300 1 sg13_lv_nmos L=0.13u W=0.42u AS=0.0378p AD=0.1428p PS=0.6u
+ PD=1.52u
M$532 343 323 324 1 sg13_lv_nmos L=0.13u W=0.42u AS=0.12665p AD=0.1428p
+ PS=1.145u PD=1.52u
M$533 322 375 343 1 sg13_lv_nmos L=0.13u W=0.74u AS=0.3473p AD=0.12665p
+ PS=2.71u PD=1.145u
M$534 324 325 1 1 sg13_lv_nmos L=0.13u W=0.42u AS=0.1428p AD=0.0798p PS=1.52u
+ PD=0.8u
M$535 1 320 362 1 sg13_lv_nmos L=0.13u W=0.42u AS=0.0798p AD=0.0378p PS=0.8u
+ PD=0.6u
M$536 362 343 325 1 sg13_lv_nmos L=0.13u W=0.42u AS=0.0378p AD=0.1428p PS=0.6u
+ PD=1.52u
M$537 301 285 1 1 sg13_lv_nmos L=0.13u W=0.42u AS=0.1428p AD=0.0798p PS=1.52u
+ PD=0.8u
M$538 1 257 309 1 sg13_lv_nmos L=0.13u W=0.42u AS=0.0798p AD=0.0378p PS=0.8u
+ PD=0.6u
M$539 309 284 285 1 sg13_lv_nmos L=0.13u W=0.42u AS=0.0378p AD=0.1428p PS=0.6u
+ PD=1.52u
M$540 326 343 1 1 sg13_lv_nmos L=0.13u W=0.74u AS=0.2516p AD=0.1406p PS=2.16u
+ PD=1.12u
M$541 1 326 286 1 sg13_lv_nmos L=0.13u W=0.74u AS=0.1406p AD=0.2516p PS=1.12u
+ PD=2.16u
M$542 1 286 344 1 sg13_lv_nmos L=0.13u W=0.55u AS=0.374p AD=0.174625p PS=2.46u
+ PD=1.185u
M$543 1 30 344 1 sg13_lv_nmos L=0.13u W=0.55u AS=0.15245p AD=0.174625p PS=1.17u
+ PD=1.185u
M$544 1 286 363 1 sg13_lv_nmos L=0.13u W=0.74u AS=0.15245p AD=0.0888p PS=1.17u
+ PD=0.98u
M$545 363 30 287 1 sg13_lv_nmos L=0.13u W=0.74u AS=0.0888p AD=0.1628p PS=0.98u
+ PD=1.18u
M$546 287 344 1 1 sg13_lv_nmos L=0.13u W=0.74u AS=0.1628p AD=0.3108p PS=1.18u
+ PD=2.32u
M$547 1 287 364 1 sg13_lv_nmos L=0.13u W=0.74u AS=0.2516p AD=0.1406p PS=2.16u
+ PD=1.12u
M$548 364 288 345 1 sg13_lv_nmos L=0.13u W=0.74u AS=0.1406p AD=0.2516p PS=1.12u
+ PD=2.16u
M$549 1 347 368 1 sg13_lv_nmos L=0.13u W=0.74u AS=0.2886p AD=0.1406p PS=2.26u
+ PD=1.12u
M$550 368 345 367 1 sg13_lv_nmos L=0.13u W=0.74u AS=0.1406p AD=0.1406p PS=1.12u
+ PD=1.12u
M$551 367 265 327 1 sg13_lv_nmos L=0.13u W=0.74u AS=0.1406p AD=0.2516p PS=1.12u
+ PD=2.16u
M$553 1 274 351 1 sg13_lv_nmos L=0.13u W=0.74u AS=0.1898p AD=0.2516p PS=1.36u
+ PD=2.16u
M$554 1 270 351 1 sg13_lv_nmos L=0.13u W=0.74u AS=0.1898p AD=0.1406p PS=1.36u
+ PD=1.12u
M$555 351 350 328 1 sg13_lv_nmos L=0.13u W=0.74u AS=0.1406p AD=0.2516p PS=1.12u
+ PD=2.16u
M$556 329 328 370 1 sg13_lv_nmos L=0.13u W=0.42u AS=0.1428p AD=0.0609p PS=1.52u
+ PD=0.71u
M$557 370 272 1 1 sg13_lv_nmos L=0.13u W=0.42u AS=0.0609p AD=0.1626p PS=0.71u
+ PD=1.415u
M$558 1 379 330 1 sg13_lv_nmos L=0.13u W=0.74u AS=0.1626p AD=0.2516p PS=1.415u
+ PD=2.16u
M$559 1 272 369 1 sg13_lv_nmos L=0.13u W=0.42u AS=0.1701p AD=0.0378p PS=1.65u
+ PD=0.6u
M$560 369 330 352 1 sg13_lv_nmos L=0.13u W=0.42u AS=0.0378p AD=0.1428p PS=0.6u
+ PD=1.52u
M$561 353 331 332 1 sg13_lv_nmos L=0.13u W=0.42u AS=0.12665p AD=0.1428p
+ PS=1.145u PD=1.52u
M$562 330 380 353 1 sg13_lv_nmos L=0.13u W=0.74u AS=0.3473p AD=0.12665p
+ PS=2.71u PD=1.145u
M$563 332 333 1 1 sg13_lv_nmos L=0.13u W=0.42u AS=0.1428p AD=0.0798p PS=1.52u
+ PD=0.8u
M$564 1 272 365 1 sg13_lv_nmos L=0.13u W=0.42u AS=0.0798p AD=0.0378p PS=0.8u
+ PD=0.6u
M$565 365 353 333 1 sg13_lv_nmos L=0.13u W=0.42u AS=0.0378p AD=0.1428p PS=0.6u
+ PD=1.52u
M$566 334 353 1 1 sg13_lv_nmos L=0.13u W=0.74u AS=0.2516p AD=0.1406p PS=2.16u
+ PD=1.12u
M$567 1 334 288 1 sg13_lv_nmos L=0.13u W=0.74u AS=0.1406p AD=0.2516p PS=1.12u
+ PD=2.16u
M$573 1 115 335 1 sg13_lv_nmos L=0.13u W=0.74u AS=0.2516p AD=0.2516p PS=2.16u
+ PD=2.16u
M$574 336 335 361 1 sg13_lv_nmos L=0.13u W=0.42u AS=0.1428p AD=0.0609p PS=1.52u
+ PD=0.71u
M$575 361 354 1 1 sg13_lv_nmos L=0.13u W=0.42u AS=0.0609p AD=0.1626p PS=0.71u
+ PD=1.415u
M$576 1 381 337 1 sg13_lv_nmos L=0.13u W=0.74u AS=0.1626p AD=0.2516p PS=1.415u
+ PD=2.16u
M$577 1 280 279 1 sg13_lv_nmos L=0.13u W=0.74u AS=0.1626p AD=0.2516p PS=1.415u
+ PD=2.16u
M$578 259 246 311 1 sg13_lv_nmos L=0.13u W=0.42u AS=0.1428p AD=0.0609p PS=1.52u
+ PD=0.71u
M$579 1 260 311 1 sg13_lv_nmos L=0.13u W=0.42u AS=0.1626p AD=0.0609p PS=1.415u
+ PD=0.71u
M$580 1 260 310 1 sg13_lv_nmos L=0.13u W=0.42u AS=0.1701p AD=0.0378p PS=1.65u
+ PD=0.6u
M$581 310 279 304 1 sg13_lv_nmos L=0.13u W=0.42u AS=0.0378p AD=0.1428p PS=0.6u
+ PD=1.52u
M$582 1 354 360 1 sg13_lv_nmos L=0.13u W=0.42u AS=0.1701p AD=0.0378p PS=1.65u
+ PD=0.6u
M$583 360 337 355 1 sg13_lv_nmos L=0.13u W=0.42u AS=0.0378p AD=0.1428p PS=0.6u
+ PD=1.52u
M$584 356 338 339 1 sg13_lv_nmos L=0.13u W=0.42u AS=0.12665p AD=0.1428p
+ PS=1.145u PD=1.52u
M$585 337 382 356 1 sg13_lv_nmos L=0.13u W=0.74u AS=0.3473p AD=0.12665p
+ PS=2.71u PD=1.145u
M$586 339 340 1 1 sg13_lv_nmos L=0.13u W=0.42u AS=0.1428p AD=0.0798p PS=1.52u
+ PD=0.8u
M$587 1 354 357 1 sg13_lv_nmos L=0.13u W=0.42u AS=0.0798p AD=0.0378p PS=0.8u
+ PD=0.6u
M$588 357 356 340 1 sg13_lv_nmos L=0.13u W=0.42u AS=0.0378p AD=0.1428p PS=0.6u
+ PD=1.52u
M$589 305 293 1 1 sg13_lv_nmos L=0.13u W=0.42u AS=0.1428p AD=0.0798p PS=1.52u
+ PD=0.8u
M$590 1 260 306 1 sg13_lv_nmos L=0.13u W=0.42u AS=0.0798p AD=0.0378p PS=0.8u
+ PD=0.6u
M$591 306 292 293 1 sg13_lv_nmos L=0.13u W=0.42u AS=0.0378p AD=0.1428p PS=0.6u
+ PD=1.52u
M$592 341 356 1 1 sg13_lv_nmos L=0.13u W=0.74u AS=0.2516p AD=0.1406p PS=2.16u
+ PD=1.12u
M$593 1 341 247 1 sg13_lv_nmos L=0.13u W=0.74u AS=0.1406p AD=0.2516p PS=1.12u
+ PD=2.16u
M$596 1 107 392 1 sg13_lv_nmos L=0.13u W=0.55u AS=0.18945p AD=0.187p PS=1.27u
+ PD=1.78u
M$597 396 405 1 1 sg13_lv_nmos L=0.13u W=0.74u AS=0.4033p AD=0.148p PS=2.57u
+ PD=1.14u
M$598 1 392 407 1 sg13_lv_nmos L=0.13u W=0.74u AS=0.148p AD=0.3367p PS=1.14u
+ PD=1.65u
M$599 407 286 405 1 sg13_lv_nmos L=0.13u W=0.74u AS=0.3367p AD=0.1628p PS=1.65u
+ PD=1.18u
M$600 405 227 408 1 sg13_lv_nmos L=0.13u W=0.74u AS=0.1628p AD=0.13135p
+ PS=1.18u PD=1.095u
M$601 408 107 1 1 sg13_lv_nmos L=0.13u W=0.74u AS=0.13135p AD=0.18945p
+ PS=1.095u PD=1.27u
M$602 321 323 374 1 sg13_lv_nmos L=0.13u W=0.42u AS=0.1296p AD=0.0798p PS=1.52u
+ PD=0.8u
M$603 374 375 342 1 sg13_lv_nmos L=0.13u W=0.42u AS=0.0798p AD=0.2373p PS=0.8u
+ PD=1.97u
M$606 1 323 375 1 sg13_lv_nmos L=0.13u W=0.74u AS=0.317325p AD=0.2516p
+ PS=1.805u PD=2.16u
M$607 1 210 323 1 sg13_lv_nmos L=0.13u W=0.74u AS=0.317325p AD=0.2516p
+ PS=1.805u PD=2.16u
M$614 393 265 409 1 sg13_lv_nmos L=0.13u W=0.64u AS=0.2176p AD=0.1216p PS=1.96u
+ PD=1.02u
M$615 409 345 410 1 sg13_lv_nmos L=0.13u W=0.64u AS=0.1216p AD=0.1216p PS=1.02u
+ PD=1.02u
M$616 410 347 1 1 sg13_lv_nmos L=0.13u W=0.64u AS=0.1216p AD=0.1371p PS=1.02u
+ PD=1.12u
M$617 1 393 394 1 sg13_lv_nmos L=0.13u W=0.74u AS=0.1371p AD=0.2516p PS=1.12u
+ PD=2.16u
M$618 1 345 366 1 sg13_lv_nmos L=0.13u W=0.74u AS=0.2516p AD=0.1406p PS=2.16u
+ PD=1.12u
M$619 366 265 346 1 sg13_lv_nmos L=0.13u W=0.74u AS=0.1406p AD=0.1406p PS=1.12u
+ PD=1.12u
M$620 346 347 1 1 sg13_lv_nmos L=0.13u W=0.74u AS=0.1406p AD=0.2516p PS=1.12u
+ PD=2.16u
M$621 1 394 397 1 sg13_lv_nmos L=0.13u W=0.74u AS=0.2516p AD=0.1406p PS=2.16u
+ PD=1.12u
M$622 397 346 1 1 sg13_lv_nmos L=0.13u W=0.74u AS=0.1406p AD=0.2516p PS=1.12u
+ PD=2.16u
M$623 1 327 411 1 sg13_lv_nmos L=0.13u W=0.74u AS=0.2516p AD=0.1406p PS=2.16u
+ PD=1.12u
M$624 411 348 399 1 sg13_lv_nmos L=0.13u W=0.74u AS=0.1406p AD=0.1406p PS=1.12u
+ PD=1.12u
M$625 399 346 1 1 sg13_lv_nmos L=0.13u W=0.74u AS=0.1406p AD=0.2516p PS=1.12u
+ PD=2.16u
M$626 1 267 348 1 sg13_lv_nmos L=0.13u W=0.74u AS=0.2516p AD=0.1406p PS=2.16u
+ PD=1.12u
M$627 348 268 371 1 sg13_lv_nmos L=0.13u W=0.74u AS=0.1406p AD=0.1406p PS=1.12u
+ PD=1.12u
M$628 371 289 1 1 sg13_lv_nmos L=0.13u W=0.74u AS=0.1406p AD=0.2516p PS=1.12u
+ PD=2.16u
M$629 395 399 406 1 sg13_lv_nmos L=0.15u W=0.74u AS=0.2516p AD=0.1406p PS=2.16u
+ PD=1.12u
M$630 406 400 1 1 sg13_lv_nmos L=0.15u W=0.74u AS=0.1406p AD=0.1406p PS=1.12u
+ PD=1.12u
M$631 1 274 406 1 sg13_lv_nmos L=0.15u W=0.74u AS=0.1406p AD=0.2516p PS=1.12u
+ PD=2.16u
M$632 400 270 412 1 sg13_lv_nmos L=0.13u W=0.74u AS=0.2516p AD=0.1406p PS=2.16u
+ PD=1.12u
M$633 412 397 1 1 sg13_lv_nmos L=0.13u W=0.74u AS=0.1406p AD=0.2516p PS=1.12u
+ PD=2.16u
M$634 1 348 349 1 sg13_lv_nmos L=0.13u W=0.74u AS=0.2516p AD=0.1406p PS=2.16u
+ PD=1.12u
M$635 349 275 373 1 sg13_lv_nmos L=0.13u W=0.74u AS=0.1406p AD=0.1406p PS=1.12u
+ PD=1.12u
M$636 373 270 1 1 sg13_lv_nmos L=0.13u W=0.74u AS=0.1406p AD=0.2516p PS=1.12u
+ PD=2.16u
M$639 1 274 372 1 sg13_lv_nmos L=0.13u W=0.64u AS=0.2272p AD=0.0784p PS=1.99u
+ PD=0.885u
M$640 372 270 350 1 sg13_lv_nmos L=0.13u W=0.64u AS=0.0784p AD=0.2176p
+ PS=0.885u PD=1.96u
M$645 329 331 379 1 sg13_lv_nmos L=0.13u W=0.42u AS=0.1296p AD=0.0798p PS=1.52u
+ PD=0.8u
M$646 379 380 352 1 sg13_lv_nmos L=0.13u W=0.42u AS=0.0798p AD=0.2373p PS=0.8u
+ PD=1.97u
M$649 1 331 380 1 sg13_lv_nmos L=0.13u W=0.74u AS=0.317325p AD=0.2516p
+ PS=1.805u PD=2.16u
M$650 1 115 331 1 sg13_lv_nmos L=0.13u W=0.74u AS=0.317325p AD=0.2516p
+ PS=1.805u PD=2.16u
M$661 1 111 354 1 sg13_lv_nmos L=0.13u W=0.74u AS=0.2516p AD=0.2516p PS=2.16u
+ PD=2.16u
M$664 336 338 381 1 sg13_lv_nmos L=0.13u W=0.42u AS=0.1296p AD=0.0798p PS=1.52u
+ PD=0.8u
M$665 381 382 355 1 sg13_lv_nmos L=0.13u W=0.42u AS=0.0798p AD=0.2373p PS=0.8u
+ PD=1.97u
M$666 1 338 382 1 sg13_lv_nmos L=0.13u W=0.74u AS=0.317325p AD=0.2516p
+ PS=1.805u PD=2.16u
M$667 1 423 338 1 sg13_lv_nmos L=0.13u W=0.74u AS=0.317325p AD=0.2516p
+ PS=1.805u PD=2.16u
M$679 1 414 413 1 sg13_lv_nmos L=0.13u W=4.44u AS=0.9546p AD=0.8436p PS=7.76u
+ PD=6.72u
M$685 1 413 415 1 sg13_lv_nmos L=0.13u W=11.84u AS=2.2496p AD=2.3606p PS=17.92u
+ PD=18.96u
M$708 1 397 421 1 sg13_lv_nmos L=0.13u W=0.74u AS=0.1898p AD=0.2516p PS=1.36u
+ PD=2.16u
M$709 1 349 421 1 sg13_lv_nmos L=0.13u W=0.74u AS=0.1898p AD=0.1406p PS=1.36u
+ PD=1.12u
M$710 421 420 416 1 sg13_lv_nmos L=0.13u W=0.74u AS=0.1406p AD=0.2516p PS=1.12u
+ PD=2.16u
M$725 1 422 417 1 sg13_lv_nmos L=0.13u W=0.74u AS=0.2516p AD=0.1406p PS=2.16u
+ PD=1.12u
M$726 417 423 1 1 sg13_lv_nmos L=0.13u W=0.74u AS=0.1406p AD=0.2516p PS=1.12u
+ PD=2.16u
M$728 1 463 419 1 sg13_lv_nmos L=0.13u W=0.74u AS=0.2516p AD=0.2516p PS=2.16u
+ PD=2.16u
M$734 430 443 1 1 sg13_lv_nmos L=0.13u W=0.55u AS=0.187p AD=0.14875p PS=1.78u
+ PD=1.16u
M$735 1 430 107 1 sg13_lv_nmos L=0.13u W=0.74u AS=0.14875p AD=0.2886p PS=1.16u
+ PD=2.26u
M$736 1 107 432 1 sg13_lv_nmos L=0.13u W=0.55u AS=0.18945p AD=0.187p PS=1.27u
+ PD=1.78u
M$737 431 459 1 1 sg13_lv_nmos L=0.13u W=0.74u AS=0.4033p AD=0.148p PS=2.57u
+ PD=1.14u
M$738 1 432 467 1 sg13_lv_nmos L=0.13u W=0.74u AS=0.148p AD=0.3367p PS=1.14u
+ PD=1.65u
M$739 467 460 459 1 sg13_lv_nmos L=0.13u W=0.74u AS=0.3367p AD=0.1628p PS=1.65u
+ PD=1.18u
M$740 459 286 468 1 sg13_lv_nmos L=0.13u W=0.74u AS=0.1628p AD=0.13135p
+ PS=1.18u PD=1.095u
M$741 468 107 1 1 sg13_lv_nmos L=0.13u W=0.74u AS=0.13135p AD=0.18945p
+ PS=1.095u PD=1.27u
M$750 1 461 470 1 sg13_lv_nmos L=0.13u W=0.64u AS=0.2272p AD=0.0784p PS=1.99u
+ PD=0.885u
M$751 470 444 433 1 sg13_lv_nmos L=0.13u W=0.64u AS=0.0784p AD=0.2176p
+ PS=0.885u PD=1.96u
M$752 465 461 1 1 sg13_lv_nmos L=0.13u W=0.74u AS=0.2516p AD=0.1898p PS=2.16u
+ PD=1.36u
M$753 1 444 465 1 sg13_lv_nmos L=0.13u W=0.74u AS=0.1898p AD=0.1406p PS=1.36u
+ PD=1.12u
M$754 465 433 347 1 sg13_lv_nmos L=0.13u W=0.74u AS=0.1406p AD=0.2516p PS=1.12u
+ PD=2.16u
M$759 1 397 426 1 sg13_lv_nmos L=0.13u W=0.64u AS=0.2272p AD=0.0784p PS=1.99u
+ PD=0.885u
M$760 426 349 420 1 sg13_lv_nmos L=0.13u W=0.64u AS=0.0784p AD=0.2176p
+ PS=0.885u PD=1.96u
M$773 1 445 434 1 sg13_lv_nmos L=0.13u W=0.74u AS=0.2516p AD=0.1406p PS=2.16u
+ PD=1.12u
M$774 434 423 471 1 sg13_lv_nmos L=0.13u W=0.74u AS=0.1406p AD=0.1406p PS=1.12u
+ PD=1.12u
M$775 471 422 1 1 sg13_lv_nmos L=0.13u W=0.74u AS=0.1406p AD=0.2516p PS=1.12u
+ PD=2.16u
M$776 1 445 436 1 sg13_lv_nmos L=0.13u W=0.77u AS=0.2618p AD=0.1694p PS=2.22u
+ PD=1.21u
M$777 436 462 1 1 sg13_lv_nmos L=0.13u W=0.77u AS=0.1694p AD=0.1463p PS=1.21u
+ PD=1.15u
M$778 1 417 436 1 sg13_lv_nmos L=0.13u W=0.77u AS=0.1463p AD=0.2618p PS=1.15u
+ PD=2.22u
M$779 1 446 437 1 sg13_lv_nmos L=0.13u W=0.74u AS=0.2516p AD=0.1406p PS=2.16u
+ PD=1.12u
M$780 437 422 472 1 sg13_lv_nmos L=0.13u W=0.74u AS=0.1406p AD=0.1406p PS=1.12u
+ PD=1.12u
M$781 472 445 1 1 sg13_lv_nmos L=0.13u W=0.74u AS=0.1406p AD=0.2516p PS=1.12u
+ PD=2.16u
M$782 1 463 439 1 sg13_lv_nmos L=0.13u W=0.74u AS=0.2516p AD=0.2516p PS=2.16u
+ PD=2.16u
M$783 1 424 418 1 sg13_lv_nmos L=0.13u W=0.74u AS=0.2516p AD=0.1406p PS=2.16u
+ PD=1.12u
M$784 418 423 425 1 sg13_lv_nmos L=0.13u W=0.74u AS=0.1406p AD=0.1406p PS=1.12u
+ PD=1.12u
M$785 425 422 1 1 sg13_lv_nmos L=0.13u W=0.74u AS=0.1406p AD=0.2516p PS=1.12u
+ PD=2.16u
M$786 440 449 441 1 sg13_lv_nmos L=0.13u W=0.42u AS=0.1296p AD=0.0798p PS=1.52u
+ PD=0.8u
M$787 441 448 464 1 sg13_lv_nmos L=0.13u W=0.42u AS=0.0798p AD=0.2373p PS=0.8u
+ PD=1.97u
M$788 448 449 1 1 sg13_lv_nmos L=0.13u W=0.74u AS=0.2516p AD=0.317325p PS=2.16u
+ PD=1.805u
M$789 1 462 449 1 sg13_lv_nmos L=0.13u W=0.74u AS=0.317325p AD=0.2516p
+ PS=1.805u PD=2.16u
M$790 466 449 450 1 sg13_lv_nmos L=0.13u W=0.42u AS=0.1428p AD=0.12665p
+ PS=1.52u PD=1.145u
M$791 450 448 447 1 sg13_lv_nmos L=0.13u W=0.74u AS=0.12665p AD=0.3473p
+ PS=1.145u PD=2.71u
M$792 442 450 1 1 sg13_lv_nmos L=0.13u W=0.74u AS=0.2516p AD=0.1406p PS=2.16u
+ PD=1.12u
M$793 1 442 423 1 sg13_lv_nmos L=0.13u W=0.74u AS=0.1406p AD=0.2516p PS=1.12u
+ PD=2.16u
M$795 1 74 483 1 sg13_lv_nmos L=0.13u W=0.74u AS=0.2516p AD=0.2516p PS=2.16u
+ PD=2.16u
M$796 484 431 513 1 sg13_lv_nmos L=0.13u W=0.42u AS=0.1428p AD=0.0609p PS=1.52u
+ PD=0.71u
M$797 513 483 1 1 sg13_lv_nmos L=0.13u W=0.42u AS=0.0609p AD=0.1626p PS=0.71u
+ PD=1.415u
M$798 1 532 475 1 sg13_lv_nmos L=0.13u W=0.74u AS=0.1626p AD=0.2516p PS=1.415u
+ PD=2.16u
M$799 1 483 515 1 sg13_lv_nmos L=0.13u W=0.42u AS=0.1701p AD=0.0378p PS=1.65u
+ PD=0.6u
M$800 515 475 485 1 sg13_lv_nmos L=0.13u W=0.42u AS=0.0378p AD=0.1428p PS=0.6u
+ PD=1.52u
M$801 487 476 486 1 sg13_lv_nmos L=0.13u W=0.42u AS=0.12665p AD=0.1428p
+ PS=1.145u PD=1.52u
M$802 475 533 487 1 sg13_lv_nmos L=0.13u W=0.74u AS=0.3473p AD=0.12665p
+ PS=2.71u PD=1.145u
M$803 486 488 1 1 sg13_lv_nmos L=0.13u W=0.42u AS=0.1428p AD=0.0798p PS=1.52u
+ PD=0.8u
M$804 1 483 517 1 sg13_lv_nmos L=0.13u W=0.42u AS=0.0798p AD=0.0378p PS=0.8u
+ PD=0.6u
M$805 517 487 488 1 sg13_lv_nmos L=0.13u W=0.42u AS=0.0378p AD=0.1428p PS=0.6u
+ PD=1.52u
M$806 489 487 1 1 sg13_lv_nmos L=0.13u W=0.74u AS=0.2516p AD=0.1406p PS=2.16u
+ PD=1.12u
M$807 1 489 460 1 sg13_lv_nmos L=0.13u W=0.74u AS=0.1406p AD=0.2516p PS=1.12u
+ PD=2.16u
M$808 490 460 519 1 sg13_lv_nmos L=0.13u W=0.74u AS=0.2516p AD=0.1406p PS=2.16u
+ PD=1.12u
M$809 519 530 1 1 sg13_lv_nmos L=0.13u W=0.74u AS=0.1406p AD=0.2516p PS=1.12u
+ PD=2.16u
M$811 1 565 521 1 sg13_lv_nmos L=0.13u W=0.74u AS=0.2886p AD=0.1406p PS=2.26u
+ PD=1.12u
M$812 521 531 523 1 sg13_lv_nmos L=0.13u W=0.74u AS=0.1406p AD=0.1406p PS=1.12u
+ PD=1.12u
M$813 523 490 492 1 sg13_lv_nmos L=0.13u W=0.74u AS=0.1406p AD=0.2516p PS=1.12u
+ PD=2.16u
M$814 1 444 524 1 sg13_lv_nmos L=0.13u W=0.74u AS=0.2516p AD=0.1406p PS=2.16u
+ PD=1.12u
M$815 524 461 531 1 sg13_lv_nmos L=0.13u W=0.74u AS=0.1406p AD=0.2516p PS=1.12u
+ PD=2.16u
M$816 1 463 493 1 sg13_lv_nmos L=0.13u W=0.74u AS=0.2516p AD=0.2516p PS=2.16u
+ PD=2.16u
M$817 494 416 525 1 sg13_lv_nmos L=0.13u W=0.42u AS=0.1428p AD=0.0609p PS=1.52u
+ PD=0.71u
M$818 525 493 1 1 sg13_lv_nmos L=0.13u W=0.42u AS=0.0609p AD=0.1626p PS=0.71u
+ PD=1.415u
M$819 1 534 477 1 sg13_lv_nmos L=0.13u W=0.74u AS=0.1626p AD=0.2516p PS=1.415u
+ PD=2.16u
M$820 1 493 527 1 sg13_lv_nmos L=0.13u W=0.42u AS=0.1701p AD=0.0378p PS=1.65u
+ PD=0.6u
M$821 527 477 495 1 sg13_lv_nmos L=0.13u W=0.42u AS=0.0378p AD=0.1428p PS=0.6u
+ PD=1.52u
M$822 497 478 496 1 sg13_lv_nmos L=0.13u W=0.42u AS=0.12665p AD=0.1428p
+ PS=1.145u PD=1.52u
M$823 477 535 497 1 sg13_lv_nmos L=0.13u W=0.74u AS=0.3473p AD=0.12665p
+ PS=2.71u PD=1.145u
M$824 496 498 1 1 sg13_lv_nmos L=0.13u W=0.42u AS=0.1428p AD=0.0798p PS=1.52u
+ PD=0.8u
M$825 1 493 529 1 sg13_lv_nmos L=0.13u W=0.42u AS=0.0798p AD=0.0378p PS=0.8u
+ PD=0.6u
M$826 529 497 498 1 sg13_lv_nmos L=0.13u W=0.42u AS=0.0378p AD=0.1428p PS=0.6u
+ PD=1.52u
M$827 499 497 1 1 sg13_lv_nmos L=0.13u W=0.74u AS=0.2516p AD=0.1406p PS=2.16u
+ PD=1.12u
M$828 1 499 461 1 sg13_lv_nmos L=0.13u W=0.74u AS=0.1406p AD=0.2516p PS=1.12u
+ PD=2.16u
M$829 1 463 500 1 sg13_lv_nmos L=0.13u W=0.74u AS=0.2516p AD=0.2516p PS=2.16u
+ PD=2.16u
M$830 501 434 528 1 sg13_lv_nmos L=0.13u W=0.42u AS=0.1428p AD=0.0609p PS=1.52u
+ PD=0.71u
M$831 528 500 1 1 sg13_lv_nmos L=0.13u W=0.42u AS=0.0609p AD=0.1626p PS=0.71u
+ PD=1.415u
M$832 1 536 479 1 sg13_lv_nmos L=0.13u W=0.74u AS=0.1626p AD=0.2516p PS=1.415u
+ PD=2.16u
M$833 1 500 526 1 sg13_lv_nmos L=0.13u W=0.42u AS=0.1701p AD=0.0378p PS=1.65u
+ PD=0.6u
M$834 526 479 502 1 sg13_lv_nmos L=0.13u W=0.42u AS=0.0378p AD=0.1428p PS=0.6u
+ PD=1.52u
M$836 504 480 503 1 sg13_lv_nmos L=0.13u W=0.42u AS=0.12665p AD=0.1428p
+ PS=1.145u PD=1.52u
M$837 479 537 504 1 sg13_lv_nmos L=0.13u W=0.74u AS=0.3473p AD=0.12665p
+ PS=2.71u PD=1.145u
M$838 503 505 1 1 sg13_lv_nmos L=0.13u W=0.42u AS=0.1428p AD=0.0798p PS=1.52u
+ PD=0.8u
M$839 1 500 522 1 sg13_lv_nmos L=0.13u W=0.42u AS=0.0798p AD=0.0378p PS=0.8u
+ PD=0.6u
M$840 522 504 505 1 sg13_lv_nmos L=0.13u W=0.42u AS=0.0378p AD=0.1428p PS=0.6u
+ PD=1.52u
M$841 506 504 1 1 sg13_lv_nmos L=0.13u W=0.74u AS=0.2516p AD=0.1406p PS=2.16u
+ PD=1.12u
M$842 1 506 445 1 sg13_lv_nmos L=0.13u W=0.74u AS=0.1406p AD=0.2516p PS=1.12u
+ PD=2.16u
M$843 507 437 518 1 sg13_lv_nmos L=0.13u W=0.42u AS=0.1428p AD=0.0609p PS=1.52u
+ PD=0.71u
M$844 518 439 1 1 sg13_lv_nmos L=0.13u W=0.42u AS=0.0609p AD=0.1626p PS=0.71u
+ PD=1.415u
M$845 1 538 481 1 sg13_lv_nmos L=0.13u W=0.74u AS=0.1626p AD=0.2516p PS=1.415u
+ PD=2.16u
M$846 1 441 447 1 sg13_lv_nmos L=0.13u W=0.74u AS=0.1626p AD=0.2516p PS=1.415u
+ PD=2.16u
M$847 440 418 473 1 sg13_lv_nmos L=0.13u W=0.42u AS=0.1428p AD=0.0609p PS=1.52u
+ PD=0.71u
M$848 1 419 473 1 sg13_lv_nmos L=0.13u W=0.42u AS=0.1626p AD=0.0609p PS=1.415u
+ PD=0.71u
M$849 1 439 516 1 sg13_lv_nmos L=0.13u W=0.42u AS=0.1701p AD=0.0378p PS=1.65u
+ PD=0.6u
M$850 516 481 508 1 sg13_lv_nmos L=0.13u W=0.42u AS=0.0378p AD=0.1428p PS=0.6u
+ PD=1.52u
M$851 1 419 474 1 sg13_lv_nmos L=0.13u W=0.42u AS=0.1701p AD=0.0378p PS=1.65u
+ PD=0.6u
M$852 474 447 464 1 sg13_lv_nmos L=0.13u W=0.42u AS=0.0378p AD=0.1428p PS=0.6u
+ PD=1.52u
M$853 510 482 509 1 sg13_lv_nmos L=0.13u W=0.42u AS=0.12665p AD=0.1428p
+ PS=1.145u PD=1.52u
M$854 481 539 510 1 sg13_lv_nmos L=0.13u W=0.74u AS=0.3473p AD=0.12665p
+ PS=2.71u PD=1.145u
M$855 509 511 1 1 sg13_lv_nmos L=0.13u W=0.42u AS=0.1428p AD=0.0798p PS=1.52u
+ PD=0.8u
M$856 1 439 514 1 sg13_lv_nmos L=0.13u W=0.42u AS=0.0798p AD=0.0378p PS=0.8u
+ PD=0.6u
M$857 514 510 511 1 sg13_lv_nmos L=0.13u W=0.42u AS=0.0378p AD=0.1428p PS=0.6u
+ PD=1.52u
M$858 466 451 1 1 sg13_lv_nmos L=0.13u W=0.42u AS=0.1428p AD=0.0798p PS=1.52u
+ PD=0.8u
M$859 1 419 469 1 sg13_lv_nmos L=0.13u W=0.42u AS=0.0798p AD=0.0378p PS=0.8u
+ PD=0.6u
M$860 469 450 451 1 sg13_lv_nmos L=0.13u W=0.42u AS=0.0378p AD=0.1428p PS=0.6u
+ PD=1.52u
M$861 512 510 1 1 sg13_lv_nmos L=0.13u W=0.74u AS=0.2516p AD=0.1406p PS=2.16u
+ PD=1.12u
M$862 1 512 422 1 sg13_lv_nmos L=0.13u W=0.74u AS=0.1406p AD=0.2516p PS=1.12u
+ PD=2.16u
M$864 551 74 1 1 sg13_lv_nmos L=0.13u W=0.74u AS=0.2516p AD=0.2516p PS=2.16u
+ PD=2.16u
M$865 553 573 555 1 sg13_lv_nmos L=0.13u W=0.42u AS=0.1296p AD=0.0798p PS=1.52u
+ PD=0.8u
M$866 555 556 572 1 sg13_lv_nmos L=0.13u W=0.42u AS=0.0798p AD=0.2373p PS=0.8u
+ PD=1.97u
M$867 484 476 532 1 sg13_lv_nmos L=0.13u W=0.42u AS=0.1296p AD=0.0798p PS=1.52u
+ PD=0.8u
M$868 532 533 485 1 sg13_lv_nmos L=0.13u W=0.42u AS=0.0798p AD=0.2373p PS=0.8u
+ PD=1.97u
M$869 556 573 1 1 sg13_lv_nmos L=0.13u W=0.74u AS=0.2516p AD=0.317325p PS=2.16u
+ PD=1.805u
M$870 1 597 573 1 sg13_lv_nmos L=0.13u W=0.74u AS=0.317325p AD=0.2516p
+ PS=1.805u PD=2.16u
M$871 1 476 533 1 sg13_lv_nmos L=0.13u W=0.74u AS=0.317325p AD=0.2516p
+ PS=1.805u PD=2.16u
M$872 1 597 476 1 sg13_lv_nmos L=0.13u W=0.74u AS=0.317325p AD=0.2516p
+ PS=1.805u PD=2.16u
M$873 581 573 557 1 sg13_lv_nmos L=0.13u W=0.42u AS=0.1428p AD=0.12665p
+ PS=1.52u PD=1.145u
M$874 557 556 554 1 sg13_lv_nmos L=0.13u W=0.74u AS=0.12665p AD=0.3473p
+ PS=1.145u PD=2.71u
M$875 1 560 561 1 sg13_lv_nmos L=0.13u W=0.55u AS=0.374p AD=0.174625p PS=2.46u
+ PD=1.185u
M$876 561 530 1 1 sg13_lv_nmos L=0.13u W=0.55u AS=0.174625p AD=0.15245p
+ PS=1.185u PD=1.17u
M$877 1 560 589 1 sg13_lv_nmos L=0.13u W=0.74u AS=0.15245p AD=0.0888p PS=1.17u
+ PD=0.98u
M$878 589 530 563 1 sg13_lv_nmos L=0.13u W=0.74u AS=0.0888p AD=0.1628p PS=0.98u
+ PD=1.18u
M$879 563 561 1 1 sg13_lv_nmos L=0.13u W=0.74u AS=0.1628p AD=0.3108p PS=1.18u
+ PD=2.32u
M$880 1 460 491 1 sg13_lv_nmos L=0.13u W=0.55u AS=0.374p AD=0.174625p PS=2.46u
+ PD=1.185u
M$881 1 530 491 1 sg13_lv_nmos L=0.13u W=0.55u AS=0.15245p AD=0.174625p
+ PS=1.17u PD=1.185u
M$882 1 460 520 1 sg13_lv_nmos L=0.13u W=0.74u AS=0.15245p AD=0.0888p PS=1.17u
+ PD=0.98u
M$883 520 530 444 1 sg13_lv_nmos L=0.13u W=0.74u AS=0.0888p AD=0.1628p PS=0.98u
+ PD=1.18u
M$884 444 491 1 1 sg13_lv_nmos L=0.13u W=0.74u AS=0.1628p AD=0.3108p PS=1.18u
+ PD=2.32u
M$886 1 574 585 1 sg13_lv_nmos L=0.13u W=0.64u AS=0.2272p AD=0.0784p PS=1.99u
+ PD=0.885u
M$887 585 563 564 1 sg13_lv_nmos L=0.13u W=0.64u AS=0.0784p AD=0.2176p
+ PS=0.885u PD=1.96u
M$888 582 574 1 1 sg13_lv_nmos L=0.13u W=0.74u AS=0.2516p AD=0.1898p PS=2.16u
+ PD=1.36u
M$889 1 563 582 1 sg13_lv_nmos L=0.13u W=0.74u AS=0.1898p AD=0.1406p PS=1.36u
+ PD=1.12u
M$890 582 564 565 1 sg13_lv_nmos L=0.13u W=0.74u AS=0.1406p AD=0.2516p PS=1.12u
+ PD=2.16u
M$891 1 565 566 1 sg13_lv_nmos L=0.13u W=0.74u AS=0.2516p AD=0.1406p PS=2.16u
+ PD=1.12u
M$892 566 490 590 1 sg13_lv_nmos L=0.13u W=0.74u AS=0.1406p AD=0.1406p PS=1.12u
+ PD=1.12u
M$893 590 531 1 1 sg13_lv_nmos L=0.13u W=0.74u AS=0.1406p AD=0.2516p PS=1.12u
+ PD=2.16u
M$898 494 478 534 1 sg13_lv_nmos L=0.13u W=0.42u AS=0.1296p AD=0.0798p PS=1.52u
+ PD=0.8u
M$899 534 535 495 1 sg13_lv_nmos L=0.13u W=0.42u AS=0.0798p AD=0.2373p PS=0.8u
+ PD=1.97u
M$900 1 478 535 1 sg13_lv_nmos L=0.13u W=0.74u AS=0.317325p AD=0.2516p
+ PS=1.805u PD=2.16u
M$901 1 115 478 1 sg13_lv_nmos L=0.13u W=0.74u AS=0.317325p AD=0.2516p
+ PS=1.805u PD=2.16u
M$902 501 480 536 1 sg13_lv_nmos L=0.13u W=0.42u AS=0.1296p AD=0.0798p PS=1.52u
+ PD=0.8u
M$903 536 537 502 1 sg13_lv_nmos L=0.13u W=0.42u AS=0.0798p AD=0.2373p PS=0.8u
+ PD=1.97u
M$904 1 480 537 1 sg13_lv_nmos L=0.13u W=0.74u AS=0.317325p AD=0.2516p
+ PS=1.805u PD=2.16u
M$905 1 462 480 1 sg13_lv_nmos L=0.13u W=0.74u AS=0.317325p AD=0.2516p
+ PS=1.805u PD=2.16u
M$906 575 423 592 1 sg13_lv_nmos L=0.13u W=0.74u AS=0.2516p AD=0.1406p PS=2.16u
+ PD=1.12u
M$907 592 422 1 1 sg13_lv_nmos L=0.13u W=0.74u AS=0.1406p AD=0.2516p PS=1.12u
+ PD=2.16u
M$908 1 445 591 1 sg13_lv_nmos L=0.13u W=0.74u AS=0.2516p AD=0.1406p PS=2.16u
+ PD=1.12u
M$909 591 422 424 1 sg13_lv_nmos L=0.13u W=0.74u AS=0.1406p AD=0.1406p PS=1.12u
+ PD=1.12u
M$910 424 423 1 1 sg13_lv_nmos L=0.13u W=0.74u AS=0.1406p AD=0.2516p PS=1.12u
+ PD=2.16u
M$911 507 482 538 1 sg13_lv_nmos L=0.13u W=0.42u AS=0.1296p AD=0.0798p PS=1.52u
+ PD=0.8u
M$912 538 539 508 1 sg13_lv_nmos L=0.13u W=0.42u AS=0.0798p AD=0.2373p PS=0.8u
+ PD=1.97u
M$913 1 482 539 1 sg13_lv_nmos L=0.13u W=0.74u AS=0.317325p AD=0.2516p
+ PS=1.805u PD=2.16u
M$914 1 462 482 1 sg13_lv_nmos L=0.13u W=0.74u AS=0.317325p AD=0.2516p
+ PS=1.805u PD=2.16u
M$915 1 570 552 1 sg13_lv_nmos L=0.13u W=0.55u AS=0.14875p AD=0.187p PS=1.16u
+ PD=1.78u
M$916 74 552 1 1 sg13_lv_nmos L=0.13u W=0.74u AS=0.2886p AD=0.14875p PS=2.26u
+ PD=1.16u
M$917 559 557 1 1 sg13_lv_nmos L=0.13u W=0.74u AS=0.2516p AD=0.1406p PS=2.16u
+ PD=1.12u
M$918 1 559 560 1 sg13_lv_nmos L=0.13u W=0.74u AS=0.1406p AD=0.2516p PS=1.12u
+ PD=2.16u
M$935 583 530 1 1 sg13_lv_nmos L=0.15u W=0.74u AS=0.2516p AD=0.1406p PS=2.16u
+ PD=1.12u
M$936 1 575 583 1 sg13_lv_nmos L=0.15u W=0.74u AS=0.1406p AD=0.1406p PS=1.12u
+ PD=1.12u
M$937 583 436 550 1 sg13_lv_nmos L=0.15u W=0.74u AS=0.1406p AD=0.2516p PS=1.12u
+ PD=2.16u
M$938 584 422 1 1 sg13_lv_nmos L=0.15u W=0.74u AS=0.2516p AD=0.1406p PS=2.16u
+ PD=1.12u
M$939 1 445 584 1 sg13_lv_nmos L=0.15u W=0.74u AS=0.1406p AD=0.1406p PS=1.12u
+ PD=1.12u
M$940 584 575 446 1 sg13_lv_nmos L=0.15u W=0.74u AS=0.1406p AD=0.2516p PS=1.12u
+ PD=2.16u
M$949 1 555 554 1 sg13_lv_nmos L=0.13u W=0.74u AS=0.1626p AD=0.2516p PS=1.415u
+ PD=2.16u
M$950 553 571 586 1 sg13_lv_nmos L=0.13u W=0.42u AS=0.1428p AD=0.0609p PS=1.52u
+ PD=0.71u
M$951 1 551 586 1 sg13_lv_nmos L=0.13u W=0.42u AS=0.1626p AD=0.0609p PS=1.415u
+ PD=0.71u
M$952 571 593 1 1 sg13_lv_nmos L=0.13u W=0.74u AS=0.4033p AD=0.148p PS=2.57u
+ PD=1.14u
M$953 1 615 617 1 sg13_lv_nmos L=0.13u W=0.74u AS=0.148p AD=0.3367p PS=1.14u
+ PD=1.65u
M$954 617 560 593 1 sg13_lv_nmos L=0.13u W=0.74u AS=0.3367p AD=0.1628p PS=1.65u
+ PD=1.18u
M$955 593 460 618 1 sg13_lv_nmos L=0.13u W=0.74u AS=0.1628p AD=0.13135p
+ PS=1.18u PD=1.095u
M$956 618 107 1 1 sg13_lv_nmos L=0.13u W=0.74u AS=0.13135p AD=0.18945p
+ PS=1.095u PD=1.27u
M$957 1 107 615 1 sg13_lv_nmos L=0.13u W=0.55u AS=0.18945p AD=0.187p PS=1.27u
+ PD=1.78u
M$958 1 551 587 1 sg13_lv_nmos L=0.13u W=0.42u AS=0.1701p AD=0.0378p PS=1.65u
+ PD=0.6u
M$959 587 554 572 1 sg13_lv_nmos L=0.13u W=0.42u AS=0.0378p AD=0.1428p PS=0.6u
+ PD=1.52u
M$960 596 597 1 1 sg13_lv_nmos L=0.13u W=0.74u AS=0.2516p AD=0.2516p PS=2.16u
+ PD=2.16u
M$961 1 598 597 1 sg13_lv_nmos L=0.13u W=11.84u AS=2.3606p AD=2.2496p PS=18.96u
+ PD=17.92u
M$977 1 415 598 1 sg13_lv_nmos L=0.13u W=4.44u AS=0.8436p AD=0.9546p PS=6.72u
+ PD=7.76u
M$983 581 558 1 1 sg13_lv_nmos L=0.13u W=0.42u AS=0.1428p AD=0.0798p PS=1.52u
+ PD=0.8u
M$984 1 551 588 1 sg13_lv_nmos L=0.13u W=0.42u AS=0.0798p AD=0.0378p PS=0.8u
+ PD=0.6u
M$985 588 557 558 1 sg13_lv_nmos L=0.13u W=0.42u AS=0.0378p AD=0.1428p PS=0.6u
+ PD=1.52u
M$987 1 563 619 1 sg13_lv_nmos L=0.13u W=0.74u AS=0.2516p AD=0.1406p PS=2.16u
+ PD=1.12u
M$988 619 574 599 1 sg13_lv_nmos L=0.13u W=0.74u AS=0.1406p AD=0.2516p PS=1.12u
+ PD=2.16u
M$990 1 492 600 1 sg13_lv_nmos L=0.13u W=0.55u AS=0.17255p AD=0.187p PS=1.25u
+ PD=1.78u
M$991 1 600 601 1 sg13_lv_nmos L=0.13u W=0.74u AS=0.17255p AD=0.1406p PS=1.25u
+ PD=1.12u
M$992 601 566 1 1 sg13_lv_nmos L=0.13u W=0.74u AS=0.1406p AD=0.2516p PS=1.12u
+ PD=2.16u
M$994 1 395 602 1 sg13_lv_nmos L=0.13u W=0.55u AS=0.374p AD=0.174625p PS=2.46u
+ PD=1.185u
M$995 1 601 602 1 sg13_lv_nmos L=0.13u W=0.55u AS=0.15245p AD=0.174625p
+ PS=1.17u PD=1.185u
M$996 1 395 620 1 sg13_lv_nmos L=0.13u W=0.74u AS=0.15245p AD=0.0888p PS=1.17u
+ PD=0.98u
M$997 620 601 603 1 sg13_lv_nmos L=0.13u W=0.74u AS=0.0888p AD=0.1628p PS=0.98u
+ PD=1.18u
M$998 603 602 1 1 sg13_lv_nmos L=0.13u W=0.74u AS=0.1628p AD=0.3108p PS=1.18u
+ PD=2.32u
M$999 1 463 604 1 sg13_lv_nmos L=0.13u W=0.74u AS=0.2516p AD=0.2516p PS=2.16u
+ PD=2.16u
M$1000 605 603 614 1 sg13_lv_nmos L=0.13u W=0.42u AS=0.1428p AD=0.0609p
+ PS=1.52u PD=0.71u
M$1001 614 604 1 1 sg13_lv_nmos L=0.13u W=0.42u AS=0.0609p AD=0.1626p PS=0.71u
+ PD=1.415u
M$1002 1 616 594 1 sg13_lv_nmos L=0.13u W=0.74u AS=0.1626p AD=0.2516p PS=1.415u
+ PD=2.16u
M$1003 1 604 613 1 sg13_lv_nmos L=0.13u W=0.42u AS=0.1701p AD=0.0378p PS=1.65u
+ PD=0.6u
M$1004 613 594 606 1 sg13_lv_nmos L=0.13u W=0.42u AS=0.0378p AD=0.1428p PS=0.6u
+ PD=1.52u
M$1005 608 595 607 1 sg13_lv_nmos L=0.13u W=0.42u AS=0.12665p AD=0.1428p
+ PS=1.145u PD=1.52u
M$1006 594 621 608 1 sg13_lv_nmos L=0.13u W=0.74u AS=0.3473p AD=0.12665p
+ PS=2.71u PD=1.145u
M$1007 607 609 1 1 sg13_lv_nmos L=0.13u W=0.42u AS=0.1428p AD=0.0798p PS=1.52u
+ PD=0.8u
M$1008 1 604 612 1 sg13_lv_nmos L=0.13u W=0.42u AS=0.0798p AD=0.0378p PS=0.8u
+ PD=0.6u
M$1009 612 608 609 1 sg13_lv_nmos L=0.13u W=0.42u AS=0.0378p AD=0.1428p PS=0.6u
+ PD=1.52u
M$1010 610 608 1 1 sg13_lv_nmos L=0.13u W=0.74u AS=0.2516p AD=0.1406p PS=2.16u
+ PD=1.12u
M$1011 1 610 574 1 sg13_lv_nmos L=0.13u W=0.74u AS=0.1406p AD=0.2516p PS=1.12u
+ PD=2.16u
M$1017 530 611 1 1 sg13_lv_nmos L=0.13u W=0.74u AS=0.2886p AD=0.14875p PS=2.26u
+ PD=1.16u
M$1018 1 719 611 1 sg13_lv_nmos L=0.13u W=0.55u AS=0.14875p AD=0.187p PS=1.16u
+ PD=1.78u
M$1049 1 566 629 1 sg13_lv_nmos L=0.13u W=0.74u AS=0.2516p AD=0.1406p PS=2.16u
+ PD=1.12u
M$1050 629 395 631 1 sg13_lv_nmos L=0.13u W=0.74u AS=0.1406p AD=0.1406p
+ PS=1.12u PD=1.12u
M$1051 631 601 1 1 sg13_lv_nmos L=0.13u W=0.74u AS=0.1406p AD=0.2516p PS=1.12u
+ PD=2.16u
M$1058 605 595 616 1 sg13_lv_nmos L=0.13u W=0.42u AS=0.1296p AD=0.0798p
+ PS=1.52u PD=0.8u
M$1059 616 621 606 1 sg13_lv_nmos L=0.13u W=0.42u AS=0.0798p AD=0.2373p PS=0.8u
+ PD=1.97u
M$1062 1 595 621 1 sg13_lv_nmos L=0.13u W=0.74u AS=0.317325p AD=0.2516p
+ PS=1.805u PD=2.16u
M$1063 1 247 595 1 sg13_lv_nmos L=0.13u W=0.74u AS=0.317325p AD=0.2516p
+ PS=1.805u PD=2.16u
M$1076 640 638 660 1 sg13_lv_nmos L=0.13u W=0.42u AS=0.1428p AD=0.0609p
+ PS=1.52u PD=0.71u
M$1077 660 639 1 1 sg13_lv_nmos L=0.13u W=0.42u AS=0.0609p AD=0.1626p PS=0.71u
+ PD=1.415u
M$1078 1 671 641 1 sg13_lv_nmos L=0.13u W=0.74u AS=0.1626p AD=0.2516p PS=1.415u
+ PD=2.16u
M$1083 643 644 1 1 sg13_lv_nmos L=0.13u W=0.42u AS=0.1428p AD=0.0798p PS=1.52u
+ PD=0.8u
M$1084 1 639 657 1 sg13_lv_nmos L=0.13u W=0.42u AS=0.0798p AD=0.0378p PS=0.8u
+ PD=0.6u
M$1085 657 654 644 1 sg13_lv_nmos L=0.13u W=0.42u AS=0.0378p AD=0.1428p PS=0.6u
+ PD=1.52u
M$1088 645 654 1 1 sg13_lv_nmos L=0.13u W=0.74u AS=0.2516p AD=0.1406p PS=2.16u
+ PD=1.12u
M$1089 1 645 462 1 sg13_lv_nmos L=0.13u W=0.74u AS=0.1406p AD=0.2516p PS=1.12u
+ PD=2.16u
M$1092 632 633 1 1 sg13_lv_nmos L=0.13u W=0.74u AS=0.4033p AD=0.148p PS=2.57u
+ PD=1.14u
M$1093 1 668 656 1 sg13_lv_nmos L=0.13u W=0.74u AS=0.148p AD=0.3367p PS=1.14u
+ PD=1.65u
M$1094 656 669 633 1 sg13_lv_nmos L=0.13u W=0.74u AS=0.3367p AD=0.1628p
+ PS=1.65u PD=1.18u
M$1095 633 560 655 1 sg13_lv_nmos L=0.13u W=0.74u AS=0.1628p AD=0.13135p
+ PS=1.18u PD=1.095u
M$1096 655 107 1 1 sg13_lv_nmos L=0.13u W=0.74u AS=0.13135p AD=0.18945p
+ PS=1.095u PD=1.27u
M$1097 1 107 668 1 sg13_lv_nmos L=0.13u W=0.55u AS=0.18945p AD=0.187p PS=1.27u
+ PD=1.78u
M$1098 634 560 659 1 sg13_lv_nmos L=0.13u W=0.74u AS=0.2516p AD=0.1406p
+ PS=2.16u PD=1.12u
M$1099 659 530 1 1 sg13_lv_nmos L=0.13u W=0.74u AS=0.1406p AD=0.2516p PS=1.12u
+ PD=2.16u
M$1100 1 635 647 1 sg13_lv_nmos L=0.13u W=0.55u AS=0.17255p AD=0.187p PS=1.25u
+ PD=1.78u
M$1101 1 647 636 1 sg13_lv_nmos L=0.13u W=0.74u AS=0.17255p AD=0.1406p PS=1.25u
+ PD=1.12u
M$1102 636 646 1 1 sg13_lv_nmos L=0.13u W=0.74u AS=0.1406p AD=0.2516p PS=1.12u
+ PD=2.16u
M$1103 1 463 637 1 sg13_lv_nmos L=0.13u W=0.74u AS=0.2516p AD=0.2516p PS=2.16u
+ PD=2.16u
M$1104 1 111 639 1 sg13_lv_nmos L=0.13u W=0.74u AS=0.2516p AD=0.2516p PS=2.16u
+ PD=2.16u
M$1112 1 670 662 1 sg13_lv_nmos L=0.13u W=0.74u AS=0.2886p AD=0.1406p PS=2.26u
+ PD=1.12u
M$1113 662 599 663 1 sg13_lv_nmos L=0.13u W=0.74u AS=0.1406p AD=0.1406p
+ PS=1.12u PD=1.12u
M$1114 663 634 635 1 sg13_lv_nmos L=0.13u W=0.74u AS=0.1406p AD=0.2516p
+ PS=1.12u PD=2.16u
M$1129 1 639 658 1 sg13_lv_nmos L=0.13u W=0.42u AS=0.1701p AD=0.0378p PS=1.65u
+ PD=0.6u
M$1130 658 641 653 1 sg13_lv_nmos L=0.13u W=0.42u AS=0.0378p AD=0.1428p PS=0.6u
+ PD=1.52u
M$1131 654 642 643 1 sg13_lv_nmos L=0.13u W=0.42u AS=0.12665p AD=0.1428p
+ PS=1.145u PD=1.52u
M$1132 641 673 654 1 sg13_lv_nmos L=0.13u W=0.74u AS=0.3473p AD=0.12665p
+ PS=2.71u PD=1.145u
M$1134 1 715 685 1 sg13_lv_nmos L=0.13u W=0.74u AS=0.2516p AD=0.2516p PS=2.16u
+ PD=2.16u
M$1135 681 716 687 1 sg13_lv_nmos L=0.13u W=0.42u AS=0.1296p AD=0.0798p
+ PS=1.52u PD=0.8u
M$1136 687 688 736 1 sg13_lv_nmos L=0.13u W=0.42u AS=0.0798p AD=0.2373p PS=0.8u
+ PD=1.97u
M$1137 688 716 1 1 sg13_lv_nmos L=0.13u W=0.74u AS=0.2516p AD=0.317325p
+ PS=2.16u PD=1.805u
M$1138 1 597 716 1 sg13_lv_nmos L=0.13u W=0.74u AS=0.317325p AD=0.2516p
+ PS=1.805u PD=2.16u
M$1139 737 716 717 1 sg13_lv_nmos L=0.13u W=0.42u AS=0.1428p AD=0.12665p
+ PS=1.52u PD=1.145u
M$1140 717 688 686 1 sg13_lv_nmos L=0.13u W=0.74u AS=0.12665p AD=0.3473p
+ PS=1.145u PD=2.71u
M$1141 691 669 1 1 sg13_lv_nmos L=0.13u W=0.55u AS=0.187p AD=0.17255p PS=1.78u
+ PD=1.25u
M$1142 1 691 692 1 sg13_lv_nmos L=0.13u W=0.74u AS=0.17255p AD=0.1406p PS=1.25u
+ PD=1.12u
M$1143 692 719 1 1 sg13_lv_nmos L=0.13u W=0.74u AS=0.1406p AD=0.2516p PS=1.12u
+ PD=2.16u
M$1144 1 692 693 1 sg13_lv_nmos L=0.13u W=0.74u AS=0.2516p AD=0.1406p PS=2.16u
+ PD=1.12u
M$1145 693 720 748 1 sg13_lv_nmos L=0.13u W=0.74u AS=0.1406p AD=0.1406p
+ PS=1.12u PD=1.12u
M$1146 748 721 1 1 sg13_lv_nmos L=0.13u W=0.74u AS=0.1406p AD=0.2516p PS=1.12u
+ PD=2.16u
M$1147 1 599 661 1 sg13_lv_nmos L=0.13u W=0.74u AS=0.2516p AD=0.1406p PS=2.16u
+ PD=1.12u
M$1148 661 634 646 1 sg13_lv_nmos L=0.13u W=0.74u AS=0.1406p AD=0.1406p
+ PS=1.12u PD=1.12u
M$1149 646 670 1 1 sg13_lv_nmos L=0.13u W=0.74u AS=0.1406p AD=0.2516p PS=1.12u
+ PD=2.16u
M$1150 1 635 665 1 sg13_lv_nmos L=0.13u W=0.74u AS=0.2516p AD=0.1406p PS=2.16u
+ PD=1.12u
M$1151 665 566 648 1 sg13_lv_nmos L=0.13u W=0.74u AS=0.1406p AD=0.2516p
+ PS=1.12u PD=2.16u
M$1152 1 636 750 1 sg13_lv_nmos L=0.13u W=0.64u AS=0.2272p AD=0.0784p PS=1.99u
+ PD=0.885u
M$1153 750 629 695 1 sg13_lv_nmos L=0.13u W=0.64u AS=0.0784p AD=0.2176p
+ PS=0.885u PD=1.96u
M$1154 648 649 666 1 sg13_lv_nmos L=0.13u W=0.74u AS=0.2516p AD=0.1406p
+ PS=2.16u PD=1.12u
M$1155 666 395 1 1 sg13_lv_nmos L=0.13u W=0.74u AS=0.1406p AD=0.1406p PS=1.12u
+ PD=1.12u
M$1156 1 646 648 1 sg13_lv_nmos L=0.13u W=0.74u AS=0.1406p AD=0.2516p PS=1.12u
+ PD=2.16u
M$1157 738 636 1 1 sg13_lv_nmos L=0.13u W=0.74u AS=0.2516p AD=0.1898p PS=2.16u
+ PD=1.36u
M$1158 1 629 738 1 sg13_lv_nmos L=0.13u W=0.74u AS=0.1898p AD=0.1406p PS=1.36u
+ PD=1.12u
M$1159 738 695 696 1 sg13_lv_nmos L=0.13u W=0.74u AS=0.1406p AD=0.2516p
+ PS=1.12u PD=2.16u
M$1160 649 650 1 1 sg13_lv_nmos L=0.13u W=0.74u AS=0.2516p AD=0.1331p PS=2.16u
+ PD=1.12u
M$1161 1 636 667 1 sg13_lv_nmos L=0.13u W=0.64u AS=0.1331p AD=0.1216p PS=1.12u
+ PD=1.02u
M$1162 667 601 650 1 sg13_lv_nmos L=0.13u W=0.64u AS=0.1216p AD=0.2176p
+ PS=1.02u PD=1.96u
M$1163 682 722 698 1 sg13_lv_nmos L=0.13u W=0.42u AS=0.1296p AD=0.0798p
+ PS=1.52u PD=0.8u
M$1164 698 699 739 1 sg13_lv_nmos L=0.13u W=0.42u AS=0.0798p AD=0.2373p PS=0.8u
+ PD=1.97u
M$1165 699 722 1 1 sg13_lv_nmos L=0.13u W=0.74u AS=0.2516p AD=0.317325p
+ PS=2.16u PD=1.805u
M$1166 1 247 722 1 sg13_lv_nmos L=0.13u W=0.74u AS=0.317325p AD=0.2516p
+ PS=1.805u PD=2.16u
M$1167 740 722 723 1 sg13_lv_nmos L=0.13u W=0.42u AS=0.1428p AD=0.12665p
+ PS=1.52u PD=1.145u
M$1168 723 699 697 1 sg13_lv_nmos L=0.13u W=0.74u AS=0.12665p AD=0.3473p
+ PS=1.145u PD=2.71u
M$1169 701 725 1 1 sg13_lv_nmos L=0.13u W=0.74u AS=0.2516p AD=0.2516p PS=2.16u
+ PD=2.16u
M$1170 1 463 702 1 sg13_lv_nmos L=0.13u W=0.74u AS=0.2516p AD=0.2516p PS=2.16u
+ PD=2.16u
M$1171 703 726 1 1 sg13_lv_nmos L=0.13u W=0.74u AS=0.2516p AD=0.2516p PS=2.16u
+ PD=2.16u
M$1172 651 652 1 1 sg13_lv_nmos L=0.13u W=0.74u AS=0.2516p AD=0.1331p PS=2.16u
+ PD=1.12u
M$1173 1 550 664 1 sg13_lv_nmos L=0.13u W=0.64u AS=0.1331p AD=0.1216p PS=1.12u
+ PD=1.02u
M$1174 664 638 652 1 sg13_lv_nmos L=0.13u W=0.64u AS=0.1216p AD=0.2176p
+ PS=1.02u PD=1.96u
M$1175 684 727 705 1 sg13_lv_nmos L=0.13u W=0.42u AS=0.1296p AD=0.0798p
+ PS=1.52u PD=0.8u
M$1176 705 706 741 1 sg13_lv_nmos L=0.13u W=0.42u AS=0.0798p AD=0.2373p PS=0.8u
+ PD=1.97u
M$1177 706 727 1 1 sg13_lv_nmos L=0.13u W=0.74u AS=0.2516p AD=0.317325p
+ PS=2.16u PD=1.805u
M$1178 1 726 727 1 sg13_lv_nmos L=0.13u W=0.74u AS=0.317325p AD=0.2516p
+ PS=1.805u PD=2.16u
M$1179 742 727 728 1 sg13_lv_nmos L=0.13u W=0.42u AS=0.1428p AD=0.12665p
+ PS=1.52u PD=1.145u
M$1180 728 706 704 1 sg13_lv_nmos L=0.13u W=0.74u AS=0.12665p AD=0.3473p
+ PS=1.145u PD=2.71u
M$1181 640 642 671 1 sg13_lv_nmos L=0.13u W=0.42u AS=0.1296p AD=0.0798p
+ PS=1.52u PD=0.8u
M$1182 671 673 653 1 sg13_lv_nmos L=0.13u W=0.42u AS=0.0798p AD=0.2373p PS=0.8u
+ PD=1.97u
M$1183 1 642 673 1 sg13_lv_nmos L=0.13u W=0.74u AS=0.317325p AD=0.2516p
+ PS=1.805u PD=2.16u
M$1184 1 726 642 1 sg13_lv_nmos L=0.13u W=0.74u AS=0.317325p AD=0.2516p
+ PS=1.805u PD=2.16u
M$1185 1 111 709 1 sg13_lv_nmos L=0.13u W=0.74u AS=0.2516p AD=0.2516p PS=2.16u
+ PD=2.16u
M$1186 1 708 710 1 sg13_lv_nmos L=0.13u W=0.74u AS=0.2516p AD=0.2516p PS=2.16u
+ PD=2.16u
M$1188 1 687 686 1 sg13_lv_nmos L=0.13u W=0.74u AS=0.1626p AD=0.2516p PS=1.415u
+ PD=2.16u
M$1189 681 735 743 1 sg13_lv_nmos L=0.13u W=0.42u AS=0.1428p AD=0.0609p
+ PS=1.52u PD=0.71u
M$1190 1 714 743 1 sg13_lv_nmos L=0.13u W=0.42u AS=0.1626p AD=0.0609p PS=1.415u
+ PD=0.71u
M$1191 1 714 744 1 sg13_lv_nmos L=0.13u W=0.42u AS=0.1701p AD=0.0378p PS=1.65u
+ PD=0.6u
M$1192 744 686 736 1 sg13_lv_nmos L=0.13u W=0.42u AS=0.0378p AD=0.1428p PS=0.6u
+ PD=1.52u
M$1193 737 718 1 1 sg13_lv_nmos L=0.13u W=0.42u AS=0.1428p AD=0.0798p PS=1.52u
+ PD=0.8u
M$1194 1 714 745 1 sg13_lv_nmos L=0.13u W=0.42u AS=0.0798p AD=0.0378p PS=0.8u
+ PD=0.6u
M$1195 745 717 718 1 sg13_lv_nmos L=0.13u W=0.42u AS=0.0378p AD=0.1428p PS=0.6u
+ PD=1.52u
M$1196 689 717 1 1 sg13_lv_nmos L=0.13u W=0.74u AS=0.2516p AD=0.1406p PS=2.16u
+ PD=1.12u
M$1197 1 689 690 1 sg13_lv_nmos L=0.13u W=0.74u AS=0.1406p AD=0.2516p PS=1.12u
+ PD=2.16u
M$1202 1 698 697 1 sg13_lv_nmos L=0.13u W=0.74u AS=0.1626p AD=0.2516p PS=1.415u
+ PD=2.16u
M$1203 682 696 751 1 sg13_lv_nmos L=0.13u W=0.42u AS=0.1428p AD=0.0609p
+ PS=1.52u PD=0.71u
M$1204 1 683 751 1 sg13_lv_nmos L=0.13u W=0.42u AS=0.1626p AD=0.0609p PS=1.415u
+ PD=0.71u
M$1205 1 683 752 1 sg13_lv_nmos L=0.13u W=0.42u AS=0.1701p AD=0.0378p PS=1.65u
+ PD=0.6u
M$1206 752 697 739 1 sg13_lv_nmos L=0.13u W=0.42u AS=0.0378p AD=0.1428p PS=0.6u
+ PD=1.52u
M$1207 740 724 1 1 sg13_lv_nmos L=0.13u W=0.42u AS=0.1428p AD=0.0798p PS=1.52u
+ PD=0.8u
M$1208 1 683 753 1 sg13_lv_nmos L=0.13u W=0.42u AS=0.0798p AD=0.0378p PS=0.8u
+ PD=0.6u
M$1209 753 723 724 1 sg13_lv_nmos L=0.13u W=0.42u AS=0.0378p AD=0.1428p PS=0.6u
+ PD=1.52u
M$1210 700 723 1 1 sg13_lv_nmos L=0.13u W=0.74u AS=0.2516p AD=0.1406p PS=2.16u
+ PD=1.12u
M$1211 1 700 720 1 sg13_lv_nmos L=0.13u W=0.74u AS=0.1406p AD=0.2516p PS=1.12u
+ PD=2.16u
M$1215 1 705 704 1 sg13_lv_nmos L=0.13u W=0.74u AS=0.1626p AD=0.2516p PS=1.415u
+ PD=2.16u
M$1216 684 651 749 1 sg13_lv_nmos L=0.13u W=0.42u AS=0.1428p AD=0.0609p
+ PS=1.52u PD=0.71u
M$1217 1 637 749 1 sg13_lv_nmos L=0.13u W=0.42u AS=0.1626p AD=0.0609p PS=1.415u
+ PD=0.71u
M$1218 1 637 747 1 sg13_lv_nmos L=0.13u W=0.42u AS=0.1701p AD=0.0378p PS=1.65u
+ PD=0.6u
M$1219 747 704 741 1 sg13_lv_nmos L=0.13u W=0.42u AS=0.0378p AD=0.1428p PS=0.6u
+ PD=1.52u
M$1220 742 729 1 1 sg13_lv_nmos L=0.13u W=0.42u AS=0.1428p AD=0.0798p PS=1.52u
+ PD=0.8u
M$1221 1 637 746 1 sg13_lv_nmos L=0.13u W=0.42u AS=0.0798p AD=0.0378p PS=0.8u
+ PD=0.6u
M$1222 746 728 729 1 sg13_lv_nmos L=0.13u W=0.42u AS=0.0378p AD=0.1428p PS=0.6u
+ PD=1.52u
M$1223 707 728 1 1 sg13_lv_nmos L=0.13u W=0.74u AS=0.2516p AD=0.1406p PS=2.16u
+ PD=1.12u
M$1224 1 707 708 1 sg13_lv_nmos L=0.13u W=0.74u AS=0.1406p AD=0.2516p PS=1.12u
+ PD=2.16u
M$1229 714 715 1 1 sg13_lv_nmos L=0.13u W=0.74u AS=0.2516p AD=0.2516p PS=2.16u
+ PD=2.16u
M$1230 715 761 1 1 sg13_lv_nmos L=0.13u W=0.74u AS=0.2886p AD=0.14875p PS=2.26u
+ PD=1.16u
M$1231 1 570 761 1 sg13_lv_nmos L=0.13u W=0.55u AS=0.14875p AD=0.187p PS=1.16u
+ PD=1.78u
M$1232 762 632 797 1 sg13_lv_nmos L=0.13u W=0.42u AS=0.1428p AD=0.0609p
+ PS=1.52u PD=0.71u
M$1233 797 685 1 1 sg13_lv_nmos L=0.13u W=0.42u AS=0.0609p AD=0.1626p PS=0.71u
+ PD=1.415u
M$1234 1 807 754 1 sg13_lv_nmos L=0.13u W=0.74u AS=0.1626p AD=0.2516p PS=1.415u
+ PD=2.16u
M$1235 1 685 799 1 sg13_lv_nmos L=0.13u W=0.42u AS=0.1701p AD=0.0378p PS=1.65u
+ PD=0.6u
M$1236 799 754 763 1 sg13_lv_nmos L=0.13u W=0.42u AS=0.0378p AD=0.1428p PS=0.6u
+ PD=1.52u
M$1237 1 755 816 1 sg13_lv_nmos L=0.13u W=0.74u AS=0.317325p AD=0.2516p
+ PS=1.805u PD=2.16u
M$1238 1 597 755 1 sg13_lv_nmos L=0.13u W=0.74u AS=0.317325p AD=0.2516p
+ PS=1.805u PD=2.16u
M$1239 765 755 764 1 sg13_lv_nmos L=0.13u W=0.42u AS=0.12665p AD=0.1428p
+ PS=1.145u PD=1.52u
M$1240 754 816 765 1 sg13_lv_nmos L=0.13u W=0.74u AS=0.3473p AD=0.12665p
+ PS=2.71u PD=1.145u
M$1241 764 766 1 1 sg13_lv_nmos L=0.13u W=0.42u AS=0.1428p AD=0.0798p PS=1.52u
+ PD=0.8u
M$1242 1 685 801 1 sg13_lv_nmos L=0.13u W=0.42u AS=0.0798p AD=0.0378p PS=0.8u
+ PD=0.6u
M$1243 801 765 766 1 sg13_lv_nmos L=0.13u W=0.42u AS=0.0378p AD=0.1428p PS=0.6u
+ PD=1.52u
M$1244 767 765 1 1 sg13_lv_nmos L=0.13u W=0.74u AS=0.2516p AD=0.1406p PS=2.16u
+ PD=1.12u
M$1245 1 767 669 1 sg13_lv_nmos L=0.13u W=0.74u AS=0.1406p AD=0.2516p PS=1.12u
+ PD=2.16u
M$1246 1 690 768 1 sg13_lv_nmos L=0.13u W=0.55u AS=0.374p AD=0.174625p PS=2.46u
+ PD=1.185u
M$1247 1 693 768 1 sg13_lv_nmos L=0.13u W=0.55u AS=0.15245p AD=0.174625p
+ PS=1.17u PD=1.185u
M$1248 1 690 813 1 sg13_lv_nmos L=0.13u W=0.74u AS=0.15245p AD=0.0888p PS=1.17u
+ PD=0.98u
M$1249 813 693 769 1 sg13_lv_nmos L=0.13u W=0.74u AS=0.0888p AD=0.1628p
+ PS=0.98u PD=1.18u
M$1250 769 768 1 1 sg13_lv_nmos L=0.13u W=0.74u AS=0.1628p AD=0.3108p PS=1.18u
+ PD=2.32u
M$1251 1 720 814 1 sg13_lv_nmos L=0.13u W=0.64u AS=0.2272p AD=0.0784p PS=1.99u
+ PD=0.885u
M$1252 814 721 770 1 sg13_lv_nmos L=0.13u W=0.64u AS=0.0784p AD=0.2176p
+ PS=0.885u PD=1.96u
M$1253 1 720 771 1 sg13_lv_nmos L=0.13u W=0.74u AS=0.1898p AD=0.2516p PS=1.36u
+ PD=2.16u
M$1254 1 721 771 1 sg13_lv_nmos L=0.13u W=0.74u AS=0.1898p AD=0.1406p PS=1.36u
+ PD=1.12u
M$1255 771 770 670 1 sg13_lv_nmos L=0.13u W=0.74u AS=0.1406p AD=0.2516p
+ PS=1.12u PD=2.16u
M$1257 1 648 815 1 sg13_lv_nmos L=0.13u W=0.64u AS=0.2272p AD=0.0784p PS=1.99u
+ PD=0.885u
M$1258 815 769 772 1 sg13_lv_nmos L=0.13u W=0.64u AS=0.0784p AD=0.2176p
+ PS=0.885u PD=1.96u
M$1259 1 648 773 1 sg13_lv_nmos L=0.13u W=0.74u AS=0.1898p AD=0.2516p PS=1.36u
+ PD=2.16u
M$1260 1 769 773 1 sg13_lv_nmos L=0.13u W=0.74u AS=0.1898p AD=0.1406p PS=1.36u
+ PD=1.12u
M$1261 773 772 808 1 sg13_lv_nmos L=0.13u W=0.74u AS=0.1406p AD=0.2516p
+ PS=1.12u PD=2.16u
M$1262 1 715 683 1 sg13_lv_nmos L=0.13u W=0.74u AS=0.2516p AD=0.2516p PS=2.16u
+ PD=2.16u
M$1263 1 715 774 1 sg13_lv_nmos L=0.13u W=0.74u AS=0.2516p AD=0.2516p PS=2.16u
+ PD=2.16u
M$1264 775 808 806 1 sg13_lv_nmos L=0.13u W=0.42u AS=0.1428p AD=0.0609p
+ PS=1.52u PD=0.71u
M$1265 806 774 1 1 sg13_lv_nmos L=0.13u W=0.42u AS=0.0609p AD=0.1626p PS=0.71u
+ PD=1.415u
M$1266 1 809 756 1 sg13_lv_nmos L=0.13u W=0.74u AS=0.1626p AD=0.2516p PS=1.415u
+ PD=2.16u
M$1267 1 774 805 1 sg13_lv_nmos L=0.13u W=0.42u AS=0.1701p AD=0.0378p PS=1.65u
+ PD=0.6u
M$1268 805 756 776 1 sg13_lv_nmos L=0.13u W=0.42u AS=0.0378p AD=0.1428p PS=0.6u
+ PD=1.52u
M$1269 1 757 817 1 sg13_lv_nmos L=0.13u W=0.74u AS=0.317325p AD=0.2516p
+ PS=1.805u PD=2.16u
M$1270 1 247 757 1 sg13_lv_nmos L=0.13u W=0.74u AS=0.317325p AD=0.2516p
+ PS=1.805u PD=2.16u
M$1271 778 757 777 1 sg13_lv_nmos L=0.13u W=0.42u AS=0.12665p AD=0.1428p
+ PS=1.145u PD=1.52u
M$1272 756 817 778 1 sg13_lv_nmos L=0.13u W=0.74u AS=0.3473p AD=0.12665p
+ PS=2.71u PD=1.145u
M$1273 777 779 1 1 sg13_lv_nmos L=0.13u W=0.42u AS=0.1428p AD=0.0798p PS=1.52u
+ PD=0.8u
M$1274 1 774 804 1 sg13_lv_nmos L=0.13u W=0.42u AS=0.0798p AD=0.0378p PS=0.8u
+ PD=0.6u
M$1275 804 778 779 1 sg13_lv_nmos L=0.13u W=0.42u AS=0.0378p AD=0.1428p PS=0.6u
+ PD=1.52u
M$1276 780 778 1 1 sg13_lv_nmos L=0.13u W=0.74u AS=0.2516p AD=0.1406p PS=2.16u
+ PD=1.12u
M$1277 1 780 719 1 sg13_lv_nmos L=0.13u W=0.74u AS=0.1406p AD=0.2516p PS=1.12u
+ PD=2.16u
M$1278 781 463 1 1 sg13_lv_nmos L=0.13u W=0.74u AS=0.2516p AD=0.2516p PS=2.16u
+ PD=2.16u
M$1279 782 703 803 1 sg13_lv_nmos L=0.13u W=0.42u AS=0.1428p AD=0.0609p
+ PS=1.52u PD=0.71u
M$1280 803 702 1 1 sg13_lv_nmos L=0.13u W=0.42u AS=0.0609p AD=0.1626p PS=0.71u
+ PD=1.415u
M$1281 1 810 758 1 sg13_lv_nmos L=0.13u W=0.74u AS=0.1626p AD=0.2516p PS=1.415u
+ PD=2.16u
M$1282 1 702 802 1 sg13_lv_nmos L=0.13u W=0.42u AS=0.1701p AD=0.0378p PS=1.65u
+ PD=0.6u
M$1283 802 758 783 1 sg13_lv_nmos L=0.13u W=0.42u AS=0.0378p AD=0.1428p PS=0.6u
+ PD=1.52u
M$1284 1 759 818 1 sg13_lv_nmos L=0.13u W=0.74u AS=0.317325p AD=0.2516p
+ PS=1.805u PD=2.16u
M$1285 1 725 759 1 sg13_lv_nmos L=0.13u W=0.74u AS=0.317325p AD=0.2516p
+ PS=1.805u PD=2.16u
M$1286 785 759 784 1 sg13_lv_nmos L=0.13u W=0.42u AS=0.12665p AD=0.1428p
+ PS=1.145u PD=1.52u
M$1287 758 818 785 1 sg13_lv_nmos L=0.13u W=0.74u AS=0.3473p AD=0.12665p
+ PS=2.71u PD=1.145u
M$1288 784 786 1 1 sg13_lv_nmos L=0.13u W=0.42u AS=0.1428p AD=0.0798p PS=1.52u
+ PD=0.8u
M$1289 1 702 800 1 sg13_lv_nmos L=0.13u W=0.42u AS=0.0798p AD=0.0378p PS=0.8u
+ PD=0.6u
M$1290 800 785 786 1 sg13_lv_nmos L=0.13u W=0.42u AS=0.0378p AD=0.1428p PS=0.6u
+ PD=1.52u
M$1291 787 785 1 1 sg13_lv_nmos L=0.13u W=0.74u AS=0.2516p AD=0.1406p PS=2.16u
+ PD=1.12u
M$1292 1 787 726 1 sg13_lv_nmos L=0.13u W=0.74u AS=0.1406p AD=0.2516p PS=1.12u
+ PD=2.16u
M$1294 638 788 1 1 sg13_lv_nmos L=0.13u W=0.74u AS=0.2516p AD=0.1406p PS=2.16u
+ PD=1.12u
M$1295 1 811 788 1 sg13_lv_nmos L=0.13u W=0.74u AS=0.1406p AD=0.2516p PS=1.12u
+ PD=2.16u
M$1296 789 811 798 1 sg13_lv_nmos L=0.13u W=0.42u AS=0.1428p AD=0.0378p
+ PS=1.52u PD=0.6u
M$1297 798 709 1 1 sg13_lv_nmos L=0.13u W=0.42u AS=0.0378p AD=0.0798p PS=0.6u
+ PD=0.8u
M$1298 1 789 790 1 sg13_lv_nmos L=0.13u W=0.42u AS=0.0798p AD=0.1428p PS=0.8u
+ PD=1.52u
M$1299 760 792 811 1 sg13_lv_nmos L=0.13u W=0.74u AS=0.3473p AD=0.12665p
+ PS=2.71u PD=1.145u
M$1300 811 791 790 1 sg13_lv_nmos L=0.13u W=0.42u AS=0.12665p AD=0.1428p
+ PS=1.145u PD=1.52u
M$1301 1 726 791 1 sg13_lv_nmos L=0.13u W=0.74u AS=0.317325p AD=0.2516p
+ PS=1.805u PD=2.16u
M$1302 1 791 792 1 sg13_lv_nmos L=0.13u W=0.74u AS=0.317325p AD=0.2516p
+ PS=1.805u PD=2.16u
M$1303 794 760 796 1 sg13_lv_nmos L=0.13u W=0.42u AS=0.1428p AD=0.0378p
+ PS=1.52u PD=0.6u
M$1304 796 709 1 1 sg13_lv_nmos L=0.13u W=0.42u AS=0.0378p AD=0.1701p PS=0.6u
+ PD=1.65u
M$1305 1 709 795 1 sg13_lv_nmos L=0.13u W=0.42u AS=0.1626p AD=0.0609p PS=1.415u
+ PD=0.71u
M$1306 795 710 793 1 sg13_lv_nmos L=0.13u W=0.42u AS=0.0609p AD=0.1428p
+ PS=0.71u PD=1.52u
M$1307 1 812 760 1 sg13_lv_nmos L=0.13u W=0.74u AS=0.1626p AD=0.2516p PS=1.415u
+ PD=2.16u
M$1309 833 819 1 1 sg13_lv_nmos L=0.13u W=0.55u AS=0.187p AD=0.14875p PS=1.78u
+ PD=1.16u
M$1310 1 833 570 1 sg13_lv_nmos L=0.13u W=0.74u AS=0.14875p AD=0.2886p PS=1.16u
+ PD=2.26u
M$1312 1 107 832 1 sg13_lv_nmos L=0.13u W=0.55u AS=0.18945p AD=0.187p PS=1.27u
+ PD=1.78u
M$1313 735 849 1 1 sg13_lv_nmos L=0.13u W=0.74u AS=0.4033p AD=0.148p PS=2.57u
+ PD=1.14u
M$1314 1 832 854 1 sg13_lv_nmos L=0.13u W=0.74u AS=0.148p AD=0.3367p PS=1.14u
+ PD=1.65u
M$1315 854 690 849 1 sg13_lv_nmos L=0.13u W=0.74u AS=0.3367p AD=0.1628p
+ PS=1.65u PD=1.18u
M$1316 849 669 855 1 sg13_lv_nmos L=0.13u W=0.74u AS=0.1628p AD=0.13135p
+ PS=1.18u PD=1.095u
M$1317 855 107 1 1 sg13_lv_nmos L=0.13u W=0.74u AS=0.13135p AD=0.18945p
+ PS=1.095u PD=1.27u
M$1318 762 755 807 1 sg13_lv_nmos L=0.13u W=0.42u AS=0.1296p AD=0.0798p
+ PS=1.52u PD=0.8u
M$1319 807 816 763 1 sg13_lv_nmos L=0.13u W=0.42u AS=0.0798p AD=0.2373p PS=0.8u
+ PD=1.97u
M$1324 1 669 856 1 sg13_lv_nmos L=0.13u W=0.64u AS=0.2272p AD=0.0784p PS=1.99u
+ PD=0.885u
M$1325 856 719 834 1 sg13_lv_nmos L=0.13u W=0.64u AS=0.0784p AD=0.2176p
+ PS=0.885u PD=1.96u
M$1326 851 669 1 1 sg13_lv_nmos L=0.13u W=0.74u AS=0.2516p AD=0.1898p PS=2.16u
+ PD=1.36u
M$1327 1 719 851 1 sg13_lv_nmos L=0.13u W=0.74u AS=0.1898p AD=0.1406p PS=1.36u
+ PD=1.12u
M$1328 851 834 721 1 sg13_lv_nmos L=0.13u W=0.74u AS=0.1406p AD=0.2516p
+ PS=1.12u PD=2.16u
M$1341 775 757 809 1 sg13_lv_nmos L=0.13u W=0.42u AS=0.1296p AD=0.0798p
+ PS=1.52u PD=0.8u
M$1342 809 817 776 1 sg13_lv_nmos L=0.13u W=0.42u AS=0.0798p AD=0.2373p PS=0.8u
+ PD=1.97u
M$1343 835 570 1 1 sg13_lv_nmos L=0.13u W=0.55u AS=0.187p AD=0.14875p PS=1.78u
+ PD=1.16u
M$1344 1 835 111 1 sg13_lv_nmos L=0.13u W=0.74u AS=0.14875p AD=0.2886p PS=1.16u
+ PD=2.26u
M$1345 1 837 838 1 sg13_lv_nmos L=0.13u W=0.74u AS=0.1626p AD=0.2516p PS=1.415u
+ PD=2.16u
M$1346 836 701 857 1 sg13_lv_nmos L=0.13u W=0.42u AS=0.1428p AD=0.0609p
+ PS=1.52u PD=0.71u
M$1347 1 781 857 1 sg13_lv_nmos L=0.13u W=0.42u AS=0.1626p AD=0.0609p PS=1.415u
+ PD=0.71u
M$1348 1 781 858 1 sg13_lv_nmos L=0.13u W=0.42u AS=0.1701p AD=0.0378p PS=1.65u
+ PD=0.6u
M$1349 858 838 852 1 sg13_lv_nmos L=0.13u W=0.42u AS=0.0378p AD=0.1428p PS=0.6u
+ PD=1.52u
M$1350 463 860 1 1 sg13_lv_nmos L=0.13u W=0.74u AS=0.2886p AD=0.14875p PS=2.26u
+ PD=1.16u
M$1351 1 111 860 1 sg13_lv_nmos L=0.13u W=0.55u AS=0.14875p AD=0.187p PS=1.16u
+ PD=1.78u
M$1352 836 840 837 1 sg13_lv_nmos L=0.13u W=0.42u AS=0.1296p AD=0.0798p
+ PS=1.52u PD=0.8u
M$1353 837 839 852 1 sg13_lv_nmos L=0.13u W=0.42u AS=0.0798p AD=0.2373p PS=0.8u
+ PD=1.97u
M$1354 839 840 1 1 sg13_lv_nmos L=0.13u W=0.74u AS=0.2516p AD=0.317325p
+ PS=2.16u PD=1.805u
M$1355 1 850 840 1 sg13_lv_nmos L=0.13u W=0.74u AS=0.317325p AD=0.2516p
+ PS=1.805u PD=2.16u
M$1356 853 840 841 1 sg13_lv_nmos L=0.13u W=0.42u AS=0.1428p AD=0.12665p
+ PS=1.52u PD=1.145u
M$1357 841 839 838 1 sg13_lv_nmos L=0.13u W=0.74u AS=0.12665p AD=0.3473p
+ PS=1.145u PD=2.71u
M$1358 853 842 1 1 sg13_lv_nmos L=0.13u W=0.42u AS=0.1428p AD=0.0798p PS=1.52u
+ PD=0.8u
M$1359 1 781 859 1 sg13_lv_nmos L=0.13u W=0.42u AS=0.0798p AD=0.0378p PS=0.8u
+ PD=0.6u
M$1360 859 841 842 1 sg13_lv_nmos L=0.13u W=0.42u AS=0.0378p AD=0.1428p PS=0.6u
+ PD=1.52u
M$1361 782 759 810 1 sg13_lv_nmos L=0.13u W=0.42u AS=0.1296p AD=0.0798p
+ PS=1.52u PD=0.8u
M$1362 810 818 783 1 sg13_lv_nmos L=0.13u W=0.42u AS=0.0798p AD=0.2373p PS=0.8u
+ PD=1.97u
M$1363 843 841 1 1 sg13_lv_nmos L=0.13u W=0.74u AS=0.2516p AD=0.1406p PS=2.16u
+ PD=1.12u
M$1364 1 843 725 1 sg13_lv_nmos L=0.13u W=0.74u AS=0.1406p AD=0.2516p PS=1.12u
+ PD=2.16u
M$1377 794 792 812 1 sg13_lv_nmos L=0.13u W=0.42u AS=0.2373p AD=0.0798p
+ PS=1.97u PD=0.8u
M$1378 812 791 793 1 sg13_lv_nmos L=0.13u W=0.42u AS=0.0798p AD=0.1296p PS=0.8u
+ PD=1.52u
M$1427 3 4 2 3 sg13_lv_pmos L=0.13u W=1.12u AS=0.3808p AD=0.3808p PS=2.92u
+ PD=2.92u
M$1428 3 1 3 3 sg13_lv_pmos L=1u W=517u AS=140.23p AD=140.23p PS=1077.46u
+ PD=1077.46u
M$1477 7 27 3 3 sg13_lv_pmos L=0.13u W=1.12u AS=0.3864p AD=0.2128p PS=2.93u
+ PD=1.5u
M$1478 3 7 8 3 sg13_lv_pmos L=0.13u W=1.12u AS=0.2128p AD=0.3808p PS=1.5u
+ PD=2.92u
M$1482 3 11 10 3 sg13_lv_pmos L=0.13u W=0.84u AS=0.2891p AD=0.1596p PS=1.695u
+ PD=1.22u
M$1483 10 65 3 3 sg13_lv_pmos L=0.13u W=0.84u AS=0.1596p AD=0.4536p PS=1.22u
+ PD=2.76u
M$1484 3 10 9 3 sg13_lv_pmos L=0.13u W=1.12u AS=0.3808p AD=0.2408p PS=2.92u
+ PD=1.55u
M$1485 9 11 36 3 sg13_lv_pmos L=0.13u W=1.12u AS=0.2408p AD=0.1428p PS=1.55u
+ PD=1.375u
M$1486 36 65 3 3 sg13_lv_pmos L=0.13u W=1.12u AS=0.1428p AD=0.2891p PS=1.375u
+ PD=1.695u
M$1487 11 13 12 3 sg13_lv_pmos L=0.13u W=1.12u AS=0.3808p AD=0.2128p PS=2.92u
+ PD=1.5u
M$1488 12 29 3 3 sg13_lv_pmos L=0.13u W=1.12u AS=0.2128p AD=0.2128p PS=1.5u
+ PD=1.5u
M$1489 3 30 12 3 sg13_lv_pmos L=0.13u W=1.12u AS=0.2128p AD=0.3808p PS=1.5u
+ PD=2.92u
M$1490 13 29 38 3 sg13_lv_pmos L=0.13u W=1u AS=0.34p AD=0.1225p PS=2.68u
+ PD=1.245u
M$1491 38 30 3 3 sg13_lv_pmos L=0.13u W=1u AS=0.1225p AD=0.36p PS=1.245u
+ PD=2.72u
M$1493 3 30 39 3 sg13_lv_pmos L=0.13u W=1.12u AS=0.4032p AD=0.1176p PS=2.96u
+ PD=1.33u
M$1494 39 29 14 3 sg13_lv_pmos L=0.13u W=1.12u AS=0.1176p AD=0.3808p PS=1.33u
+ PD=2.92u
M$1495 15 165 3 3 sg13_lv_pmos L=0.13u W=1u AS=0.34p AD=0.19p PS=2.68u PD=1.38u
M$1496 3 2 15 3 sg13_lv_pmos L=0.13u W=1u AS=0.19p AD=0.2125p PS=1.38u PD=1.425u
M$1497 15 31 16 3 sg13_lv_pmos L=0.13u W=1u AS=0.2125p AD=0.35p PS=1.425u
+ PD=2.7u
M$1498 3 16 17 3 sg13_lv_pmos L=0.13u W=2.24u AS=0.5936p AD=0.5936p PS=4.42u
+ PD=4.42u
M$1500 3 14 40 3 sg13_lv_pmos L=0.13u W=1.12u AS=0.4032p AD=0.1176p PS=2.96u
+ PD=1.33u
M$1501 40 166 31 3 sg13_lv_pmos L=0.13u W=1.12u AS=0.1176p AD=0.3808p PS=1.33u
+ PD=2.92u
M$1505 3 8 37 3 sg13_lv_pmos L=0.13u W=1u AS=0.36p AD=0.1225p PS=2.72u PD=1.245u
M$1506 37 30 18 3 sg13_lv_pmos L=0.13u W=1u AS=0.1225p AD=0.34p PS=1.245u
+ PD=2.68u
M$1507 19 8 3 3 sg13_lv_pmos L=0.13u W=1.12u AS=0.3808p AD=0.2128p PS=2.92u
+ PD=1.5u
M$1508 3 30 19 3 sg13_lv_pmos L=0.13u W=1.12u AS=0.2128p AD=0.2128p PS=1.5u
+ PD=1.5u
M$1509 19 18 20 3 sg13_lv_pmos L=0.13u W=1.12u AS=0.2128p AD=0.3808p PS=1.5u
+ PD=2.92u
M$1510 21 20 3 3 sg13_lv_pmos L=0.13u W=1.12u AS=0.3808p AD=0.2128p PS=2.92u
+ PD=1.5u
M$1511 3 32 21 3 sg13_lv_pmos L=0.13u W=1.12u AS=0.2128p AD=0.2128p PS=1.5u
+ PD=1.5u
M$1512 21 33 22 3 sg13_lv_pmos L=0.13u W=1.12u AS=0.2128p AD=0.3808p PS=1.5u
+ PD=2.92u
M$1529 3 74 23 3 sg13_lv_pmos L=0.13u W=1.12u AS=0.3808p AD=0.3808p PS=2.92u
+ PD=2.92u
M$1530 3 74 106 3 sg13_lv_pmos L=0.13u W=1.12u AS=0.3808p AD=0.3808p PS=2.92u
+ PD=2.92u
M$1531 75 107 3 3 sg13_lv_pmos L=0.13u W=0.84u AS=0.2856p AD=0.253p PS=2.36u
+ PD=1.53u
M$1532 3 107 121 3 sg13_lv_pmos L=0.13u W=1u AS=0.253p AD=0.3325p PS=1.53u
+ PD=1.665u
M$1533 121 8 60 3 sg13_lv_pmos L=0.13u W=1u AS=0.3325p AD=0.2225p PS=1.665u
+ PD=1.445u
M$1534 60 65 122 3 sg13_lv_pmos L=0.13u W=1u AS=0.2225p AD=0.2975p PS=1.445u
+ PD=1.595u
M$1535 122 75 3 3 sg13_lv_pmos L=0.13u W=1u AS=0.2975p AD=0.2198p PS=1.595u
+ PD=1.52u
M$1536 3 60 41 3 sg13_lv_pmos L=0.13u W=1.12u AS=0.2198p AD=0.6048p PS=1.52u
+ PD=3.32u
M$1537 3 41 5 3 sg13_lv_pmos L=0.13u W=0.42u AS=0.1428p AD=0.0798p PS=1.52u
+ PD=0.8u
M$1538 3 23 5 3 sg13_lv_pmos L=0.13u W=0.42u AS=0.3623875p AD=0.0798p PS=2.605u
+ PD=0.8u
M$1539 3 6 24 3 sg13_lv_pmos L=0.13u W=1u AS=0.3623875p AD=0.34p PS=2.605u
+ PD=2.68u
M$1540 3 23 6 3 sg13_lv_pmos L=0.13u W=0.42u AS=0.1563p AD=0.147p PS=1.22u
+ PD=1.54u
M$1541 3 24 34 3 sg13_lv_pmos L=0.13u W=0.42u AS=0.1563p AD=0.063p PS=1.22u
+ PD=0.72u
M$1542 34 26 6 3 sg13_lv_pmos L=0.13u W=0.42u AS=0.063p AD=0.0798p PS=0.72u
+ PD=0.8u
M$1543 6 25 5 3 sg13_lv_pmos L=0.13u W=0.42u AS=0.0798p AD=0.1428p PS=0.8u
+ PD=1.52u
M$1544 3 26 25 3 sg13_lv_pmos L=0.13u W=1.12u AS=0.41165p AD=0.3864p PS=2.12u
+ PD=2.93u
M$1545 3 210 26 3 sg13_lv_pmos L=0.13u W=1.12u AS=0.41165p AD=0.4088p PS=2.12u
+ PD=2.97u
M$1546 24 26 27 3 sg13_lv_pmos L=0.13u W=1u AS=0.34p AD=0.2048p PS=2.68u
+ PD=1.63u
M$1547 27 25 35 3 sg13_lv_pmos L=0.13u W=0.42u AS=0.2048p AD=0.09345p PS=1.63u
+ PD=0.865u
M$1548 3 28 35 3 sg13_lv_pmos L=0.13u W=0.42u AS=0.204p AD=0.09345p PS=1.835u
+ PD=0.865u
M$1549 3 23 28 3 sg13_lv_pmos L=0.13u W=0.42u AS=0.204p AD=0.0798p PS=1.835u
+ PD=0.8u
M$1550 3 27 28 3 sg13_lv_pmos L=0.13u W=0.42u AS=0.4659p AD=0.0798p PS=3.65u
+ PD=0.8u
M$1551 116 54 3 3 sg13_lv_pmos L=0.13u W=1.12u AS=0.3864p AD=0.41165p PS=2.93u
+ PD=2.12u
M$1552 3 210 54 3 sg13_lv_pmos L=0.13u W=1.12u AS=0.41165p AD=0.4088p PS=2.12u
+ PD=2.97u
M$1553 77 116 124 3 sg13_lv_pmos L=0.13u W=0.42u AS=0.2048p AD=0.09345p
+ PS=1.63u PD=0.865u
M$1554 124 63 3 3 sg13_lv_pmos L=0.13u W=0.42u AS=0.09345p AD=0.204p PS=0.865u
+ PD=1.835u
M$1555 3 106 63 3 sg13_lv_pmos L=0.13u W=0.42u AS=0.204p AD=0.0798p PS=1.835u
+ PD=0.8u
M$1556 63 77 3 3 sg13_lv_pmos L=0.13u W=0.42u AS=0.0798p AD=0.4659p PS=0.8u
+ PD=3.65u
M$1557 53 54 77 3 sg13_lv_pmos L=0.13u W=1u AS=0.34p AD=0.2048p PS=2.68u
+ PD=1.63u
M$1558 64 77 3 3 sg13_lv_pmos L=0.13u W=1.12u AS=0.3864p AD=0.2128p PS=2.93u
+ PD=1.5u
M$1559 3 64 65 3 sg13_lv_pmos L=0.13u W=1.12u AS=0.2128p AD=0.3808p PS=1.5u
+ PD=2.92u
M$1560 3 74 78 3 sg13_lv_pmos L=0.13u W=1.12u AS=0.3808p AD=0.3808p PS=2.92u
+ PD=2.92u
M$1561 117 56 3 3 sg13_lv_pmos L=0.13u W=1.12u AS=0.3864p AD=0.41165p PS=2.93u
+ PD=2.12u
M$1562 3 115 56 3 sg13_lv_pmos L=0.13u W=1.12u AS=0.41165p AD=0.4088p PS=2.12u
+ PD=2.97u
M$1563 80 117 127 3 sg13_lv_pmos L=0.13u W=0.42u AS=0.2048p AD=0.09345p
+ PS=1.63u PD=0.865u
M$1564 127 68 3 3 sg13_lv_pmos L=0.13u W=0.42u AS=0.09345p AD=0.204p PS=0.865u
+ PD=1.835u
M$1565 3 78 68 3 sg13_lv_pmos L=0.13u W=0.42u AS=0.204p AD=0.0798p PS=1.835u
+ PD=0.8u
M$1566 68 80 3 3 sg13_lv_pmos L=0.13u W=0.42u AS=0.0798p AD=0.4659p PS=0.8u
+ PD=3.65u
M$1567 55 56 80 3 sg13_lv_pmos L=0.13u W=1u AS=0.34p AD=0.2048p PS=2.68u
+ PD=1.63u
M$1568 69 80 3 3 sg13_lv_pmos L=0.13u W=1.12u AS=0.3864p AD=0.2128p PS=2.93u
+ PD=1.5u
M$1569 3 69 29 3 sg13_lv_pmos L=0.13u W=1.12u AS=0.2128p AD=0.3808p PS=1.5u
+ PD=2.92u
M$1570 81 111 3 3 sg13_lv_pmos L=0.13u W=1.12u AS=0.3808p AD=0.3808p PS=2.92u
+ PD=2.92u
M$1571 118 58 3 3 sg13_lv_pmos L=0.13u W=1.12u AS=0.3864p AD=0.41165p PS=2.93u
+ PD=2.12u
M$1572 3 115 58 3 sg13_lv_pmos L=0.13u W=1.12u AS=0.41165p AD=0.4088p PS=2.12u
+ PD=2.97u
M$1573 83 118 131 3 sg13_lv_pmos L=0.13u W=0.42u AS=0.2048p AD=0.09345p
+ PS=1.63u PD=0.865u
M$1574 131 72 3 3 sg13_lv_pmos L=0.13u W=0.42u AS=0.09345p AD=0.204p PS=0.865u
+ PD=1.835u
M$1575 3 81 72 3 sg13_lv_pmos L=0.13u W=0.42u AS=0.204p AD=0.0798p PS=1.835u
+ PD=0.8u
M$1576 72 83 3 3 sg13_lv_pmos L=0.13u W=0.42u AS=0.0798p AD=0.4659p PS=0.8u
+ PD=3.65u
M$1577 57 58 83 3 sg13_lv_pmos L=0.13u W=1u AS=0.34p AD=0.2048p PS=2.68u
+ PD=1.63u
M$1578 73 83 3 3 sg13_lv_pmos L=0.13u W=1.12u AS=0.3864p AD=0.2128p PS=2.93u
+ PD=1.5u
M$1579 3 73 32 3 sg13_lv_pmos L=0.13u W=1.12u AS=0.2128p AD=0.3808p PS=1.5u
+ PD=2.92u
M$1580 119 114 3 3 sg13_lv_pmos L=0.13u W=1.12u AS=0.3808p AD=0.2128p PS=2.92u
+ PD=1.5u
M$1581 3 530 119 3 sg13_lv_pmos L=0.13u W=1.12u AS=0.2128p AD=0.2128p PS=1.5u
+ PD=1.5u
M$1582 119 85 86 3 sg13_lv_pmos L=0.13u W=1.12u AS=0.2128p AD=0.3808p PS=1.5u
+ PD=2.92u
M$1583 3 22 128 3 sg13_lv_pmos L=0.13u W=1.12u AS=0.4032p AD=0.1176p PS=2.96u
+ PD=1.33u
M$1584 128 167 87 3 sg13_lv_pmos L=0.13u W=1.12u AS=0.1176p AD=0.3808p PS=1.33u
+ PD=2.92u
M$1585 120 17 3 3 sg13_lv_pmos L=0.13u W=1.12u AS=0.3808p AD=0.2128p PS=2.92u
+ PD=1.5u
M$1586 3 151 120 3 sg13_lv_pmos L=0.13u W=1.12u AS=0.2128p AD=0.2128p PS=1.5u
+ PD=1.5u
M$1587 120 88 89 3 sg13_lv_pmos L=0.13u W=1.12u AS=0.2128p AD=0.3808p PS=1.5u
+ PD=2.92u
M$1588 3 111 90 3 sg13_lv_pmos L=0.13u W=1.12u AS=0.3808p AD=0.3808p PS=2.92u
+ PD=2.92u
M$1589 3 115 91 3 sg13_lv_pmos L=0.13u W=0.84u AS=0.2114p AD=0.2856p PS=1.54u
+ PD=2.36u
M$1590 3 91 59 3 sg13_lv_pmos L=0.13u W=1.12u AS=0.2114p AD=0.42p PS=1.54u
+ PD=2.99u
M$1593 3 108 61 3 sg13_lv_pmos L=0.13u W=0.42u AS=0.1428p AD=0.0798p PS=1.52u
+ PD=0.8u
M$1594 3 106 61 3 sg13_lv_pmos L=0.13u W=0.42u AS=0.3623875p AD=0.0798p
+ PS=2.605u PD=0.8u
M$1595 3 109 53 3 sg13_lv_pmos L=0.13u W=1u AS=0.3623875p AD=0.34p PS=2.605u
+ PD=2.68u
M$1596 109 106 3 3 sg13_lv_pmos L=0.13u W=0.42u AS=0.147p AD=0.1563p PS=1.54u
+ PD=1.22u
M$1597 3 53 123 3 sg13_lv_pmos L=0.13u W=0.42u AS=0.1563p AD=0.063p PS=1.22u
+ PD=0.72u
M$1598 123 54 109 3 sg13_lv_pmos L=0.13u W=0.42u AS=0.063p AD=0.0798p PS=0.72u
+ PD=0.8u
M$1599 109 116 61 3 sg13_lv_pmos L=0.13u W=0.42u AS=0.0798p AD=0.1428p PS=0.8u
+ PD=1.52u
M$1600 141 139 3 3 sg13_lv_pmos L=0.13u W=1.12u AS=0.3864p AD=0.2128p PS=2.93u
+ PD=1.5u
M$1601 3 141 114 3 sg13_lv_pmos L=0.13u W=1.12u AS=0.2128p AD=0.3808p PS=1.5u
+ PD=2.92u
M$1604 3 9 66 3 sg13_lv_pmos L=0.13u W=0.42u AS=0.1428p AD=0.0798p PS=1.52u
+ PD=0.8u
M$1605 3 78 66 3 sg13_lv_pmos L=0.13u W=0.42u AS=0.3623875p AD=0.0798p
+ PS=2.605u PD=0.8u
M$1606 3 110 55 3 sg13_lv_pmos L=0.13u W=1u AS=0.3623875p AD=0.34p PS=2.605u
+ PD=2.68u
M$1608 110 78 3 3 sg13_lv_pmos L=0.13u W=0.42u AS=0.147p AD=0.1563p PS=1.54u
+ PD=1.22u
M$1609 3 55 125 3 sg13_lv_pmos L=0.13u W=0.42u AS=0.1563p AD=0.063p PS=1.22u
+ PD=0.72u
M$1610 125 56 110 3 sg13_lv_pmos L=0.13u W=0.42u AS=0.063p AD=0.0798p PS=0.72u
+ PD=0.8u
M$1611 110 117 66 3 sg13_lv_pmos L=0.13u W=0.42u AS=0.0798p AD=0.1428p PS=0.8u
+ PD=1.52u
M$1612 3 11 142 3 sg13_lv_pmos L=0.13u W=0.84u AS=0.2198p AD=0.2856p PS=1.53u
+ PD=2.36u
M$1613 3 65 4 3 sg13_lv_pmos L=0.13u W=1.12u AS=0.2198p AD=0.2128p PS=1.53u
+ PD=1.5u
M$1614 4 142 3 3 sg13_lv_pmos L=0.13u W=1.12u AS=0.2128p AD=0.3808p PS=1.5u
+ PD=2.92u
M$1616 3 4 143 3 sg13_lv_pmos L=0.13u W=0.84u AS=0.4536p AD=0.1596p PS=2.76u
+ PD=1.22u
M$1617 3 165 143 3 sg13_lv_pmos L=0.13u W=0.84u AS=0.2891p AD=0.1596p PS=1.695u
+ PD=1.22u
M$1618 3 4 175 3 sg13_lv_pmos L=0.13u W=1.12u AS=0.2891p AD=0.1428p PS=1.695u
+ PD=1.375u
M$1619 175 165 112 3 sg13_lv_pmos L=0.13u W=1.12u AS=0.1428p AD=0.2408p
+ PS=1.375u PD=1.55u
M$1620 112 143 3 3 sg13_lv_pmos L=0.13u W=1.12u AS=0.2408p AD=0.3808p PS=1.55u
+ PD=2.92u
M$1621 165 145 144 3 sg13_lv_pmos L=0.13u W=1.12u AS=0.3808p AD=0.2128p
+ PS=2.92u PD=1.5u
M$1622 144 166 3 3 sg13_lv_pmos L=0.13u W=1.12u AS=0.2128p AD=0.2128p PS=1.5u
+ PD=1.5u
M$1623 3 14 144 3 sg13_lv_pmos L=0.13u W=1.12u AS=0.2128p AD=0.3808p PS=1.5u
+ PD=2.92u
M$1624 145 166 176 3 sg13_lv_pmos L=0.13u W=1u AS=0.34p AD=0.1225p PS=2.68u
+ PD=1.245u
M$1625 176 14 3 3 sg13_lv_pmos L=0.13u W=1u AS=0.1225p AD=0.36p PS=1.245u
+ PD=2.72u
M$1626 3 112 70 3 sg13_lv_pmos L=0.13u W=0.42u AS=0.1428p AD=0.0798p PS=1.52u
+ PD=0.8u
M$1627 3 81 70 3 sg13_lv_pmos L=0.13u W=0.42u AS=0.3623875p AD=0.0798p
+ PS=2.605u PD=0.8u
M$1628 3 113 57 3 sg13_lv_pmos L=0.13u W=1u AS=0.3623875p AD=0.34p PS=2.605u
+ PD=2.68u
M$1631 113 81 3 3 sg13_lv_pmos L=0.13u W=0.42u AS=0.147p AD=0.1563p PS=1.54u
+ PD=1.22u
M$1632 3 57 130 3 sg13_lv_pmos L=0.13u W=0.42u AS=0.1563p AD=0.063p PS=1.22u
+ PD=0.72u
M$1633 130 58 113 3 sg13_lv_pmos L=0.13u W=0.42u AS=0.063p AD=0.0798p PS=0.72u
+ PD=0.8u
M$1634 113 118 70 3 sg13_lv_pmos L=0.13u W=0.42u AS=0.0798p AD=0.1428p PS=0.8u
+ PD=1.52u
M$1637 3 20 146 3 sg13_lv_pmos L=0.13u W=0.84u AS=0.2891p AD=0.1596p PS=1.695u
+ PD=1.22u
M$1638 146 32 3 3 sg13_lv_pmos L=0.13u W=0.84u AS=0.1596p AD=0.4536p PS=1.22u
+ PD=2.76u
M$1639 3 146 166 3 sg13_lv_pmos L=0.13u W=1.12u AS=0.3808p AD=0.2408p PS=2.92u
+ PD=1.55u
M$1640 166 20 178 3 sg13_lv_pmos L=0.13u W=1.12u AS=0.2408p AD=0.1428p PS=1.55u
+ PD=1.375u
M$1641 178 32 3 3 sg13_lv_pmos L=0.13u W=1.12u AS=0.1428p AD=0.2891p PS=1.375u
+ PD=1.695u
M$1644 3 8 84 3 sg13_lv_pmos L=0.13u W=0.84u AS=0.2856p AD=0.1596p PS=2.36u
+ PD=1.22u
M$1645 3 30 84 3 sg13_lv_pmos L=0.13u W=0.84u AS=0.1918p AD=0.1596p PS=1.5u
+ PD=1.22u
M$1646 3 84 33 3 sg13_lv_pmos L=0.13u W=1.12u AS=0.1918p AD=0.3808p PS=1.5u
+ PD=2.92u
M$1647 3 114 147 3 sg13_lv_pmos L=0.13u W=0.84u AS=0.2856p AD=0.1596p PS=2.36u
+ PD=1.22u
M$1648 147 530 3 3 sg13_lv_pmos L=0.13u W=0.84u AS=0.1596p AD=0.1918p PS=1.22u
+ PD=1.5u
M$1649 3 147 148 3 sg13_lv_pmos L=0.13u W=1.12u AS=0.1918p AD=0.3808p PS=1.5u
+ PD=2.92u
M$1650 3 114 129 3 sg13_lv_pmos L=0.13u W=1u AS=0.36p AD=0.1225p PS=2.72u
+ PD=1.245u
M$1651 129 530 85 3 sg13_lv_pmos L=0.13u W=1u AS=0.1225p AD=0.34p PS=1.245u
+ PD=2.68u
M$1652 3 22 179 3 sg13_lv_pmos L=0.13u W=1u AS=0.36p AD=0.1225p PS=2.72u
+ PD=1.245u
M$1653 179 167 149 3 sg13_lv_pmos L=0.13u W=1u AS=0.1225p AD=0.34p PS=1.245u
+ PD=2.68u
M$1654 150 22 3 3 sg13_lv_pmos L=0.13u W=1.12u AS=0.3808p AD=0.2128p PS=2.92u
+ PD=1.5u
M$1655 3 167 150 3 sg13_lv_pmos L=0.13u W=1.12u AS=0.2128p AD=0.2128p PS=1.5u
+ PD=1.5u
M$1656 150 149 151 3 sg13_lv_pmos L=0.13u W=1.12u AS=0.2128p AD=0.3808p PS=1.5u
+ PD=2.92u
M$1657 3 17 126 3 sg13_lv_pmos L=0.13u W=1u AS=0.36p AD=0.1225p PS=2.72u
+ PD=1.245u
M$1658 126 151 88 3 sg13_lv_pmos L=0.13u W=1u AS=0.1225p AD=0.34p PS=1.245u
+ PD=2.68u
M$1659 3 86 152 3 sg13_lv_pmos L=0.13u W=0.84u AS=0.2891p AD=0.1596p PS=1.695u
+ PD=1.22u
M$1660 152 168 3 3 sg13_lv_pmos L=0.13u W=0.84u AS=0.1596p AD=0.4536p PS=1.22u
+ PD=2.76u
M$1661 3 152 167 3 sg13_lv_pmos L=0.13u W=1.12u AS=0.3808p AD=0.2408p PS=2.92u
+ PD=1.55u
M$1662 167 86 177 3 sg13_lv_pmos L=0.13u W=1.12u AS=0.2408p AD=0.1428p PS=1.55u
+ PD=1.375u
M$1663 177 168 3 3 sg13_lv_pmos L=0.13u W=1.12u AS=0.1428p AD=0.2891p PS=1.375u
+ PD=1.695u
M$1670 159 157 3 3 sg13_lv_pmos L=0.13u W=1.12u AS=0.3864p AD=0.2128p PS=2.93u
+ PD=1.5u
M$1671 3 159 168 3 sg13_lv_pmos L=0.13u W=1.12u AS=0.2128p AD=0.3808p PS=1.5u
+ PD=2.92u
M$1674 3 107 133 3 sg13_lv_pmos L=0.13u W=0.84u AS=0.253p AD=0.2856p PS=1.53u
+ PD=2.36u
M$1675 3 107 171 3 sg13_lv_pmos L=0.13u W=1u AS=0.253p AD=0.3325p PS=1.53u
+ PD=1.665u
M$1676 171 65 134 3 sg13_lv_pmos L=0.13u W=1u AS=0.3325p AD=0.2225p PS=1.665u
+ PD=1.445u
M$1677 134 162 172 3 sg13_lv_pmos L=0.13u W=1u AS=0.2225p AD=0.2975p PS=1.445u
+ PD=1.595u
M$1678 3 133 172 3 sg13_lv_pmos L=0.13u W=1u AS=0.2198p AD=0.2975p PS=1.52u
+ PD=1.595u
M$1679 3 134 108 3 sg13_lv_pmos L=0.13u W=1.12u AS=0.2198p AD=0.6048p PS=1.52u
+ PD=3.32u
M$1680 200 107 3 3 sg13_lv_pmos L=0.13u W=0.84u AS=0.2856p AD=0.253p PS=2.36u
+ PD=1.53u
M$1681 3 107 208 3 sg13_lv_pmos L=0.13u W=1u AS=0.253p AD=0.3325p PS=1.53u
+ PD=1.665u
M$1682 208 114 201 3 sg13_lv_pmos L=0.13u W=1u AS=0.3325p AD=0.2225p PS=1.665u
+ PD=1.445u
M$1683 201 8 209 3 sg13_lv_pmos L=0.13u W=1u AS=0.2225p AD=0.2975p PS=1.445u
+ PD=1.595u
M$1684 209 200 3 3 sg13_lv_pmos L=0.13u W=1u AS=0.2975p AD=0.2198p PS=1.595u
+ PD=1.52u
M$1685 3 201 202 3 sg13_lv_pmos L=0.13u W=1.12u AS=0.2198p AD=0.6048p PS=1.52u
+ PD=3.32u
M$1686 3 202 135 3 sg13_lv_pmos L=0.13u W=0.42u AS=0.1428p AD=0.0798p PS=1.52u
+ PD=0.8u
M$1687 3 132 135 3 sg13_lv_pmos L=0.13u W=0.42u AS=0.3623875p AD=0.0798p
+ PS=2.605u PD=0.8u
M$1688 3 137 136 3 sg13_lv_pmos L=0.13u W=1u AS=0.3623875p AD=0.34p PS=2.605u
+ PD=2.68u
M$1689 3 74 132 3 sg13_lv_pmos L=0.13u W=1.12u AS=0.3808p AD=0.3808p PS=2.92u
+ PD=2.92u
M$1692 3 132 137 3 sg13_lv_pmos L=0.13u W=0.42u AS=0.1563p AD=0.147p PS=1.22u
+ PD=1.54u
M$1693 3 136 161 3 sg13_lv_pmos L=0.13u W=0.42u AS=0.1563p AD=0.063p PS=1.22u
+ PD=0.72u
M$1694 161 164 137 3 sg13_lv_pmos L=0.13u W=0.42u AS=0.063p AD=0.0798p PS=0.72u
+ PD=0.8u
M$1695 137 138 135 3 sg13_lv_pmos L=0.13u W=0.42u AS=0.0798p AD=0.1428p PS=0.8u
+ PD=1.52u
M$1698 3 164 138 3 sg13_lv_pmos L=0.13u W=1.12u AS=0.41165p AD=0.3864p PS=2.12u
+ PD=2.93u
M$1699 3 210 164 3 sg13_lv_pmos L=0.13u W=1.12u AS=0.41165p AD=0.4088p PS=2.12u
+ PD=2.97u
M$1700 136 164 139 3 sg13_lv_pmos L=0.13u W=1u AS=0.34p AD=0.2048p PS=2.68u
+ PD=1.63u
M$1701 139 138 174 3 sg13_lv_pmos L=0.13u W=0.42u AS=0.2048p AD=0.09345p
+ PS=1.63u PD=0.865u
M$1702 3 140 174 3 sg13_lv_pmos L=0.13u W=0.42u AS=0.204p AD=0.09345p PS=1.835u
+ PD=0.865u
M$1703 3 132 140 3 sg13_lv_pmos L=0.13u W=0.42u AS=0.204p AD=0.0798p PS=1.835u
+ PD=0.8u
M$1704 3 139 140 3 sg13_lv_pmos L=0.13u W=0.42u AS=0.4659p AD=0.0798p PS=3.65u
+ PD=0.8u
M$1729 203 148 207 3 sg13_lv_pmos L=0.13u W=1.12u AS=0.3808p AD=0.2128p
+ PS=2.92u PD=1.5u
M$1730 207 168 3 3 sg13_lv_pmos L=0.13u W=1.12u AS=0.2128p AD=0.2128p PS=1.5u
+ PD=1.5u
M$1731 3 86 207 3 sg13_lv_pmos L=0.13u W=1.12u AS=0.2128p AD=0.3808p PS=1.5u
+ PD=2.92u
M$1736 3 89 153 3 sg13_lv_pmos L=0.13u W=0.42u AS=0.1428p AD=0.0798p PS=1.52u
+ PD=0.8u
M$1737 3 90 153 3 sg13_lv_pmos L=0.13u W=0.42u AS=0.3623875p AD=0.0798p
+ PS=2.605u PD=0.8u
M$1738 3 155 154 3 sg13_lv_pmos L=0.13u W=1u AS=0.3623875p AD=0.34p PS=2.605u
+ PD=2.68u
M$1741 3 90 155 3 sg13_lv_pmos L=0.13u W=0.42u AS=0.1563p AD=0.147p PS=1.22u
+ PD=1.54u
M$1742 3 154 160 3 sg13_lv_pmos L=0.13u W=0.42u AS=0.1563p AD=0.063p PS=1.22u
+ PD=0.72u
M$1743 160 170 155 3 sg13_lv_pmos L=0.13u W=0.42u AS=0.063p AD=0.0798p PS=0.72u
+ PD=0.8u
M$1744 155 156 153 3 sg13_lv_pmos L=0.13u W=0.42u AS=0.0798p AD=0.1428p PS=0.8u
+ PD=1.52u
M$1747 3 170 156 3 sg13_lv_pmos L=0.13u W=1.12u AS=0.41165p AD=0.3864p PS=2.12u
+ PD=2.93u
M$1748 3 115 170 3 sg13_lv_pmos L=0.13u W=1.12u AS=0.41165p AD=0.4088p PS=2.12u
+ PD=2.97u
M$1749 154 170 157 3 sg13_lv_pmos L=0.13u W=1u AS=0.34p AD=0.2048p PS=2.68u
+ PD=1.63u
M$1750 157 156 173 3 sg13_lv_pmos L=0.13u W=0.42u AS=0.2048p AD=0.09345p
+ PS=1.63u PD=0.865u
M$1751 3 158 173 3 sg13_lv_pmos L=0.13u W=0.42u AS=0.204p AD=0.09345p PS=1.835u
+ PD=0.865u
M$1752 3 90 158 3 sg13_lv_pmos L=0.13u W=0.42u AS=0.204p AD=0.0798p PS=1.835u
+ PD=0.8u
M$1753 3 157 158 3 sg13_lv_pmos L=0.13u W=0.42u AS=0.4659p AD=0.0798p PS=3.65u
+ PD=0.8u
M$1765 3 211 210 3 sg13_lv_pmos L=0.13u W=17.92u AS=3.5896p AD=3.4048p
+ PS=25.45u PD=24u
M$1781 3 415 211 3 sg13_lv_pmos L=0.13u W=6.72u AS=1.2768p AD=1.4448p PS=9u
+ PD=10.42u
M$1805 212 217 216 3 sg13_lv_pmos L=0.13u W=1.12u AS=0.3808p AD=0.1176p
+ PS=2.92u PD=1.33u
M$1806 216 203 3 3 sg13_lv_pmos L=0.13u W=1.12u AS=0.1176p AD=0.4032p PS=1.33u
+ PD=2.96u
M$1807 3 215 214 3 sg13_lv_pmos L=0.13u W=0.84u AS=0.1918p AD=0.1596p PS=1.5u
+ PD=1.22u
M$1808 214 151 3 3 sg13_lv_pmos L=0.13u W=0.84u AS=0.1596p AD=0.2856p PS=1.22u
+ PD=2.36u
M$1809 213 214 3 3 sg13_lv_pmos L=0.13u W=1.12u AS=0.3808p AD=0.1918p PS=2.92u
+ PD=1.5u
M$1820 3 218 225 3 sg13_lv_pmos L=0.13u W=0.84u AS=0.2114p AD=0.2856p PS=1.54u
+ PD=2.36u
M$1821 3 225 162 3 sg13_lv_pmos L=0.13u W=1.12u AS=0.2114p AD=0.42p PS=1.54u
+ PD=2.99u
M$1823 3 107 226 3 sg13_lv_pmos L=0.13u W=0.84u AS=0.253p AD=0.2856p PS=1.53u
+ PD=2.36u
M$1824 3 226 250 3 sg13_lv_pmos L=0.13u W=1u AS=0.2198p AD=0.2975p PS=1.52u
+ PD=1.595u
M$1825 250 114 221 3 sg13_lv_pmos L=0.13u W=1u AS=0.2975p AD=0.2225p PS=1.595u
+ PD=1.445u
M$1826 221 227 251 3 sg13_lv_pmos L=0.13u W=1u AS=0.2225p AD=0.3325p PS=1.445u
+ PD=1.665u
M$1827 251 107 3 3 sg13_lv_pmos L=0.13u W=1u AS=0.3325p AD=0.253p PS=1.665u
+ PD=1.53u
M$1828 220 221 3 3 sg13_lv_pmos L=0.13u W=1.12u AS=0.6048p AD=0.2198p PS=3.32u
+ PD=1.52u
M$1843 3 227 252 3 sg13_lv_pmos L=0.13u W=1u AS=0.36p AD=0.1225p PS=2.72u
+ PD=1.245u
M$1844 252 30 228 3 sg13_lv_pmos L=0.13u W=1u AS=0.1225p AD=0.34p PS=1.245u
+ PD=2.68u
M$1845 248 227 3 3 sg13_lv_pmos L=0.13u W=1.12u AS=0.3808p AD=0.2128p PS=2.92u
+ PD=1.5u
M$1846 3 30 248 3 sg13_lv_pmos L=0.13u W=1.12u AS=0.2128p AD=0.2128p PS=1.5u
+ PD=1.5u
M$1847 248 228 222 3 sg13_lv_pmos L=0.13u W=1.12u AS=0.2128p AD=0.3808p PS=1.5u
+ PD=2.92u
M$1850 3 222 289 3 sg13_lv_pmos L=0.13u W=1.12u AS=0.3808p AD=0.2128p PS=2.92u
+ PD=1.5u
M$1851 289 229 3 3 sg13_lv_pmos L=0.13u W=1.12u AS=0.2128p AD=0.3808p PS=1.5u
+ PD=2.92u
M$1854 3 229 230 3 sg13_lv_pmos L=0.13u W=0.84u AS=0.4536p AD=0.1596p PS=2.76u
+ PD=1.22u
M$1855 3 222 230 3 sg13_lv_pmos L=0.13u W=0.84u AS=0.2891p AD=0.1596p PS=1.695u
+ PD=1.22u
M$1856 3 229 253 3 sg13_lv_pmos L=0.13u W=1.12u AS=0.2891p AD=0.1428p PS=1.695u
+ PD=1.375u
M$1857 253 222 217 3 sg13_lv_pmos L=0.13u W=1.12u AS=0.1428p AD=0.2408p
+ PS=1.375u PD=1.55u
M$1858 217 230 3 3 sg13_lv_pmos L=0.13u W=1.12u AS=0.2408p AD=0.3808p PS=1.55u
+ PD=2.92u
M$1861 3 224 223 3 sg13_lv_pmos L=0.13u W=2.24u AS=0.5936p AD=0.5936p PS=4.42u
+ PD=4.42u
M$1863 224 212 245 3 sg13_lv_pmos L=0.13u W=1u AS=0.35p AD=0.2125p PS=2.7u
+ PD=1.425u
M$1864 245 87 3 3 sg13_lv_pmos L=0.13u W=1u AS=0.2125p AD=0.19p PS=1.425u
+ PD=1.38u
M$1865 3 232 245 3 sg13_lv_pmos L=0.13u W=1u AS=0.19p AD=0.34p PS=1.38u PD=2.68u
M$1866 3 203 254 3 sg13_lv_pmos L=0.13u W=1u AS=0.36p AD=0.1225p PS=2.72u
+ PD=1.245u
M$1867 254 217 233 3 sg13_lv_pmos L=0.13u W=1u AS=0.1225p AD=0.34p PS=1.245u
+ PD=2.68u
M$1868 249 203 3 3 sg13_lv_pmos L=0.13u W=1.12u AS=0.3808p AD=0.2128p PS=2.92u
+ PD=1.5u
M$1869 3 217 249 3 sg13_lv_pmos L=0.13u W=1.12u AS=0.2128p AD=0.2128p PS=1.5u
+ PD=1.5u
M$1870 249 233 215 3 sg13_lv_pmos L=0.13u W=1.12u AS=0.2128p AD=0.3808p PS=1.5u
+ PD=2.92u
M$1871 3 215 234 3 sg13_lv_pmos L=0.13u W=0.84u AS=0.4536p AD=0.1596p PS=2.76u
+ PD=1.22u
M$1872 3 277 234 3 sg13_lv_pmos L=0.13u W=0.84u AS=0.2891p AD=0.1596p PS=1.695u
+ PD=1.22u
M$1873 3 215 255 3 sg13_lv_pmos L=0.13u W=1.12u AS=0.2891p AD=0.1428p PS=1.695u
+ PD=1.375u
M$1874 255 277 246 3 sg13_lv_pmos L=0.13u W=1.12u AS=0.1428p AD=0.2408p
+ PS=1.375u PD=1.55u
M$1875 246 234 3 3 sg13_lv_pmos L=0.13u W=1.12u AS=0.2408p AD=0.3808p PS=1.55u
+ PD=2.92u
M$1880 115 236 3 3 sg13_lv_pmos L=0.13u W=1.12u AS=0.42p AD=0.2114p PS=2.99u
+ PD=1.54u
M$1881 3 247 236 3 sg13_lv_pmos L=0.13u W=0.84u AS=0.2114p AD=0.2856p PS=1.54u
+ PD=2.36u
M$1886 3 74 257 3 sg13_lv_pmos L=0.13u W=1.12u AS=0.3808p AD=0.3808p PS=2.92u
+ PD=2.92u
M$1887 3 220 256 3 sg13_lv_pmos L=0.13u W=0.42u AS=0.1428p AD=0.0798p PS=1.52u
+ PD=0.8u
M$1888 3 257 256 3 sg13_lv_pmos L=0.13u W=0.42u AS=0.3623875p AD=0.0798p
+ PS=2.605u PD=0.8u
M$1889 3 262 261 3 sg13_lv_pmos L=0.13u W=1u AS=0.3623875p AD=0.34p PS=2.605u
+ PD=2.68u
M$1890 3 283 263 3 sg13_lv_pmos L=0.13u W=1.12u AS=0.41165p AD=0.3864p PS=2.12u
+ PD=2.93u
M$1891 3 210 283 3 sg13_lv_pmos L=0.13u W=1.12u AS=0.41165p AD=0.4088p PS=2.12u
+ PD=2.97u
M$1892 261 283 284 3 sg13_lv_pmos L=0.13u W=1u AS=0.34p AD=0.2048p PS=2.68u
+ PD=1.63u
M$1893 284 263 297 3 sg13_lv_pmos L=0.13u W=0.42u AS=0.2048p AD=0.09345p
+ PS=1.63u PD=0.865u
M$1894 3 285 297 3 sg13_lv_pmos L=0.13u W=0.42u AS=0.204p AD=0.09345p PS=1.835u
+ PD=0.865u
M$1895 3 257 285 3 sg13_lv_pmos L=0.13u W=0.42u AS=0.204p AD=0.0798p PS=1.835u
+ PD=0.8u
M$1896 3 284 285 3 sg13_lv_pmos L=0.13u W=0.42u AS=0.4659p AD=0.0798p PS=3.65u
+ PD=0.8u
M$1897 264 284 3 3 sg13_lv_pmos L=0.13u W=1.12u AS=0.3864p AD=0.2128p PS=2.93u
+ PD=1.5u
M$1898 3 264 227 3 sg13_lv_pmos L=0.13u W=1.12u AS=0.2128p AD=0.3808p PS=1.5u
+ PD=2.92u
M$1900 3 286 265 3 sg13_lv_pmos L=0.13u W=1.12u AS=0.3808p AD=0.2128p PS=2.92u
+ PD=1.5u
M$1901 265 30 3 3 sg13_lv_pmos L=0.13u W=1.12u AS=0.2128p AD=0.3808p PS=1.5u
+ PD=2.92u
M$1904 3 288 266 3 sg13_lv_pmos L=0.13u W=0.84u AS=0.4536p AD=0.1596p PS=2.76u
+ PD=1.22u
M$1905 3 287 266 3 sg13_lv_pmos L=0.13u W=0.84u AS=0.2891p AD=0.1596p PS=1.695u
+ PD=1.22u
M$1906 3 288 298 3 sg13_lv_pmos L=0.13u W=1.12u AS=0.2891p AD=0.1428p PS=1.695u
+ PD=1.375u
M$1907 298 287 267 3 sg13_lv_pmos L=0.13u W=1.12u AS=0.1428p AD=0.2408p
+ PS=1.375u PD=1.55u
M$1908 267 266 3 3 sg13_lv_pmos L=0.13u W=1.12u AS=0.2408p AD=0.3808p PS=1.55u
+ PD=2.92u
M$1909 3 30 268 3 sg13_lv_pmos L=0.13u W=1.12u AS=0.3808p AD=0.2128p PS=2.92u
+ PD=1.5u
M$1910 268 227 3 3 sg13_lv_pmos L=0.13u W=1.12u AS=0.2128p AD=0.3808p PS=1.5u
+ PD=2.92u
M$1911 3 267 258 3 sg13_lv_pmos L=0.13u W=1.12u AS=0.3808p AD=0.2128p PS=2.92u
+ PD=1.5u
M$1912 258 289 3 3 sg13_lv_pmos L=0.13u W=1.12u AS=0.2128p AD=0.2128p PS=1.5u
+ PD=1.5u
M$1913 3 268 258 3 sg13_lv_pmos L=0.13u W=1.12u AS=0.2128p AD=0.3808p PS=1.5u
+ PD=2.92u
M$1914 3 258 269 3 sg13_lv_pmos L=0.13u W=0.84u AS=0.2618p AD=0.2856p PS=1.63u
+ PD=2.36u
M$1915 3 269 299 3 sg13_lv_pmos L=0.13u W=1.12u AS=0.2618p AD=0.1176p PS=1.63u
+ PD=1.33u
M$1916 299 348 270 3 sg13_lv_pmos L=0.13u W=1.12u AS=0.1176p AD=0.3808p
+ PS=1.33u PD=2.92u
M$1917 271 530 3 3 sg13_lv_pmos L=0.13u W=0.84u AS=0.2856p AD=0.2114p PS=2.36u
+ PD=1.54u
M$1918 3 271 30 3 sg13_lv_pmos L=0.13u W=1.12u AS=0.2114p AD=0.42p PS=1.54u
+ PD=2.99u
M$1922 272 111 3 3 sg13_lv_pmos L=0.13u W=1.12u AS=0.3808p AD=0.3808p PS=2.92u
+ PD=2.92u
M$1924 273 213 3 3 sg13_lv_pmos L=0.13u W=2.24u AS=0.5936p AD=0.4256p PS=4.42u
+ PD=3u
M$1925 3 17 273 3 sg13_lv_pmos L=0.13u W=2.24u AS=0.4256p AD=0.4256p PS=3u PD=3u
M$1928 273 223 274 3 sg13_lv_pmos L=0.13u W=2.24u AS=0.4256p AD=0.5936p PS=3u
+ PD=4.42u
M$1930 275 290 3 3 sg13_lv_pmos L=0.13u W=1.12u AS=0.3808p AD=0.3808p PS=2.92u
+ PD=2.92u
M$1931 290 223 276 3 sg13_lv_pmos L=0.13u W=1u AS=0.35p AD=0.2125p PS=2.7u
+ PD=1.425u
M$1932 276 17 3 3 sg13_lv_pmos L=0.13u W=1u AS=0.2125p AD=0.19p PS=1.425u
+ PD=1.38u
M$1933 3 213 276 3 sg13_lv_pmos L=0.13u W=1u AS=0.19p AD=0.34p PS=1.38u PD=2.68u
M$1934 3 217 232 3 sg13_lv_pmos L=0.13u W=1.12u AS=0.3808p AD=0.2128p PS=2.92u
+ PD=1.5u
M$1935 232 203 3 3 sg13_lv_pmos L=0.13u W=1.12u AS=0.2128p AD=0.3808p PS=1.5u
+ PD=2.92u
M$1936 277 87 278 3 sg13_lv_pmos L=0.13u W=1.12u AS=0.3808p AD=0.2128p PS=2.92u
+ PD=1.5u
M$1937 278 17 3 3 sg13_lv_pmos L=0.13u W=1.12u AS=0.2128p AD=0.2128p PS=1.5u
+ PD=1.5u
M$1938 3 151 278 3 sg13_lv_pmos L=0.13u W=1.12u AS=0.2128p AD=0.3808p PS=1.5u
+ PD=2.92u
M$1940 3 111 260 3 sg13_lv_pmos L=0.13u W=1.12u AS=0.3808p AD=0.3808p PS=2.92u
+ PD=2.92u
M$1941 3 246 259 3 sg13_lv_pmos L=0.13u W=0.42u AS=0.1428p AD=0.0798p PS=1.52u
+ PD=0.8u
M$1942 3 260 259 3 sg13_lv_pmos L=0.13u W=0.42u AS=0.3623875p AD=0.0798p
+ PS=2.605u PD=0.8u
M$1943 3 280 279 3 sg13_lv_pmos L=0.13u W=1u AS=0.3623875p AD=0.34p PS=2.605u
+ PD=2.68u
M$1944 3 291 281 3 sg13_lv_pmos L=0.13u W=1.12u AS=0.41165p AD=0.3864p PS=2.12u
+ PD=2.93u
M$1945 3 115 291 3 sg13_lv_pmos L=0.13u W=1.12u AS=0.41165p AD=0.4088p PS=2.12u
+ PD=2.97u
M$1946 279 291 292 3 sg13_lv_pmos L=0.13u W=1u AS=0.34p AD=0.2048p PS=2.68u
+ PD=1.63u
M$1947 292 281 294 3 sg13_lv_pmos L=0.13u W=0.42u AS=0.2048p AD=0.09345p
+ PS=1.63u PD=0.865u
M$1948 3 293 294 3 sg13_lv_pmos L=0.13u W=0.42u AS=0.204p AD=0.09345p PS=1.835u
+ PD=0.865u
M$1949 3 260 293 3 sg13_lv_pmos L=0.13u W=0.42u AS=0.204p AD=0.0798p PS=1.835u
+ PD=0.8u
M$1950 3 292 293 3 sg13_lv_pmos L=0.13u W=0.42u AS=0.4659p AD=0.0798p PS=3.65u
+ PD=0.8u
M$1951 282 292 3 3 sg13_lv_pmos L=0.13u W=1.12u AS=0.3864p AD=0.2128p PS=2.93u
+ PD=1.5u
M$1952 3 282 229 3 sg13_lv_pmos L=0.13u W=1.12u AS=0.2128p AD=0.3808p PS=1.5u
+ PD=2.92u
M$1953 3 74 320 3 sg13_lv_pmos L=0.13u W=1.12u AS=0.3808p AD=0.3808p PS=2.92u
+ PD=2.92u
M$1954 3 257 262 3 sg13_lv_pmos L=0.13u W=0.42u AS=0.1563p AD=0.147p PS=1.22u
+ PD=1.54u
M$1955 3 261 295 3 sg13_lv_pmos L=0.13u W=0.42u AS=0.1563p AD=0.063p PS=1.22u
+ PD=0.72u
M$1956 295 283 262 3 sg13_lv_pmos L=0.13u W=0.42u AS=0.063p AD=0.0798p PS=0.72u
+ PD=0.8u
M$1957 262 263 256 3 sg13_lv_pmos L=0.13u W=0.42u AS=0.0798p AD=0.1428p PS=0.8u
+ PD=1.52u
M$1958 375 323 3 3 sg13_lv_pmos L=0.13u W=1.12u AS=0.3864p AD=0.41165p PS=2.93u
+ PD=2.12u
M$1959 3 210 323 3 sg13_lv_pmos L=0.13u W=1.12u AS=0.41165p AD=0.4088p PS=2.12u
+ PD=2.97u
M$1960 343 375 386 3 sg13_lv_pmos L=0.13u W=0.42u AS=0.2048p AD=0.09345p
+ PS=1.63u PD=0.865u
M$1961 386 325 3 3 sg13_lv_pmos L=0.13u W=0.42u AS=0.09345p AD=0.204p PS=0.865u
+ PD=1.835u
M$1962 3 320 325 3 sg13_lv_pmos L=0.13u W=0.42u AS=0.204p AD=0.0798p PS=1.835u
+ PD=0.8u
M$1963 325 343 3 3 sg13_lv_pmos L=0.13u W=0.42u AS=0.0798p AD=0.4659p PS=0.8u
+ PD=3.65u
M$1964 322 323 343 3 sg13_lv_pmos L=0.13u W=1u AS=0.34p AD=0.2048p PS=2.68u
+ PD=1.63u
M$1965 326 343 3 3 sg13_lv_pmos L=0.13u W=1.12u AS=0.3864p AD=0.2128p PS=2.93u
+ PD=1.5u
M$1966 3 326 286 3 sg13_lv_pmos L=0.13u W=1.12u AS=0.2128p AD=0.3808p PS=1.5u
+ PD=2.92u
M$1967 383 286 3 3 sg13_lv_pmos L=0.13u W=1.12u AS=0.3808p AD=0.2128p PS=2.92u
+ PD=1.5u
M$1968 3 30 383 3 sg13_lv_pmos L=0.13u W=1.12u AS=0.2128p AD=0.2128p PS=1.5u
+ PD=1.5u
M$1969 383 344 287 3 sg13_lv_pmos L=0.13u W=1.12u AS=0.2128p AD=0.3808p PS=1.5u
+ PD=2.92u
M$1970 3 287 345 3 sg13_lv_pmos L=0.13u W=1.12u AS=0.3808p AD=0.2128p PS=2.92u
+ PD=1.5u
M$1971 345 288 3 3 sg13_lv_pmos L=0.13u W=1.12u AS=0.2128p AD=0.3808p PS=1.5u
+ PD=2.92u
M$1972 376 345 3 3 sg13_lv_pmos L=0.13u W=1.12u AS=0.3808p AD=0.2128p PS=2.92u
+ PD=1.5u
M$1973 3 265 376 3 sg13_lv_pmos L=0.13u W=1.12u AS=0.2128p AD=0.2128p PS=1.5u
+ PD=1.5u
M$1974 376 347 346 3 sg13_lv_pmos L=0.13u W=1.12u AS=0.2128p AD=0.3808p PS=1.5u
+ PD=2.92u
M$1975 3 347 327 3 sg13_lv_pmos L=0.13u W=1.12u AS=0.3808p AD=0.2128p PS=2.92u
+ PD=1.5u
M$1976 327 345 3 3 sg13_lv_pmos L=0.13u W=1.12u AS=0.2128p AD=0.2128p PS=1.5u
+ PD=1.5u
M$1977 3 265 327 3 sg13_lv_pmos L=0.13u W=1.12u AS=0.2128p AD=0.3808p PS=1.5u
+ PD=2.92u
M$1978 348 267 377 3 sg13_lv_pmos L=0.13u W=1.12u AS=0.3808p AD=0.2128p
+ PS=2.92u PD=1.5u
M$1979 377 268 3 3 sg13_lv_pmos L=0.13u W=1.12u AS=0.2128p AD=0.2128p PS=1.5u
+ PD=1.5u
M$1980 3 289 377 3 sg13_lv_pmos L=0.13u W=1.12u AS=0.2128p AD=0.3808p PS=1.5u
+ PD=2.92u
M$1981 349 348 378 3 sg13_lv_pmos L=0.13u W=1.12u AS=0.3808p AD=0.2128p
+ PS=2.92u PD=1.5u
M$1982 378 275 3 3 sg13_lv_pmos L=0.13u W=1.12u AS=0.2128p AD=0.2128p PS=1.5u
+ PD=1.5u
M$1983 3 270 378 3 sg13_lv_pmos L=0.13u W=1.12u AS=0.2128p AD=0.3808p PS=1.5u
+ PD=2.92u
M$1984 3 274 350 3 sg13_lv_pmos L=0.13u W=0.84u AS=0.4536p AD=0.1596p PS=2.76u
+ PD=1.22u
M$1985 3 270 350 3 sg13_lv_pmos L=0.13u W=0.84u AS=0.2891p AD=0.1596p PS=1.695u
+ PD=1.22u
M$1986 3 274 389 3 sg13_lv_pmos L=0.13u W=1.12u AS=0.2891p AD=0.1428p PS=1.695u
+ PD=1.375u
M$1987 389 270 328 3 sg13_lv_pmos L=0.13u W=1.12u AS=0.1428p AD=0.2408p
+ PS=1.375u PD=1.55u
M$1988 328 350 3 3 sg13_lv_pmos L=0.13u W=1.12u AS=0.2408p AD=0.3808p PS=1.55u
+ PD=2.92u
M$1989 380 331 3 3 sg13_lv_pmos L=0.13u W=1.12u AS=0.3864p AD=0.41165p PS=2.93u
+ PD=2.12u
M$1990 3 115 331 3 sg13_lv_pmos L=0.13u W=1.12u AS=0.41165p AD=0.4088p PS=2.12u
+ PD=2.97u
M$1991 353 380 391 3 sg13_lv_pmos L=0.13u W=0.42u AS=0.2048p AD=0.09345p
+ PS=1.63u PD=0.865u
M$1992 391 333 3 3 sg13_lv_pmos L=0.13u W=0.42u AS=0.09345p AD=0.204p PS=0.865u
+ PD=1.835u
M$1993 3 272 333 3 sg13_lv_pmos L=0.13u W=0.42u AS=0.204p AD=0.0798p PS=1.835u
+ PD=0.8u
M$1994 333 353 3 3 sg13_lv_pmos L=0.13u W=0.42u AS=0.0798p AD=0.4659p PS=0.8u
+ PD=3.65u
M$1995 330 331 353 3 sg13_lv_pmos L=0.13u W=1u AS=0.34p AD=0.2048p PS=2.68u
+ PD=1.63u
M$1996 334 353 3 3 sg13_lv_pmos L=0.13u W=1.12u AS=0.3864p AD=0.2128p PS=2.93u
+ PD=1.5u
M$1997 3 334 288 3 sg13_lv_pmos L=0.13u W=1.12u AS=0.2128p AD=0.3808p PS=1.5u
+ PD=2.92u
M$1998 3 115 335 3 sg13_lv_pmos L=0.13u W=1.12u AS=0.3808p AD=0.3808p PS=2.92u
+ PD=2.92u
M$1999 3 260 280 3 sg13_lv_pmos L=0.13u W=0.42u AS=0.1563p AD=0.147p PS=1.22u
+ PD=1.54u
M$2000 3 279 296 3 sg13_lv_pmos L=0.13u W=0.42u AS=0.1563p AD=0.063p PS=1.22u
+ PD=0.72u
M$2001 296 291 280 3 sg13_lv_pmos L=0.13u W=0.42u AS=0.063p AD=0.0798p PS=0.72u
+ PD=0.8u
M$2002 280 281 259 3 sg13_lv_pmos L=0.13u W=0.42u AS=0.0798p AD=0.1428p PS=0.8u
+ PD=1.52u
M$2003 382 338 3 3 sg13_lv_pmos L=0.13u W=1.12u AS=0.3864p AD=0.41165p PS=2.93u
+ PD=2.12u
M$2004 3 423 338 3 sg13_lv_pmos L=0.13u W=1.12u AS=0.41165p AD=0.4088p PS=2.12u
+ PD=2.97u
M$2005 356 382 385 3 sg13_lv_pmos L=0.13u W=0.42u AS=0.2048p AD=0.09345p
+ PS=1.63u PD=0.865u
M$2006 385 340 3 3 sg13_lv_pmos L=0.13u W=0.42u AS=0.09345p AD=0.204p PS=0.865u
+ PD=1.835u
M$2007 3 354 340 3 sg13_lv_pmos L=0.13u W=0.42u AS=0.204p AD=0.0798p PS=1.835u
+ PD=0.8u
M$2008 340 356 3 3 sg13_lv_pmos L=0.13u W=0.42u AS=0.0798p AD=0.4659p PS=0.8u
+ PD=3.65u
M$2009 337 338 356 3 sg13_lv_pmos L=0.13u W=1u AS=0.34p AD=0.2048p PS=2.68u
+ PD=1.63u
M$2010 341 356 3 3 sg13_lv_pmos L=0.13u W=1.12u AS=0.3864p AD=0.2128p PS=2.93u
+ PD=1.5u
M$2011 3 341 247 3 sg13_lv_pmos L=0.13u W=1.12u AS=0.2128p AD=0.3808p PS=1.5u
+ PD=2.92u
M$2016 3 396 321 3 sg13_lv_pmos L=0.13u W=0.42u AS=0.1428p AD=0.0798p PS=1.52u
+ PD=0.8u
M$2017 3 320 321 3 sg13_lv_pmos L=0.13u W=0.42u AS=0.3623875p AD=0.0798p
+ PS=2.605u PD=0.8u
M$2018 3 374 322 3 sg13_lv_pmos L=0.13u W=1u AS=0.3623875p AD=0.34p PS=2.605u
+ PD=2.68u
M$2019 374 320 3 3 sg13_lv_pmos L=0.13u W=0.42u AS=0.147p AD=0.1563p PS=1.54u
+ PD=1.22u
M$2020 3 322 384 3 sg13_lv_pmos L=0.13u W=0.42u AS=0.1563p AD=0.063p PS=1.22u
+ PD=0.72u
M$2021 384 323 374 3 sg13_lv_pmos L=0.13u W=0.42u AS=0.063p AD=0.0798p PS=0.72u
+ PD=0.8u
M$2022 374 375 321 3 sg13_lv_pmos L=0.13u W=0.42u AS=0.0798p AD=0.1428p PS=0.8u
+ PD=1.52u
M$2031 3 286 388 3 sg13_lv_pmos L=0.13u W=1u AS=0.36p AD=0.1225p PS=2.72u
+ PD=1.245u
M$2032 388 30 344 3 sg13_lv_pmos L=0.13u W=1u AS=0.1225p AD=0.34p PS=1.245u
+ PD=2.68u
M$2033 393 265 3 3 sg13_lv_pmos L=0.13u W=0.84u AS=0.2856p AD=0.1596p PS=2.36u
+ PD=1.22u
M$2034 3 345 393 3 sg13_lv_pmos L=0.13u W=0.84u AS=0.1596p AD=0.1596p PS=1.22u
+ PD=1.22u
M$2035 3 347 393 3 sg13_lv_pmos L=0.13u W=0.84u AS=0.36195p AD=0.1596p PS=1.84u
+ PD=1.22u
M$2036 3 393 394 3 sg13_lv_pmos L=0.13u W=1.12u AS=0.36195p AD=0.3808p PS=1.84u
+ PD=2.92u
M$2037 3 399 395 3 sg13_lv_pmos L=0.15u W=1.12u AS=0.3808p AD=0.2128p PS=2.92u
+ PD=1.5u
M$2038 395 400 404 3 sg13_lv_pmos L=0.15u W=1.12u AS=0.2128p AD=0.2128p PS=1.5u
+ PD=1.5u
M$2039 404 274 3 3 sg13_lv_pmos L=0.15u W=1.12u AS=0.2128p AD=0.3808p PS=1.5u
+ PD=2.92u
M$2045 3 328 329 3 sg13_lv_pmos L=0.13u W=0.42u AS=0.1428p AD=0.0798p PS=1.52u
+ PD=0.8u
M$2046 3 272 329 3 sg13_lv_pmos L=0.13u W=0.42u AS=0.3623875p AD=0.0798p
+ PS=2.605u PD=0.8u
M$2047 3 379 330 3 sg13_lv_pmos L=0.13u W=1u AS=0.3623875p AD=0.34p PS=2.605u
+ PD=2.68u
M$2050 379 272 3 3 sg13_lv_pmos L=0.13u W=0.42u AS=0.147p AD=0.1563p PS=1.54u
+ PD=1.22u
M$2051 3 330 390 3 sg13_lv_pmos L=0.13u W=0.42u AS=0.1563p AD=0.063p PS=1.22u
+ PD=0.72u
M$2052 390 331 379 3 sg13_lv_pmos L=0.13u W=0.42u AS=0.063p AD=0.0798p PS=0.72u
+ PD=0.8u
M$2053 379 380 329 3 sg13_lv_pmos L=0.13u W=0.42u AS=0.0798p AD=0.1428p PS=0.8u
+ PD=1.52u
M$2071 3 335 336 3 sg13_lv_pmos L=0.13u W=0.42u AS=0.1428p AD=0.0798p PS=1.52u
+ PD=0.8u
M$2072 3 354 336 3 sg13_lv_pmos L=0.13u W=0.42u AS=0.3623875p AD=0.0798p
+ PS=2.605u PD=0.8u
M$2073 3 381 337 3 sg13_lv_pmos L=0.13u W=1u AS=0.3623875p AD=0.34p PS=2.605u
+ PD=2.68u
M$2074 3 111 354 3 sg13_lv_pmos L=0.13u W=1.12u AS=0.3808p AD=0.3808p PS=2.92u
+ PD=2.92u
M$2075 381 354 3 3 sg13_lv_pmos L=0.13u W=0.42u AS=0.147p AD=0.1563p PS=1.54u
+ PD=1.22u
M$2076 3 337 387 3 sg13_lv_pmos L=0.13u W=0.42u AS=0.1563p AD=0.063p PS=1.22u
+ PD=0.72u
M$2077 387 338 381 3 sg13_lv_pmos L=0.13u W=0.42u AS=0.063p AD=0.0798p PS=0.72u
+ PD=0.8u
M$2078 381 382 336 3 sg13_lv_pmos L=0.13u W=0.42u AS=0.0798p AD=0.1428p PS=0.8u
+ PD=1.52u
M$2085 396 405 3 3 sg13_lv_pmos L=0.13u W=1.12u AS=0.6048p AD=0.2198p PS=3.32u
+ PD=1.52u
M$2086 3 392 401 3 sg13_lv_pmos L=0.13u W=1u AS=0.2198p AD=0.2975p PS=1.52u
+ PD=1.595u
M$2087 401 227 405 3 sg13_lv_pmos L=0.13u W=1u AS=0.2975p AD=0.2225p PS=1.595u
+ PD=1.445u
M$2088 405 286 402 3 sg13_lv_pmos L=0.13u W=1u AS=0.2225p AD=0.3325p PS=1.445u
+ PD=1.665u
M$2089 402 107 3 3 sg13_lv_pmos L=0.13u W=1u AS=0.3325p AD=0.253p PS=1.665u
+ PD=1.53u
M$2090 3 107 392 3 sg13_lv_pmos L=0.13u W=0.84u AS=0.253p AD=0.2856p PS=1.53u
+ PD=2.36u
M$2091 3 414 413 3 sg13_lv_pmos L=0.13u W=6.72u AS=1.4448p AD=1.2768p PS=10.42u
+ PD=9u
M$2097 3 413 415 3 sg13_lv_pmos L=0.13u W=17.92u AS=3.4048p AD=3.5896p PS=24u
+ PD=25.45u
M$2114 3 394 403 3 sg13_lv_pmos L=0.13u W=1.12u AS=0.4032p AD=0.1176p PS=2.96u
+ PD=1.33u
M$2115 403 346 397 3 sg13_lv_pmos L=0.13u W=1.12u AS=0.1176p AD=0.3808p
+ PS=1.33u PD=2.92u
M$2116 398 327 3 3 sg13_lv_pmos L=0.13u W=1.12u AS=0.3808p AD=0.2128p PS=2.92u
+ PD=1.5u
M$2117 3 348 398 3 sg13_lv_pmos L=0.13u W=1.12u AS=0.2128p AD=0.2128p PS=1.5u
+ PD=1.5u
M$2118 398 346 399 3 sg13_lv_pmos L=0.13u W=1.12u AS=0.2128p AD=0.3808p PS=1.5u
+ PD=2.92u
M$2119 3 397 420 3 sg13_lv_pmos L=0.13u W=0.84u AS=0.4536p AD=0.1596p PS=2.76u
+ PD=1.22u
M$2120 3 349 420 3 sg13_lv_pmos L=0.13u W=0.84u AS=0.2891p AD=0.1596p PS=1.695u
+ PD=1.22u
M$2121 3 397 429 3 sg13_lv_pmos L=0.13u W=1.12u AS=0.2891p AD=0.1428p PS=1.695u
+ PD=1.375u
M$2122 429 349 416 3 sg13_lv_pmos L=0.13u W=1.12u AS=0.1428p AD=0.2408p
+ PS=1.375u PD=1.55u
M$2123 416 420 3 3 sg13_lv_pmos L=0.13u W=1.12u AS=0.2408p AD=0.3808p PS=1.55u
+ PD=2.92u
M$2124 3 270 400 3 sg13_lv_pmos L=0.13u W=1.12u AS=0.3808p AD=0.2128p PS=2.92u
+ PD=1.5u
M$2125 400 397 3 3 sg13_lv_pmos L=0.13u W=1.12u AS=0.2128p AD=0.3808p PS=1.5u
+ PD=2.92u
M$2126 417 422 428 3 sg13_lv_pmos L=0.13u W=1.12u AS=0.3808p AD=0.1176p
+ PS=2.92u PD=1.33u
M$2127 428 423 3 3 sg13_lv_pmos L=0.13u W=1.12u AS=0.1176p AD=0.4032p PS=1.33u
+ PD=2.96u
M$2128 418 424 427 3 sg13_lv_pmos L=0.13u W=1.12u AS=0.3808p AD=0.2128p
+ PS=2.92u PD=1.5u
M$2129 427 423 3 3 sg13_lv_pmos L=0.13u W=1.12u AS=0.2128p AD=0.2128p PS=1.5u
+ PD=1.5u
M$2130 3 422 427 3 sg13_lv_pmos L=0.13u W=1.12u AS=0.2128p AD=0.3808p PS=1.5u
+ PD=2.92u
M$2131 3 463 419 3 sg13_lv_pmos L=0.13u W=1.12u AS=0.3808p AD=0.3808p PS=2.92u
+ PD=2.92u
M$2165 430 443 3 3 sg13_lv_pmos L=0.13u W=0.84u AS=0.2856p AD=0.2114p PS=2.36u
+ PD=1.54u
M$2166 3 430 107 3 sg13_lv_pmos L=0.13u W=1.12u AS=0.2114p AD=0.42p PS=1.54u
+ PD=2.99u
M$2168 431 459 3 3 sg13_lv_pmos L=0.13u W=1.12u AS=0.6048p AD=0.2198p PS=3.32u
+ PD=1.52u
M$2169 3 432 452 3 sg13_lv_pmos L=0.13u W=1u AS=0.2198p AD=0.2975p PS=1.52u
+ PD=1.595u
M$2170 452 286 459 3 sg13_lv_pmos L=0.13u W=1u AS=0.2975p AD=0.2225p PS=1.595u
+ PD=1.445u
M$2171 459 460 454 3 sg13_lv_pmos L=0.13u W=1u AS=0.2225p AD=0.3325p PS=1.445u
+ PD=1.665u
M$2172 454 107 3 3 sg13_lv_pmos L=0.13u W=1u AS=0.3325p AD=0.253p PS=1.665u
+ PD=1.53u
M$2173 3 107 432 3 sg13_lv_pmos L=0.13u W=0.84u AS=0.253p AD=0.2856p PS=1.53u
+ PD=2.36u
M$2183 3 461 433 3 sg13_lv_pmos L=0.13u W=0.84u AS=0.4536p AD=0.1596p PS=2.76u
+ PD=1.22u
M$2184 3 444 433 3 sg13_lv_pmos L=0.13u W=0.84u AS=0.2891p AD=0.1596p PS=1.695u
+ PD=1.22u
M$2185 3 461 456 3 sg13_lv_pmos L=0.13u W=1.12u AS=0.2891p AD=0.1428p PS=1.695u
+ PD=1.375u
M$2186 456 444 347 3 sg13_lv_pmos L=0.13u W=1.12u AS=0.1428p AD=0.2408p
+ PS=1.375u PD=1.55u
M$2187 347 433 3 3 sg13_lv_pmos L=0.13u W=1.12u AS=0.2408p AD=0.3808p PS=1.55u
+ PD=2.92u
M$2205 434 445 435 3 sg13_lv_pmos L=0.13u W=1.12u AS=0.3808p AD=0.2128p
+ PS=2.92u PD=1.5u
M$2206 435 423 3 3 sg13_lv_pmos L=0.13u W=1.12u AS=0.2128p AD=0.2128p PS=1.5u
+ PD=1.5u
M$2207 3 422 435 3 sg13_lv_pmos L=0.13u W=1.12u AS=0.2128p AD=0.3808p PS=1.5u
+ PD=2.92u
M$2208 3 445 457 3 sg13_lv_pmos L=0.13u W=1.12u AS=0.3808p AD=0.2464p PS=2.92u
+ PD=1.56u
M$2209 457 462 458 3 sg13_lv_pmos L=0.13u W=1.12u AS=0.2464p AD=0.2128p
+ PS=1.56u PD=1.5u
M$2210 458 417 436 3 sg13_lv_pmos L=0.13u W=1.12u AS=0.2128p AD=0.3808p PS=1.5u
+ PD=2.92u
M$2211 437 446 438 3 sg13_lv_pmos L=0.13u W=1.12u AS=0.3808p AD=0.2128p
+ PS=2.92u PD=1.5u
M$2212 438 422 3 3 sg13_lv_pmos L=0.13u W=1.12u AS=0.2128p AD=0.2128p PS=1.5u
+ PD=1.5u
M$2213 3 445 438 3 sg13_lv_pmos L=0.13u W=1.12u AS=0.2128p AD=0.3808p PS=1.5u
+ PD=2.92u
M$2214 3 463 439 3 sg13_lv_pmos L=0.13u W=1.12u AS=0.3808p AD=0.3808p PS=2.92u
+ PD=2.92u
M$2215 3 418 440 3 sg13_lv_pmos L=0.13u W=0.42u AS=0.1428p AD=0.0798p PS=1.52u
+ PD=0.8u
M$2216 3 419 440 3 sg13_lv_pmos L=0.13u W=0.42u AS=0.3623875p AD=0.0798p
+ PS=2.605u PD=0.8u
M$2217 3 441 447 3 sg13_lv_pmos L=0.13u W=1u AS=0.3623875p AD=0.34p PS=2.605u
+ PD=2.68u
M$2218 3 419 441 3 sg13_lv_pmos L=0.13u W=0.42u AS=0.1563p AD=0.147p PS=1.22u
+ PD=1.54u
M$2219 3 447 455 3 sg13_lv_pmos L=0.13u W=0.42u AS=0.1563p AD=0.063p PS=1.22u
+ PD=0.72u
M$2220 455 449 441 3 sg13_lv_pmos L=0.13u W=0.42u AS=0.063p AD=0.0798p PS=0.72u
+ PD=0.8u
M$2221 441 448 440 3 sg13_lv_pmos L=0.13u W=0.42u AS=0.0798p AD=0.1428p PS=0.8u
+ PD=1.52u
M$2222 3 449 448 3 sg13_lv_pmos L=0.13u W=1.12u AS=0.41165p AD=0.3864p PS=2.12u
+ PD=2.93u
M$2223 3 462 449 3 sg13_lv_pmos L=0.13u W=1.12u AS=0.41165p AD=0.4088p PS=2.12u
+ PD=2.97u
M$2224 447 449 450 3 sg13_lv_pmos L=0.13u W=1u AS=0.34p AD=0.2048p PS=2.68u
+ PD=1.63u
M$2225 450 448 453 3 sg13_lv_pmos L=0.13u W=0.42u AS=0.2048p AD=0.09345p
+ PS=1.63u PD=0.865u
M$2226 3 451 453 3 sg13_lv_pmos L=0.13u W=0.42u AS=0.204p AD=0.09345p PS=1.835u
+ PD=0.865u
M$2227 3 419 451 3 sg13_lv_pmos L=0.13u W=0.42u AS=0.204p AD=0.0798p PS=1.835u
+ PD=0.8u
M$2228 3 450 451 3 sg13_lv_pmos L=0.13u W=0.42u AS=0.4659p AD=0.0798p PS=3.65u
+ PD=0.8u
M$2229 442 450 3 3 sg13_lv_pmos L=0.13u W=1.12u AS=0.3864p AD=0.2128p PS=2.93u
+ PD=1.5u
M$2230 3 442 423 3 sg13_lv_pmos L=0.13u W=1.12u AS=0.2128p AD=0.3808p PS=1.5u
+ PD=2.92u
M$2232 3 74 483 3 sg13_lv_pmos L=0.13u W=1.12u AS=0.3808p AD=0.3808p PS=2.92u
+ PD=2.92u
M$2233 3 431 484 3 sg13_lv_pmos L=0.13u W=0.42u AS=0.1428p AD=0.0798p PS=1.52u
+ PD=0.8u
M$2234 3 483 484 3 sg13_lv_pmos L=0.13u W=0.42u AS=0.3623875p AD=0.0798p
+ PS=2.605u PD=0.8u
M$2235 3 532 475 3 sg13_lv_pmos L=0.13u W=1u AS=0.3623875p AD=0.34p PS=2.605u
+ PD=2.68u
M$2236 533 476 3 3 sg13_lv_pmos L=0.13u W=1.12u AS=0.3864p AD=0.41165p PS=2.93u
+ PD=2.12u
M$2237 3 597 476 3 sg13_lv_pmos L=0.13u W=1.12u AS=0.41165p AD=0.4088p PS=2.12u
+ PD=2.97u
M$2238 487 533 543 3 sg13_lv_pmos L=0.13u W=0.42u AS=0.2048p AD=0.09345p
+ PS=1.63u PD=0.865u
M$2239 543 488 3 3 sg13_lv_pmos L=0.13u W=0.42u AS=0.09345p AD=0.204p PS=0.865u
+ PD=1.835u
M$2240 3 483 488 3 sg13_lv_pmos L=0.13u W=0.42u AS=0.204p AD=0.0798p PS=1.835u
+ PD=0.8u
M$2241 488 487 3 3 sg13_lv_pmos L=0.13u W=0.42u AS=0.0798p AD=0.4659p PS=0.8u
+ PD=3.65u
M$2242 475 476 487 3 sg13_lv_pmos L=0.13u W=1u AS=0.34p AD=0.2048p PS=2.68u
+ PD=1.63u
M$2243 489 487 3 3 sg13_lv_pmos L=0.13u W=1.12u AS=0.3864p AD=0.2128p PS=2.93u
+ PD=1.5u
M$2244 3 489 460 3 sg13_lv_pmos L=0.13u W=1.12u AS=0.2128p AD=0.3808p PS=1.5u
+ PD=2.92u
M$2245 3 460 490 3 sg13_lv_pmos L=0.13u W=1.12u AS=0.3808p AD=0.2128p PS=2.92u
+ PD=1.5u
M$2246 490 530 3 3 sg13_lv_pmos L=0.13u W=1.12u AS=0.2128p AD=0.3808p PS=1.5u
+ PD=2.92u
M$2247 3 460 545 3 sg13_lv_pmos L=0.13u W=1u AS=0.36p AD=0.1225p PS=2.72u
+ PD=1.245u
M$2248 545 530 491 3 sg13_lv_pmos L=0.13u W=1u AS=0.1225p AD=0.34p PS=1.245u
+ PD=2.68u
M$2249 540 460 3 3 sg13_lv_pmos L=0.13u W=1.12u AS=0.3808p AD=0.2128p PS=2.92u
+ PD=1.5u
M$2250 3 530 540 3 sg13_lv_pmos L=0.13u W=1.12u AS=0.2128p AD=0.2128p PS=1.5u
+ PD=1.5u
M$2251 540 491 444 3 sg13_lv_pmos L=0.13u W=1.12u AS=0.2128p AD=0.3808p PS=1.5u
+ PD=2.92u
M$2253 3 565 492 3 sg13_lv_pmos L=0.13u W=1.12u AS=0.3808p AD=0.2128p PS=2.92u
+ PD=1.5u
M$2254 492 531 3 3 sg13_lv_pmos L=0.13u W=1.12u AS=0.2128p AD=0.2128p PS=1.5u
+ PD=1.5u
M$2255 3 490 492 3 sg13_lv_pmos L=0.13u W=1.12u AS=0.2128p AD=0.3808p PS=1.5u
+ PD=2.92u
M$2256 3 444 531 3 sg13_lv_pmos L=0.13u W=1.12u AS=0.3808p AD=0.2128p PS=2.92u
+ PD=1.5u
M$2257 531 461 3 3 sg13_lv_pmos L=0.13u W=1.12u AS=0.2128p AD=0.3808p PS=1.5u
+ PD=2.92u
M$2262 3 463 493 3 sg13_lv_pmos L=0.13u W=1.12u AS=0.3808p AD=0.3808p PS=2.92u
+ PD=2.92u
M$2263 3 416 494 3 sg13_lv_pmos L=0.13u W=0.42u AS=0.1428p AD=0.0798p PS=1.52u
+ PD=0.8u
M$2264 3 493 494 3 sg13_lv_pmos L=0.13u W=0.42u AS=0.3623875p AD=0.0798p
+ PS=2.605u PD=0.8u
M$2265 3 534 477 3 sg13_lv_pmos L=0.13u W=1u AS=0.3623875p AD=0.34p PS=2.605u
+ PD=2.68u
M$2266 535 478 3 3 sg13_lv_pmos L=0.13u W=1.12u AS=0.3864p AD=0.41165p PS=2.93u
+ PD=2.12u
M$2267 3 115 478 3 sg13_lv_pmos L=0.13u W=1.12u AS=0.41165p AD=0.4088p PS=2.12u
+ PD=2.97u
M$2268 497 535 549 3 sg13_lv_pmos L=0.13u W=0.42u AS=0.2048p AD=0.09345p
+ PS=1.63u PD=0.865u
M$2269 549 498 3 3 sg13_lv_pmos L=0.13u W=0.42u AS=0.09345p AD=0.204p PS=0.865u
+ PD=1.835u
M$2270 3 493 498 3 sg13_lv_pmos L=0.13u W=0.42u AS=0.204p AD=0.0798p PS=1.835u
+ PD=0.8u
M$2271 498 497 3 3 sg13_lv_pmos L=0.13u W=0.42u AS=0.0798p AD=0.4659p PS=0.8u
+ PD=3.65u
M$2272 477 478 497 3 sg13_lv_pmos L=0.13u W=1u AS=0.34p AD=0.2048p PS=2.68u
+ PD=1.63u
M$2273 499 497 3 3 sg13_lv_pmos L=0.13u W=1.12u AS=0.3864p AD=0.2128p PS=2.93u
+ PD=1.5u
M$2274 3 499 461 3 sg13_lv_pmos L=0.13u W=1.12u AS=0.2128p AD=0.3808p PS=1.5u
+ PD=2.92u
M$2275 3 463 500 3 sg13_lv_pmos L=0.13u W=1.12u AS=0.3808p AD=0.3808p PS=2.92u
+ PD=2.92u
M$2276 3 434 501 3 sg13_lv_pmos L=0.13u W=0.42u AS=0.1428p AD=0.0798p PS=1.52u
+ PD=0.8u
M$2277 3 500 501 3 sg13_lv_pmos L=0.13u W=0.42u AS=0.3623875p AD=0.0798p
+ PS=2.605u PD=0.8u
M$2278 3 536 479 3 sg13_lv_pmos L=0.13u W=1u AS=0.3623875p AD=0.34p PS=2.605u
+ PD=2.68u
M$2279 537 480 3 3 sg13_lv_pmos L=0.13u W=1.12u AS=0.3864p AD=0.41165p PS=2.93u
+ PD=2.12u
M$2280 3 462 480 3 sg13_lv_pmos L=0.13u W=1.12u AS=0.41165p AD=0.4088p PS=2.12u
+ PD=2.97u
M$2281 504 537 546 3 sg13_lv_pmos L=0.13u W=0.42u AS=0.2048p AD=0.09345p
+ PS=1.63u PD=0.865u
M$2282 546 505 3 3 sg13_lv_pmos L=0.13u W=0.42u AS=0.09345p AD=0.204p PS=0.865u
+ PD=1.835u
M$2283 3 500 505 3 sg13_lv_pmos L=0.13u W=0.42u AS=0.204p AD=0.0798p PS=1.835u
+ PD=0.8u
M$2284 505 504 3 3 sg13_lv_pmos L=0.13u W=0.42u AS=0.0798p AD=0.4659p PS=0.8u
+ PD=3.65u
M$2285 479 480 504 3 sg13_lv_pmos L=0.13u W=1u AS=0.34p AD=0.2048p PS=2.68u
+ PD=1.63u
M$2286 506 504 3 3 sg13_lv_pmos L=0.13u W=1.12u AS=0.3864p AD=0.2128p PS=2.93u
+ PD=1.5u
M$2287 3 506 445 3 sg13_lv_pmos L=0.13u W=1.12u AS=0.2128p AD=0.3808p PS=1.5u
+ PD=2.92u
M$2288 3 437 507 3 sg13_lv_pmos L=0.13u W=0.42u AS=0.1428p AD=0.0798p PS=1.52u
+ PD=0.8u
M$2289 3 439 507 3 sg13_lv_pmos L=0.13u W=0.42u AS=0.3623875p AD=0.0798p
+ PS=2.605u PD=0.8u
M$2290 3 538 481 3 sg13_lv_pmos L=0.13u W=1u AS=0.3623875p AD=0.34p PS=2.605u
+ PD=2.68u
M$2291 539 482 3 3 sg13_lv_pmos L=0.13u W=1.12u AS=0.3864p AD=0.41165p PS=2.93u
+ PD=2.12u
M$2292 3 462 482 3 sg13_lv_pmos L=0.13u W=1.12u AS=0.41165p AD=0.4088p PS=2.12u
+ PD=2.97u
M$2293 510 539 542 3 sg13_lv_pmos L=0.13u W=0.42u AS=0.2048p AD=0.09345p
+ PS=1.63u PD=0.865u
M$2294 542 511 3 3 sg13_lv_pmos L=0.13u W=0.42u AS=0.09345p AD=0.204p PS=0.865u
+ PD=1.835u
M$2295 3 439 511 3 sg13_lv_pmos L=0.13u W=0.42u AS=0.204p AD=0.0798p PS=1.835u
+ PD=0.8u
M$2296 511 510 3 3 sg13_lv_pmos L=0.13u W=0.42u AS=0.0798p AD=0.4659p PS=0.8u
+ PD=3.65u
M$2297 481 482 510 3 sg13_lv_pmos L=0.13u W=1u AS=0.34p AD=0.2048p PS=2.68u
+ PD=1.63u
M$2298 512 510 3 3 sg13_lv_pmos L=0.13u W=1.12u AS=0.3864p AD=0.2128p PS=2.93u
+ PD=1.5u
M$2299 3 512 422 3 sg13_lv_pmos L=0.13u W=1.12u AS=0.2128p AD=0.3808p PS=1.5u
+ PD=2.92u
M$2300 551 74 3 3 sg13_lv_pmos L=0.13u W=1.12u AS=0.3808p AD=0.3808p PS=2.92u
+ PD=2.92u
M$2301 3 570 552 3 sg13_lv_pmos L=0.13u W=0.84u AS=0.2114p AD=0.2856p PS=1.54u
+ PD=2.36u
M$2302 74 552 3 3 sg13_lv_pmos L=0.13u W=1.12u AS=0.42p AD=0.2114p PS=2.99u
+ PD=1.54u
M$2303 532 483 3 3 sg13_lv_pmos L=0.13u W=0.42u AS=0.147p AD=0.1563p PS=1.54u
+ PD=1.22u
M$2304 3 475 541 3 sg13_lv_pmos L=0.13u W=0.42u AS=0.1563p AD=0.063p PS=1.22u
+ PD=0.72u
M$2305 541 476 532 3 sg13_lv_pmos L=0.13u W=0.42u AS=0.063p AD=0.0798p PS=0.72u
+ PD=0.8u
M$2306 532 533 484 3 sg13_lv_pmos L=0.13u W=0.42u AS=0.0798p AD=0.1428p PS=0.8u
+ PD=1.52u
M$2307 559 557 3 3 sg13_lv_pmos L=0.13u W=1.12u AS=0.3864p AD=0.2128p PS=2.93u
+ PD=1.5u
M$2308 3 559 560 3 sg13_lv_pmos L=0.13u W=1.12u AS=0.2128p AD=0.3808p PS=1.5u
+ PD=2.92u
M$2309 3 560 577 3 sg13_lv_pmos L=0.13u W=1u AS=0.36p AD=0.1225p PS=2.72u
+ PD=1.245u
M$2310 577 530 561 3 sg13_lv_pmos L=0.13u W=1u AS=0.1225p AD=0.34p PS=1.245u
+ PD=2.68u
M$2311 562 560 3 3 sg13_lv_pmos L=0.13u W=1.12u AS=0.3808p AD=0.2128p PS=2.92u
+ PD=1.5u
M$2312 3 530 562 3 sg13_lv_pmos L=0.13u W=1.12u AS=0.2128p AD=0.2128p PS=1.5u
+ PD=1.5u
M$2313 562 561 563 3 sg13_lv_pmos L=0.13u W=1.12u AS=0.2128p AD=0.3808p PS=1.5u
+ PD=2.92u
M$2315 3 574 564 3 sg13_lv_pmos L=0.13u W=0.84u AS=0.4536p AD=0.1596p PS=2.76u
+ PD=1.22u
M$2316 3 563 564 3 sg13_lv_pmos L=0.13u W=0.84u AS=0.2891p AD=0.1596p PS=1.695u
+ PD=1.22u
M$2317 3 574 578 3 sg13_lv_pmos L=0.13u W=1.12u AS=0.2891p AD=0.1428p PS=1.695u
+ PD=1.375u
M$2318 578 563 565 3 sg13_lv_pmos L=0.13u W=1.12u AS=0.1428p AD=0.2408p
+ PS=1.375u PD=1.55u
M$2319 565 564 3 3 sg13_lv_pmos L=0.13u W=1.12u AS=0.2408p AD=0.3808p PS=1.55u
+ PD=2.92u
M$2320 566 565 567 3 sg13_lv_pmos L=0.13u W=1.12u AS=0.3808p AD=0.2128p
+ PS=2.92u PD=1.5u
M$2321 567 490 3 3 sg13_lv_pmos L=0.13u W=1.12u AS=0.2128p AD=0.2128p PS=1.5u
+ PD=1.5u
M$2322 3 531 567 3 sg13_lv_pmos L=0.13u W=1.12u AS=0.2128p AD=0.3808p PS=1.5u
+ PD=2.92u
M$2331 534 493 3 3 sg13_lv_pmos L=0.13u W=0.42u AS=0.147p AD=0.1563p PS=1.54u
+ PD=1.22u
M$2332 3 477 548 3 sg13_lv_pmos L=0.13u W=0.42u AS=0.1563p AD=0.063p PS=1.22u
+ PD=0.72u
M$2333 548 478 534 3 sg13_lv_pmos L=0.13u W=0.42u AS=0.063p AD=0.0798p PS=0.72u
+ PD=0.8u
M$2334 534 535 494 3 sg13_lv_pmos L=0.13u W=0.42u AS=0.0798p AD=0.1428p PS=0.8u
+ PD=1.52u
M$2343 536 500 3 3 sg13_lv_pmos L=0.13u W=0.42u AS=0.147p AD=0.1563p PS=1.54u
+ PD=1.22u
M$2344 3 479 547 3 sg13_lv_pmos L=0.13u W=0.42u AS=0.1563p AD=0.063p PS=1.22u
+ PD=0.72u
M$2345 547 480 536 3 sg13_lv_pmos L=0.13u W=0.42u AS=0.063p AD=0.0798p PS=0.72u
+ PD=0.8u
M$2346 536 537 501 3 sg13_lv_pmos L=0.13u W=0.42u AS=0.0798p AD=0.1428p PS=0.8u
+ PD=1.52u
M$2348 3 530 580 3 sg13_lv_pmos L=0.15u W=1.12u AS=0.3808p AD=0.2128p PS=2.92u
+ PD=1.5u
M$2349 580 575 550 3 sg13_lv_pmos L=0.15u W=1.12u AS=0.2128p AD=0.2128p PS=1.5u
+ PD=1.5u
M$2350 550 436 3 3 sg13_lv_pmos L=0.15u W=1.12u AS=0.2128p AD=0.3808p PS=1.5u
+ PD=2.92u
M$2351 3 422 579 3 sg13_lv_pmos L=0.15u W=1.12u AS=0.3808p AD=0.2128p PS=2.92u
+ PD=1.5u
M$2352 579 445 446 3 sg13_lv_pmos L=0.15u W=1.12u AS=0.2128p AD=0.2128p PS=1.5u
+ PD=1.5u
M$2353 446 575 3 3 sg13_lv_pmos L=0.15u W=1.12u AS=0.2128p AD=0.3808p PS=1.5u
+ PD=2.92u
M$2354 3 423 575 3 sg13_lv_pmos L=0.13u W=1.12u AS=0.3808p AD=0.2128p PS=2.92u
+ PD=1.5u
M$2355 575 422 3 3 sg13_lv_pmos L=0.13u W=1.12u AS=0.2128p AD=0.3808p PS=1.5u
+ PD=2.92u
M$2356 568 445 3 3 sg13_lv_pmos L=0.13u W=1.12u AS=0.3808p AD=0.2128p PS=2.92u
+ PD=1.5u
M$2357 3 422 568 3 sg13_lv_pmos L=0.13u W=1.12u AS=0.2128p AD=0.2128p PS=1.5u
+ PD=1.5u
M$2358 568 423 424 3 sg13_lv_pmos L=0.13u W=1.12u AS=0.2128p AD=0.3808p PS=1.5u
+ PD=2.92u
M$2361 538 439 3 3 sg13_lv_pmos L=0.13u W=0.42u AS=0.147p AD=0.1563p PS=1.54u
+ PD=1.22u
M$2362 3 481 544 3 sg13_lv_pmos L=0.13u W=0.42u AS=0.1563p AD=0.063p PS=1.22u
+ PD=0.72u
M$2363 544 482 538 3 sg13_lv_pmos L=0.13u W=0.42u AS=0.063p AD=0.0798p PS=0.72u
+ PD=0.8u
M$2364 538 539 507 3 sg13_lv_pmos L=0.13u W=0.42u AS=0.0798p AD=0.1428p PS=0.8u
+ PD=1.52u
M$2370 3 571 553 3 sg13_lv_pmos L=0.13u W=0.42u AS=0.1428p AD=0.0798p PS=1.52u
+ PD=0.8u
M$2371 3 551 553 3 sg13_lv_pmos L=0.13u W=0.42u AS=0.3623875p AD=0.0798p
+ PS=2.605u PD=0.8u
M$2372 3 555 554 3 sg13_lv_pmos L=0.13u W=1u AS=0.3623875p AD=0.34p PS=2.605u
+ PD=2.68u
M$2373 3 107 615 3 sg13_lv_pmos L=0.13u W=0.84u AS=0.253p AD=0.2856p PS=1.53u
+ PD=2.36u
M$2374 3 615 623 3 sg13_lv_pmos L=0.13u W=1u AS=0.2198p AD=0.2975p PS=1.52u
+ PD=1.595u
M$2375 623 460 593 3 sg13_lv_pmos L=0.13u W=1u AS=0.2975p AD=0.2225p PS=1.595u
+ PD=1.445u
M$2376 593 560 624 3 sg13_lv_pmos L=0.13u W=1u AS=0.2225p AD=0.3325p PS=1.445u
+ PD=1.665u
M$2377 624 107 3 3 sg13_lv_pmos L=0.13u W=1u AS=0.3325p AD=0.253p PS=1.665u
+ PD=1.53u
M$2378 571 593 3 3 sg13_lv_pmos L=0.13u W=1.12u AS=0.6048p AD=0.2198p PS=3.32u
+ PD=1.52u
M$2379 3 551 555 3 sg13_lv_pmos L=0.13u W=0.42u AS=0.1563p AD=0.147p PS=1.22u
+ PD=1.54u
M$2380 3 554 569 3 sg13_lv_pmos L=0.13u W=0.42u AS=0.1563p AD=0.063p PS=1.22u
+ PD=0.72u
M$2381 569 573 555 3 sg13_lv_pmos L=0.13u W=0.42u AS=0.063p AD=0.0798p PS=0.72u
+ PD=0.8u
M$2382 555 556 553 3 sg13_lv_pmos L=0.13u W=0.42u AS=0.0798p AD=0.1428p PS=0.8u
+ PD=1.52u
M$2383 3 573 556 3 sg13_lv_pmos L=0.13u W=1.12u AS=0.41165p AD=0.3864p PS=2.12u
+ PD=2.93u
M$2384 3 597 573 3 sg13_lv_pmos L=0.13u W=1.12u AS=0.41165p AD=0.4088p PS=2.12u
+ PD=2.97u
M$2385 596 597 3 3 sg13_lv_pmos L=0.13u W=1.12u AS=0.3808p AD=0.3808p PS=2.92u
+ PD=2.92u
M$2386 3 598 597 3 sg13_lv_pmos L=0.13u W=17.92u AS=3.5896p AD=3.4048p
+ PS=25.45u PD=24u
M$2402 3 415 598 3 sg13_lv_pmos L=0.13u W=6.72u AS=1.2768p AD=1.4448p PS=9u
+ PD=10.42u
M$2408 554 573 557 3 sg13_lv_pmos L=0.13u W=1u AS=0.34p AD=0.2048p PS=2.68u
+ PD=1.63u
M$2409 557 556 576 3 sg13_lv_pmos L=0.13u W=0.42u AS=0.2048p AD=0.09345p
+ PS=1.63u PD=0.865u
M$2410 3 558 576 3 sg13_lv_pmos L=0.13u W=0.42u AS=0.204p AD=0.09345p PS=1.835u
+ PD=0.865u
M$2411 3 551 558 3 sg13_lv_pmos L=0.13u W=0.42u AS=0.204p AD=0.0798p PS=1.835u
+ PD=0.8u
M$2412 3 557 558 3 sg13_lv_pmos L=0.13u W=0.42u AS=0.4659p AD=0.0798p PS=3.65u
+ PD=0.8u
M$2413 3 563 599 3 sg13_lv_pmos L=0.13u W=1.12u AS=0.3808p AD=0.2128p PS=2.92u
+ PD=1.5u
M$2414 599 574 3 3 sg13_lv_pmos L=0.13u W=1.12u AS=0.2128p AD=0.3808p PS=1.5u
+ PD=2.92u
M$2415 600 492 3 3 sg13_lv_pmos L=0.13u W=0.84u AS=0.2856p AD=0.2618p PS=2.36u
+ PD=1.63u
M$2416 3 600 625 3 sg13_lv_pmos L=0.13u W=1.12u AS=0.2618p AD=0.1176p PS=1.63u
+ PD=1.33u
M$2417 625 566 601 3 sg13_lv_pmos L=0.13u W=1.12u AS=0.1176p AD=0.3808p
+ PS=1.33u PD=2.92u
M$2418 622 395 3 3 sg13_lv_pmos L=0.13u W=1.12u AS=0.3808p AD=0.2128p PS=2.92u
+ PD=1.5u
M$2419 3 601 622 3 sg13_lv_pmos L=0.13u W=1.12u AS=0.2128p AD=0.2128p PS=1.5u
+ PD=1.5u
M$2420 622 602 603 3 sg13_lv_pmos L=0.13u W=1.12u AS=0.2128p AD=0.3808p PS=1.5u
+ PD=2.92u
M$2421 3 463 604 3 sg13_lv_pmos L=0.13u W=1.12u AS=0.3808p AD=0.3808p PS=2.92u
+ PD=2.92u
M$2422 621 595 3 3 sg13_lv_pmos L=0.13u W=1.12u AS=0.3864p AD=0.41165p PS=2.93u
+ PD=2.12u
M$2423 3 247 595 3 sg13_lv_pmos L=0.13u W=1.12u AS=0.41165p AD=0.4088p PS=2.12u
+ PD=2.97u
M$2424 608 621 628 3 sg13_lv_pmos L=0.13u W=0.42u AS=0.2048p AD=0.09345p
+ PS=1.63u PD=0.865u
M$2425 628 609 3 3 sg13_lv_pmos L=0.13u W=0.42u AS=0.09345p AD=0.204p PS=0.865u
+ PD=1.835u
M$2426 3 604 609 3 sg13_lv_pmos L=0.13u W=0.42u AS=0.204p AD=0.0798p PS=1.835u
+ PD=0.8u
M$2427 609 608 3 3 sg13_lv_pmos L=0.13u W=0.42u AS=0.0798p AD=0.4659p PS=0.8u
+ PD=3.65u
M$2428 594 595 608 3 sg13_lv_pmos L=0.13u W=1u AS=0.34p AD=0.2048p PS=2.68u
+ PD=1.63u
M$2429 610 608 3 3 sg13_lv_pmos L=0.13u W=1.12u AS=0.3864p AD=0.2128p PS=2.93u
+ PD=1.5u
M$2430 3 610 574 3 sg13_lv_pmos L=0.13u W=1.12u AS=0.2128p AD=0.3808p PS=1.5u
+ PD=2.92u
M$2431 530 611 3 3 sg13_lv_pmos L=0.13u W=1.12u AS=0.42p AD=0.2114p PS=2.99u
+ PD=1.54u
M$2432 3 719 611 3 sg13_lv_pmos L=0.13u W=0.84u AS=0.2114p AD=0.2856p PS=1.54u
+ PD=2.36u
M$2457 3 395 626 3 sg13_lv_pmos L=0.13u W=1u AS=0.36p AD=0.1225p PS=2.72u
+ PD=1.245u
M$2458 626 601 602 3 sg13_lv_pmos L=0.13u W=1u AS=0.1225p AD=0.34p PS=1.245u
+ PD=2.68u
M$2461 3 603 605 3 sg13_lv_pmos L=0.13u W=0.42u AS=0.1428p AD=0.0798p PS=1.52u
+ PD=0.8u
M$2462 3 604 605 3 sg13_lv_pmos L=0.13u W=0.42u AS=0.3623875p AD=0.0798p
+ PS=2.605u PD=0.8u
M$2463 3 616 594 3 sg13_lv_pmos L=0.13u W=1u AS=0.3623875p AD=0.34p PS=2.605u
+ PD=2.68u
M$2466 616 604 3 3 sg13_lv_pmos L=0.13u W=0.42u AS=0.147p AD=0.1563p PS=1.54u
+ PD=1.22u
M$2467 3 594 627 3 sg13_lv_pmos L=0.13u W=0.42u AS=0.1563p AD=0.063p PS=1.22u
+ PD=0.72u
M$2468 627 595 616 3 sg13_lv_pmos L=0.13u W=0.42u AS=0.063p AD=0.0798p PS=0.72u
+ PD=0.8u
M$2469 616 621 605 3 sg13_lv_pmos L=0.13u W=0.42u AS=0.0798p AD=0.1428p PS=0.8u
+ PD=1.52u
M$2509 3 107 668 3 sg13_lv_pmos L=0.13u W=0.84u AS=0.253p AD=0.2856p PS=1.53u
+ PD=2.36u
M$2510 3 668 676 3 sg13_lv_pmos L=0.13u W=1u AS=0.2198p AD=0.2975p PS=1.52u
+ PD=1.595u
M$2511 676 560 633 3 sg13_lv_pmos L=0.13u W=1u AS=0.2975p AD=0.2225p PS=1.595u
+ PD=1.445u
M$2512 633 669 677 3 sg13_lv_pmos L=0.13u W=1u AS=0.2225p AD=0.3325p PS=1.445u
+ PD=1.665u
M$2513 677 107 3 3 sg13_lv_pmos L=0.13u W=1u AS=0.3325p AD=0.253p PS=1.665u
+ PD=1.53u
M$2514 632 633 3 3 sg13_lv_pmos L=0.13u W=1.12u AS=0.6048p AD=0.2198p PS=3.32u
+ PD=1.52u
M$2520 3 560 634 3 sg13_lv_pmos L=0.13u W=1.12u AS=0.3808p AD=0.2128p PS=2.92u
+ PD=1.5u
M$2521 634 530 3 3 sg13_lv_pmos L=0.13u W=1.12u AS=0.2128p AD=0.3808p PS=1.5u
+ PD=2.92u
M$2522 672 599 3 3 sg13_lv_pmos L=0.13u W=1.12u AS=0.3808p AD=0.2128p PS=2.92u
+ PD=1.5u
M$2523 3 634 672 3 sg13_lv_pmos L=0.13u W=1.12u AS=0.2128p AD=0.2128p PS=1.5u
+ PD=1.5u
M$2524 672 670 646 3 sg13_lv_pmos L=0.13u W=1.12u AS=0.2128p AD=0.3808p PS=1.5u
+ PD=2.92u
M$2525 3 670 635 3 sg13_lv_pmos L=0.13u W=1.12u AS=0.3808p AD=0.2128p PS=2.92u
+ PD=1.5u
M$2526 635 599 3 3 sg13_lv_pmos L=0.13u W=1.12u AS=0.2128p AD=0.2128p PS=1.5u
+ PD=1.5u
M$2527 3 634 635 3 sg13_lv_pmos L=0.13u W=1.12u AS=0.2128p AD=0.3808p PS=1.5u
+ PD=2.92u
M$2528 647 635 3 3 sg13_lv_pmos L=0.13u W=0.84u AS=0.2856p AD=0.2618p PS=2.36u
+ PD=1.63u
M$2529 3 647 680 3 sg13_lv_pmos L=0.13u W=1.12u AS=0.2618p AD=0.1176p PS=1.63u
+ PD=1.33u
M$2530 680 646 636 3 sg13_lv_pmos L=0.13u W=1.12u AS=0.1176p AD=0.3808p
+ PS=1.33u PD=2.92u
M$2531 3 635 674 3 sg13_lv_pmos L=0.13u W=1.12u AS=0.3808p AD=0.2128p PS=2.92u
+ PD=1.5u
M$2532 674 566 3 3 sg13_lv_pmos L=0.13u W=1.12u AS=0.2128p AD=0.3808p PS=1.5u
+ PD=2.92u
M$2533 675 649 674 3 sg13_lv_pmos L=0.13u W=1.12u AS=0.3808p AD=0.2128p
+ PS=2.92u PD=1.5u
M$2534 674 395 675 3 sg13_lv_pmos L=0.13u W=1.12u AS=0.2128p AD=0.2128p PS=1.5u
+ PD=1.5u
M$2535 675 646 648 3 sg13_lv_pmos L=0.13u W=1.12u AS=0.2128p AD=0.3808p PS=1.5u
+ PD=2.92u
M$2536 629 566 630 3 sg13_lv_pmos L=0.13u W=1.12u AS=0.3808p AD=0.2128p
+ PS=2.92u PD=1.5u
M$2537 630 395 3 3 sg13_lv_pmos L=0.13u W=1.12u AS=0.2128p AD=0.2128p PS=1.5u
+ PD=1.5u
M$2538 3 601 630 3 sg13_lv_pmos L=0.13u W=1.12u AS=0.2128p AD=0.3808p PS=1.5u
+ PD=2.92u
M$2539 649 650 3 3 sg13_lv_pmos L=0.13u W=1.12u AS=0.3808p AD=0.1918p PS=2.92u
+ PD=1.5u
M$2540 3 636 650 3 sg13_lv_pmos L=0.13u W=0.84u AS=0.1918p AD=0.1596p PS=1.5u
+ PD=1.22u
M$2541 650 601 3 3 sg13_lv_pmos L=0.13u W=0.84u AS=0.1596p AD=0.2856p PS=1.22u
+ PD=2.36u
M$2555 3 463 637 3 sg13_lv_pmos L=0.13u W=1.12u AS=0.3808p AD=0.3808p PS=2.92u
+ PD=2.92u
M$2556 651 652 3 3 sg13_lv_pmos L=0.13u W=1.12u AS=0.3808p AD=0.1918p PS=2.92u
+ PD=1.5u
M$2557 3 550 652 3 sg13_lv_pmos L=0.13u W=0.84u AS=0.1918p AD=0.1596p PS=1.5u
+ PD=1.22u
M$2558 652 638 3 3 sg13_lv_pmos L=0.13u W=0.84u AS=0.1596p AD=0.2856p PS=1.22u
+ PD=2.36u
M$2560 3 111 639 3 sg13_lv_pmos L=0.13u W=1.12u AS=0.3808p AD=0.3808p PS=2.92u
+ PD=2.92u
M$2561 3 638 640 3 sg13_lv_pmos L=0.13u W=0.42u AS=0.1428p AD=0.0798p PS=1.52u
+ PD=0.8u
M$2562 3 639 640 3 sg13_lv_pmos L=0.13u W=0.42u AS=0.3623875p AD=0.0798p
+ PS=2.605u PD=0.8u
M$2563 3 671 641 3 sg13_lv_pmos L=0.13u W=1u AS=0.3623875p AD=0.34p PS=2.605u
+ PD=2.68u
M$2564 673 642 3 3 sg13_lv_pmos L=0.13u W=1.12u AS=0.3864p AD=0.41165p PS=2.93u
+ PD=2.12u
M$2565 3 726 642 3 sg13_lv_pmos L=0.13u W=1.12u AS=0.41165p AD=0.4088p PS=2.12u
+ PD=2.97u
M$2566 654 673 678 3 sg13_lv_pmos L=0.13u W=0.42u AS=0.2048p AD=0.09345p
+ PS=1.63u PD=0.865u
M$2567 678 644 3 3 sg13_lv_pmos L=0.13u W=0.42u AS=0.09345p AD=0.204p PS=0.865u
+ PD=1.835u
M$2568 3 639 644 3 sg13_lv_pmos L=0.13u W=0.42u AS=0.204p AD=0.0798p PS=1.835u
+ PD=0.8u
M$2569 644 654 3 3 sg13_lv_pmos L=0.13u W=0.42u AS=0.0798p AD=0.4659p PS=0.8u
+ PD=3.65u
M$2570 641 642 654 3 sg13_lv_pmos L=0.13u W=1u AS=0.34p AD=0.2048p PS=2.68u
+ PD=1.63u
M$2571 645 654 3 3 sg13_lv_pmos L=0.13u W=1.12u AS=0.3864p AD=0.2128p PS=2.93u
+ PD=1.5u
M$2572 3 645 462 3 sg13_lv_pmos L=0.13u W=1.12u AS=0.2128p AD=0.3808p PS=1.5u
+ PD=2.92u
M$2575 3 715 685 3 sg13_lv_pmos L=0.13u W=1.12u AS=0.3808p AD=0.3808p PS=2.92u
+ PD=2.92u
M$2576 3 735 681 3 sg13_lv_pmos L=0.13u W=0.42u AS=0.1428p AD=0.0798p PS=1.52u
+ PD=0.8u
M$2577 3 714 681 3 sg13_lv_pmos L=0.13u W=0.42u AS=0.3623875p AD=0.0798p
+ PS=2.605u PD=0.8u
M$2578 3 687 686 3 sg13_lv_pmos L=0.13u W=1u AS=0.3623875p AD=0.34p PS=2.605u
+ PD=2.68u
M$2579 3 714 687 3 sg13_lv_pmos L=0.13u W=0.42u AS=0.1563p AD=0.147p PS=1.22u
+ PD=1.54u
M$2580 3 686 711 3 sg13_lv_pmos L=0.13u W=0.42u AS=0.1563p AD=0.063p PS=1.22u
+ PD=0.72u
M$2581 711 716 687 3 sg13_lv_pmos L=0.13u W=0.42u AS=0.063p AD=0.0798p PS=0.72u
+ PD=0.8u
M$2582 687 688 681 3 sg13_lv_pmos L=0.13u W=0.42u AS=0.0798p AD=0.1428p PS=0.8u
+ PD=1.52u
M$2583 3 716 688 3 sg13_lv_pmos L=0.13u W=1.12u AS=0.41165p AD=0.3864p PS=2.12u
+ PD=2.93u
M$2584 3 597 716 3 sg13_lv_pmos L=0.13u W=1.12u AS=0.41165p AD=0.4088p PS=2.12u
+ PD=2.97u
M$2585 686 716 717 3 sg13_lv_pmos L=0.13u W=1u AS=0.34p AD=0.2048p PS=2.68u
+ PD=1.63u
M$2586 717 688 731 3 sg13_lv_pmos L=0.13u W=0.42u AS=0.2048p AD=0.09345p
+ PS=1.63u PD=0.865u
M$2587 3 718 731 3 sg13_lv_pmos L=0.13u W=0.42u AS=0.204p AD=0.09345p PS=1.835u
+ PD=0.865u
M$2588 3 714 718 3 sg13_lv_pmos L=0.13u W=0.42u AS=0.204p AD=0.0798p PS=1.835u
+ PD=0.8u
M$2589 3 717 718 3 sg13_lv_pmos L=0.13u W=0.42u AS=0.4659p AD=0.0798p PS=3.65u
+ PD=0.8u
M$2590 689 717 3 3 sg13_lv_pmos L=0.13u W=1.12u AS=0.3864p AD=0.2128p PS=2.93u
+ PD=1.5u
M$2591 3 689 690 3 sg13_lv_pmos L=0.13u W=1.12u AS=0.2128p AD=0.3808p PS=1.5u
+ PD=2.92u
M$2592 3 669 691 3 sg13_lv_pmos L=0.13u W=0.84u AS=0.2618p AD=0.2856p PS=1.63u
+ PD=2.36u
M$2593 3 691 732 3 sg13_lv_pmos L=0.13u W=1.12u AS=0.2618p AD=0.1176p PS=1.63u
+ PD=1.33u
M$2594 732 719 692 3 sg13_lv_pmos L=0.13u W=1.12u AS=0.1176p AD=0.3808p
+ PS=1.33u PD=2.92u
M$2595 693 692 694 3 sg13_lv_pmos L=0.13u W=1.12u AS=0.3808p AD=0.2128p
+ PS=2.92u PD=1.5u
M$2596 694 720 3 3 sg13_lv_pmos L=0.13u W=1.12u AS=0.2128p AD=0.2128p PS=1.5u
+ PD=1.5u
M$2597 3 721 694 3 sg13_lv_pmos L=0.13u W=1.12u AS=0.2128p AD=0.3808p PS=1.5u
+ PD=2.92u
M$2602 3 636 695 3 sg13_lv_pmos L=0.13u W=0.84u AS=0.4536p AD=0.1596p PS=2.76u
+ PD=1.22u
M$2603 3 629 695 3 sg13_lv_pmos L=0.13u W=0.84u AS=0.2891p AD=0.1596p PS=1.695u
+ PD=1.22u
M$2604 3 636 734 3 sg13_lv_pmos L=0.13u W=1.12u AS=0.2891p AD=0.1428p PS=1.695u
+ PD=1.375u
M$2605 734 629 696 3 sg13_lv_pmos L=0.13u W=1.12u AS=0.1428p AD=0.2408p
+ PS=1.375u PD=1.55u
M$2606 696 695 3 3 sg13_lv_pmos L=0.13u W=1.12u AS=0.2408p AD=0.3808p PS=1.55u
+ PD=2.92u
M$2607 3 696 682 3 sg13_lv_pmos L=0.13u W=0.42u AS=0.1428p AD=0.0798p PS=1.52u
+ PD=0.8u
M$2608 3 683 682 3 sg13_lv_pmos L=0.13u W=0.42u AS=0.3623875p AD=0.0798p
+ PS=2.605u PD=0.8u
M$2609 3 698 697 3 sg13_lv_pmos L=0.13u W=1u AS=0.3623875p AD=0.34p PS=2.605u
+ PD=2.68u
M$2610 3 683 698 3 sg13_lv_pmos L=0.13u W=0.42u AS=0.1563p AD=0.147p PS=1.22u
+ PD=1.54u
M$2611 3 697 713 3 sg13_lv_pmos L=0.13u W=0.42u AS=0.1563p AD=0.063p PS=1.22u
+ PD=0.72u
M$2612 713 722 698 3 sg13_lv_pmos L=0.13u W=0.42u AS=0.063p AD=0.0798p PS=0.72u
+ PD=0.8u
M$2613 698 699 682 3 sg13_lv_pmos L=0.13u W=0.42u AS=0.0798p AD=0.1428p PS=0.8u
+ PD=1.52u
M$2614 3 722 699 3 sg13_lv_pmos L=0.13u W=1.12u AS=0.41165p AD=0.3864p PS=2.12u
+ PD=2.93u
M$2615 3 247 722 3 sg13_lv_pmos L=0.13u W=1.12u AS=0.41165p AD=0.4088p PS=2.12u
+ PD=2.97u
M$2616 697 722 723 3 sg13_lv_pmos L=0.13u W=1u AS=0.34p AD=0.2048p PS=2.68u
+ PD=1.63u
M$2617 723 699 733 3 sg13_lv_pmos L=0.13u W=0.42u AS=0.2048p AD=0.09345p
+ PS=1.63u PD=0.865u
M$2618 3 724 733 3 sg13_lv_pmos L=0.13u W=0.42u AS=0.204p AD=0.09345p PS=1.835u
+ PD=0.865u
M$2619 3 683 724 3 sg13_lv_pmos L=0.13u W=0.42u AS=0.204p AD=0.0798p PS=1.835u
+ PD=0.8u
M$2620 3 723 724 3 sg13_lv_pmos L=0.13u W=0.42u AS=0.4659p AD=0.0798p PS=3.65u
+ PD=0.8u
M$2621 700 723 3 3 sg13_lv_pmos L=0.13u W=1.12u AS=0.3864p AD=0.2128p PS=2.93u
+ PD=1.5u
M$2622 3 700 720 3 sg13_lv_pmos L=0.13u W=1.12u AS=0.2128p AD=0.3808p PS=1.5u
+ PD=2.92u
M$2625 701 725 3 3 sg13_lv_pmos L=0.13u W=1.12u AS=0.3808p AD=0.3808p PS=2.92u
+ PD=2.92u
M$2626 3 463 702 3 sg13_lv_pmos L=0.13u W=1.12u AS=0.3808p AD=0.3808p PS=2.92u
+ PD=2.92u
M$2628 703 726 3 3 sg13_lv_pmos L=0.13u W=1.12u AS=0.3808p AD=0.3808p PS=2.92u
+ PD=2.92u
M$2629 3 651 684 3 sg13_lv_pmos L=0.13u W=0.42u AS=0.1428p AD=0.0798p PS=1.52u
+ PD=0.8u
M$2630 3 637 684 3 sg13_lv_pmos L=0.13u W=0.42u AS=0.3623875p AD=0.0798p
+ PS=2.605u PD=0.8u
M$2631 3 705 704 3 sg13_lv_pmos L=0.13u W=1u AS=0.3623875p AD=0.34p PS=2.605u
+ PD=2.68u
M$2632 3 637 705 3 sg13_lv_pmos L=0.13u W=0.42u AS=0.1563p AD=0.147p PS=1.22u
+ PD=1.54u
M$2633 3 704 712 3 sg13_lv_pmos L=0.13u W=0.42u AS=0.1563p AD=0.063p PS=1.22u
+ PD=0.72u
M$2634 712 727 705 3 sg13_lv_pmos L=0.13u W=0.42u AS=0.063p AD=0.0798p PS=0.72u
+ PD=0.8u
M$2635 705 706 684 3 sg13_lv_pmos L=0.13u W=0.42u AS=0.0798p AD=0.1428p PS=0.8u
+ PD=1.52u
M$2636 3 727 706 3 sg13_lv_pmos L=0.13u W=1.12u AS=0.41165p AD=0.3864p PS=2.12u
+ PD=2.93u
M$2637 3 726 727 3 sg13_lv_pmos L=0.13u W=1.12u AS=0.41165p AD=0.4088p PS=2.12u
+ PD=2.97u
M$2638 704 727 728 3 sg13_lv_pmos L=0.13u W=1u AS=0.34p AD=0.2048p PS=2.68u
+ PD=1.63u
M$2639 728 706 730 3 sg13_lv_pmos L=0.13u W=0.42u AS=0.2048p AD=0.09345p
+ PS=1.63u PD=0.865u
M$2640 3 729 730 3 sg13_lv_pmos L=0.13u W=0.42u AS=0.204p AD=0.09345p PS=1.835u
+ PD=0.865u
M$2641 3 637 729 3 sg13_lv_pmos L=0.13u W=0.42u AS=0.204p AD=0.0798p PS=1.835u
+ PD=0.8u
M$2642 3 728 729 3 sg13_lv_pmos L=0.13u W=0.42u AS=0.4659p AD=0.0798p PS=3.65u
+ PD=0.8u
M$2643 671 639 3 3 sg13_lv_pmos L=0.13u W=0.42u AS=0.147p AD=0.1563p PS=1.54u
+ PD=1.22u
M$2644 3 641 679 3 sg13_lv_pmos L=0.13u W=0.42u AS=0.1563p AD=0.063p PS=1.22u
+ PD=0.72u
M$2645 679 642 671 3 sg13_lv_pmos L=0.13u W=0.42u AS=0.063p AD=0.0798p PS=0.72u
+ PD=0.8u
M$2646 671 673 640 3 sg13_lv_pmos L=0.13u W=0.42u AS=0.0798p AD=0.1428p PS=0.8u
+ PD=1.52u
M$2647 707 728 3 3 sg13_lv_pmos L=0.13u W=1.12u AS=0.3864p AD=0.2128p PS=2.93u
+ PD=1.5u
M$2648 3 707 708 3 sg13_lv_pmos L=0.13u W=1.12u AS=0.2128p AD=0.3808p PS=1.5u
+ PD=2.92u
M$2649 3 111 709 3 sg13_lv_pmos L=0.13u W=1.12u AS=0.3808p AD=0.3808p PS=2.92u
+ PD=2.92u
M$2650 3 708 710 3 sg13_lv_pmos L=0.13u W=1.12u AS=0.3808p AD=0.3808p PS=2.92u
+ PD=2.92u
M$2655 714 715 3 3 sg13_lv_pmos L=0.13u W=1.12u AS=0.3808p AD=0.3808p PS=2.92u
+ PD=2.92u
M$2656 715 761 3 3 sg13_lv_pmos L=0.13u W=1.12u AS=0.42p AD=0.2114p PS=2.99u
+ PD=1.54u
M$2657 3 570 761 3 sg13_lv_pmos L=0.13u W=0.84u AS=0.2114p AD=0.2856p PS=1.54u
+ PD=2.36u
M$2658 816 755 3 3 sg13_lv_pmos L=0.13u W=1.12u AS=0.3864p AD=0.41165p PS=2.93u
+ PD=2.12u
M$2659 3 597 755 3 sg13_lv_pmos L=0.13u W=1.12u AS=0.41165p AD=0.4088p PS=2.12u
+ PD=2.97u
M$2660 765 816 823 3 sg13_lv_pmos L=0.13u W=0.42u AS=0.2048p AD=0.09345p
+ PS=1.63u PD=0.865u
M$2661 823 766 3 3 sg13_lv_pmos L=0.13u W=0.42u AS=0.09345p AD=0.204p PS=0.865u
+ PD=1.835u
M$2662 3 685 766 3 sg13_lv_pmos L=0.13u W=0.42u AS=0.204p AD=0.0798p PS=1.835u
+ PD=0.8u
M$2663 766 765 3 3 sg13_lv_pmos L=0.13u W=0.42u AS=0.0798p AD=0.4659p PS=0.8u
+ PD=3.65u
M$2664 754 755 765 3 sg13_lv_pmos L=0.13u W=1u AS=0.34p AD=0.2048p PS=2.68u
+ PD=1.63u
M$2665 767 765 3 3 sg13_lv_pmos L=0.13u W=1.12u AS=0.3864p AD=0.2128p PS=2.93u
+ PD=1.5u
M$2666 3 767 669 3 sg13_lv_pmos L=0.13u W=1.12u AS=0.2128p AD=0.3808p PS=1.5u
+ PD=2.92u
M$2667 820 690 3 3 sg13_lv_pmos L=0.13u W=1.12u AS=0.3808p AD=0.2128p PS=2.92u
+ PD=1.5u
M$2668 3 693 820 3 sg13_lv_pmos L=0.13u W=1.12u AS=0.2128p AD=0.2128p PS=1.5u
+ PD=1.5u
M$2669 820 768 769 3 sg13_lv_pmos L=0.13u W=1.12u AS=0.2128p AD=0.3808p PS=1.5u
+ PD=2.92u
M$2670 3 720 770 3 sg13_lv_pmos L=0.13u W=0.84u AS=0.4536p AD=0.1596p PS=2.76u
+ PD=1.22u
M$2671 3 721 770 3 sg13_lv_pmos L=0.13u W=0.84u AS=0.2891p AD=0.1596p PS=1.695u
+ PD=1.22u
M$2672 3 720 826 3 sg13_lv_pmos L=0.13u W=1.12u AS=0.2891p AD=0.1428p PS=1.695u
+ PD=1.375u
M$2673 826 721 670 3 sg13_lv_pmos L=0.13u W=1.12u AS=0.1428p AD=0.2408p
+ PS=1.375u PD=1.55u
M$2674 670 770 3 3 sg13_lv_pmos L=0.13u W=1.12u AS=0.2408p AD=0.3808p PS=1.55u
+ PD=2.92u
M$2675 3 648 772 3 sg13_lv_pmos L=0.13u W=0.84u AS=0.4536p AD=0.1596p PS=2.76u
+ PD=1.22u
M$2676 3 769 772 3 sg13_lv_pmos L=0.13u W=0.84u AS=0.2891p AD=0.1596p PS=1.695u
+ PD=1.22u
M$2677 3 648 827 3 sg13_lv_pmos L=0.13u W=1.12u AS=0.2891p AD=0.1428p PS=1.695u
+ PD=1.375u
M$2678 827 769 808 3 sg13_lv_pmos L=0.13u W=1.12u AS=0.1428p AD=0.2408p
+ PS=1.375u PD=1.55u
M$2679 808 772 3 3 sg13_lv_pmos L=0.13u W=1.12u AS=0.2408p AD=0.3808p PS=1.55u
+ PD=2.92u
M$2680 3 715 683 3 sg13_lv_pmos L=0.13u W=1.12u AS=0.3808p AD=0.3808p PS=2.92u
+ PD=2.92u
M$2681 3 715 774 3 sg13_lv_pmos L=0.13u W=1.12u AS=0.3808p AD=0.3808p PS=2.92u
+ PD=2.92u
M$2682 817 757 3 3 sg13_lv_pmos L=0.13u W=1.12u AS=0.3864p AD=0.41165p PS=2.93u
+ PD=2.12u
M$2683 3 247 757 3 sg13_lv_pmos L=0.13u W=1.12u AS=0.41165p AD=0.4088p PS=2.12u
+ PD=2.97u
M$2684 778 817 830 3 sg13_lv_pmos L=0.13u W=0.42u AS=0.2048p AD=0.09345p
+ PS=1.63u PD=0.865u
M$2685 830 779 3 3 sg13_lv_pmos L=0.13u W=0.42u AS=0.09345p AD=0.204p PS=0.865u
+ PD=1.835u
M$2686 3 774 779 3 sg13_lv_pmos L=0.13u W=0.42u AS=0.204p AD=0.0798p PS=1.835u
+ PD=0.8u
M$2687 779 778 3 3 sg13_lv_pmos L=0.13u W=0.42u AS=0.0798p AD=0.4659p PS=0.8u
+ PD=3.65u
M$2688 756 757 778 3 sg13_lv_pmos L=0.13u W=1u AS=0.34p AD=0.2048p PS=2.68u
+ PD=1.63u
M$2689 780 778 3 3 sg13_lv_pmos L=0.13u W=1.12u AS=0.3864p AD=0.2128p PS=2.93u
+ PD=1.5u
M$2690 3 780 719 3 sg13_lv_pmos L=0.13u W=1.12u AS=0.2128p AD=0.3808p PS=1.5u
+ PD=2.92u
M$2691 781 463 3 3 sg13_lv_pmos L=0.13u W=1.12u AS=0.3808p AD=0.3808p PS=2.92u
+ PD=2.92u
M$2692 818 759 3 3 sg13_lv_pmos L=0.13u W=1.12u AS=0.3864p AD=0.41165p PS=2.93u
+ PD=2.12u
M$2693 3 725 759 3 sg13_lv_pmos L=0.13u W=1.12u AS=0.41165p AD=0.4088p PS=2.12u
+ PD=2.97u
M$2694 785 818 828 3 sg13_lv_pmos L=0.13u W=0.42u AS=0.2048p AD=0.09345p
+ PS=1.63u PD=0.865u
M$2695 828 786 3 3 sg13_lv_pmos L=0.13u W=0.42u AS=0.09345p AD=0.204p PS=0.865u
+ PD=1.835u
M$2696 3 702 786 3 sg13_lv_pmos L=0.13u W=0.42u AS=0.204p AD=0.0798p PS=1.835u
+ PD=0.8u
M$2697 786 785 3 3 sg13_lv_pmos L=0.13u W=0.42u AS=0.0798p AD=0.4659p PS=0.8u
+ PD=3.65u
M$2698 758 759 785 3 sg13_lv_pmos L=0.13u W=1u AS=0.34p AD=0.2048p PS=2.68u
+ PD=1.63u
M$2699 787 785 3 3 sg13_lv_pmos L=0.13u W=1.12u AS=0.3864p AD=0.2128p PS=2.93u
+ PD=1.5u
M$2700 3 787 726 3 sg13_lv_pmos L=0.13u W=1.12u AS=0.2128p AD=0.3808p PS=1.5u
+ PD=2.92u
M$2701 638 788 3 3 sg13_lv_pmos L=0.13u W=1.12u AS=0.3808p AD=0.2128p PS=2.92u
+ PD=1.5u
M$2702 3 811 788 3 sg13_lv_pmos L=0.13u W=1.12u AS=0.2128p AD=0.3864p PS=1.5u
+ PD=2.93u
M$2703 3 811 789 3 sg13_lv_pmos L=0.13u W=0.42u AS=0.4659p AD=0.0798p PS=3.65u
+ PD=0.8u
M$2704 789 709 3 3 sg13_lv_pmos L=0.13u W=0.42u AS=0.0798p AD=0.204p PS=0.8u
+ PD=1.835u
M$2705 3 789 824 3 sg13_lv_pmos L=0.13u W=0.42u AS=0.204p AD=0.09345p PS=1.835u
+ PD=0.865u
M$2706 824 792 811 3 sg13_lv_pmos L=0.13u W=0.42u AS=0.09345p AD=0.2048p
+ PS=0.865u PD=1.63u
M$2707 811 791 760 3 sg13_lv_pmos L=0.13u W=1u AS=0.2048p AD=0.34p PS=1.63u
+ PD=2.68u
M$2708 791 726 3 3 sg13_lv_pmos L=0.13u W=1.12u AS=0.4088p AD=0.41165p PS=2.97u
+ PD=2.12u
M$2709 3 791 792 3 sg13_lv_pmos L=0.13u W=1.12u AS=0.41165p AD=0.3864p PS=2.12u
+ PD=2.93u
M$2710 3 632 762 3 sg13_lv_pmos L=0.13u W=0.42u AS=0.1428p AD=0.0798p PS=1.52u
+ PD=0.8u
M$2711 3 685 762 3 sg13_lv_pmos L=0.13u W=0.42u AS=0.3623875p AD=0.0798p
+ PS=2.605u PD=0.8u
M$2712 3 807 754 3 sg13_lv_pmos L=0.13u W=1u AS=0.3623875p AD=0.34p PS=2.605u
+ PD=2.68u
M$2713 807 685 3 3 sg13_lv_pmos L=0.13u W=0.42u AS=0.147p AD=0.1563p PS=1.54u
+ PD=1.22u
M$2714 3 754 821 3 sg13_lv_pmos L=0.13u W=0.42u AS=0.1563p AD=0.063p PS=1.22u
+ PD=0.72u
M$2715 821 755 807 3 sg13_lv_pmos L=0.13u W=0.42u AS=0.063p AD=0.0798p PS=0.72u
+ PD=0.8u
M$2716 807 816 762 3 sg13_lv_pmos L=0.13u W=0.42u AS=0.0798p AD=0.1428p PS=0.8u
+ PD=1.52u
M$2721 3 690 825 3 sg13_lv_pmos L=0.13u W=1u AS=0.36p AD=0.1225p PS=2.72u
+ PD=1.245u
M$2722 825 693 768 3 sg13_lv_pmos L=0.13u W=1u AS=0.1225p AD=0.34p PS=1.245u
+ PD=2.68u
M$2734 3 808 775 3 sg13_lv_pmos L=0.13u W=0.42u AS=0.1428p AD=0.0798p PS=1.52u
+ PD=0.8u
M$2735 3 774 775 3 sg13_lv_pmos L=0.13u W=0.42u AS=0.3623875p AD=0.0798p
+ PS=2.605u PD=0.8u
M$2736 3 809 756 3 sg13_lv_pmos L=0.13u W=1u AS=0.3623875p AD=0.34p PS=2.605u
+ PD=2.68u
M$2737 809 774 3 3 sg13_lv_pmos L=0.13u W=0.42u AS=0.147p AD=0.1563p PS=1.54u
+ PD=1.22u
M$2738 3 756 829 3 sg13_lv_pmos L=0.13u W=0.42u AS=0.1563p AD=0.063p PS=1.22u
+ PD=0.72u
M$2739 829 757 809 3 sg13_lv_pmos L=0.13u W=0.42u AS=0.063p AD=0.0798p PS=0.72u
+ PD=0.8u
M$2740 809 817 775 3 sg13_lv_pmos L=0.13u W=0.42u AS=0.0798p AD=0.1428p PS=0.8u
+ PD=1.52u
M$2743 3 703 782 3 sg13_lv_pmos L=0.13u W=0.42u AS=0.1428p AD=0.0798p PS=1.52u
+ PD=0.8u
M$2744 3 702 782 3 sg13_lv_pmos L=0.13u W=0.42u AS=0.3623875p AD=0.0798p
+ PS=2.605u PD=0.8u
M$2745 3 810 758 3 sg13_lv_pmos L=0.13u W=1u AS=0.3623875p AD=0.34p PS=2.605u
+ PD=2.68u
M$2746 810 702 3 3 sg13_lv_pmos L=0.13u W=0.42u AS=0.147p AD=0.1563p PS=1.54u
+ PD=1.22u
M$2747 3 758 831 3 sg13_lv_pmos L=0.13u W=0.42u AS=0.1563p AD=0.063p PS=1.22u
+ PD=0.72u
M$2748 831 759 810 3 sg13_lv_pmos L=0.13u W=0.42u AS=0.063p AD=0.0798p PS=0.72u
+ PD=0.8u
M$2749 810 818 782 3 sg13_lv_pmos L=0.13u W=0.42u AS=0.0798p AD=0.1428p PS=0.8u
+ PD=1.52u
M$2763 793 792 812 3 sg13_lv_pmos L=0.13u W=0.42u AS=0.1428p AD=0.0798p
+ PS=1.52u PD=0.8u
M$2764 812 791 822 3 sg13_lv_pmos L=0.13u W=0.42u AS=0.0798p AD=0.063p PS=0.8u
+ PD=0.72u
M$2765 822 760 3 3 sg13_lv_pmos L=0.13u W=0.42u AS=0.063p AD=0.1563p PS=0.72u
+ PD=1.22u
M$2766 3 709 812 3 sg13_lv_pmos L=0.13u W=0.42u AS=0.1563p AD=0.147p PS=1.22u
+ PD=1.54u
M$2767 3 709 793 3 sg13_lv_pmos L=0.13u W=0.42u AS=0.3623875p AD=0.0798p
+ PS=2.605u PD=0.8u
M$2768 793 710 3 3 sg13_lv_pmos L=0.13u W=0.42u AS=0.0798p AD=0.1428p PS=0.8u
+ PD=1.52u
M$2769 760 812 3 3 sg13_lv_pmos L=0.13u W=1u AS=0.34p AD=0.3623875p PS=2.68u
+ PD=2.605u
M$2775 833 819 3 3 sg13_lv_pmos L=0.13u W=0.84u AS=0.2856p AD=0.2114p PS=2.36u
+ PD=1.54u
M$2776 3 833 570 3 sg13_lv_pmos L=0.13u W=1.12u AS=0.2114p AD=0.42p PS=1.54u
+ PD=2.99u
M$2780 735 849 3 3 sg13_lv_pmos L=0.13u W=1.12u AS=0.6048p AD=0.2198p PS=3.32u
+ PD=1.52u
M$2781 3 832 844 3 sg13_lv_pmos L=0.13u W=1u AS=0.2198p AD=0.2975p PS=1.52u
+ PD=1.595u
M$2782 844 669 849 3 sg13_lv_pmos L=0.13u W=1u AS=0.2975p AD=0.2225p PS=1.595u
+ PD=1.445u
M$2783 849 690 845 3 sg13_lv_pmos L=0.13u W=1u AS=0.2225p AD=0.3325p PS=1.445u
+ PD=1.665u
M$2784 845 107 3 3 sg13_lv_pmos L=0.13u W=1u AS=0.3325p AD=0.253p PS=1.665u
+ PD=1.53u
M$2785 3 107 832 3 sg13_lv_pmos L=0.13u W=0.84u AS=0.253p AD=0.2856p PS=1.53u
+ PD=2.36u
M$2792 3 669 834 3 sg13_lv_pmos L=0.13u W=0.84u AS=0.4536p AD=0.1596p PS=2.76u
+ PD=1.22u
M$2793 3 719 834 3 sg13_lv_pmos L=0.13u W=0.84u AS=0.2891p AD=0.1596p PS=1.695u
+ PD=1.22u
M$2794 3 669 846 3 sg13_lv_pmos L=0.13u W=1.12u AS=0.2891p AD=0.1428p PS=1.695u
+ PD=1.375u
M$2795 846 719 721 3 sg13_lv_pmos L=0.13u W=1.12u AS=0.1428p AD=0.2408p
+ PS=1.375u PD=1.55u
M$2796 721 834 3 3 sg13_lv_pmos L=0.13u W=1.12u AS=0.2408p AD=0.3808p PS=1.55u
+ PD=2.92u
M$2813 835 570 3 3 sg13_lv_pmos L=0.13u W=0.84u AS=0.2856p AD=0.2114p PS=2.36u
+ PD=1.54u
M$2814 3 835 111 3 sg13_lv_pmos L=0.13u W=1.12u AS=0.2114p AD=0.42p PS=1.54u
+ PD=2.99u
M$2815 3 701 836 3 sg13_lv_pmos L=0.13u W=0.42u AS=0.1428p AD=0.0798p PS=1.52u
+ PD=0.8u
M$2816 3 781 836 3 sg13_lv_pmos L=0.13u W=0.42u AS=0.3623875p AD=0.0798p
+ PS=2.605u PD=0.8u
M$2817 3 837 838 3 sg13_lv_pmos L=0.13u W=1u AS=0.3623875p AD=0.34p PS=2.605u
+ PD=2.68u
M$2818 3 781 837 3 sg13_lv_pmos L=0.13u W=0.42u AS=0.1563p AD=0.147p PS=1.22u
+ PD=1.54u
M$2819 3 838 847 3 sg13_lv_pmos L=0.13u W=0.42u AS=0.1563p AD=0.063p PS=1.22u
+ PD=0.72u
M$2820 847 840 837 3 sg13_lv_pmos L=0.13u W=0.42u AS=0.063p AD=0.0798p PS=0.72u
+ PD=0.8u
M$2821 837 839 836 3 sg13_lv_pmos L=0.13u W=0.42u AS=0.0798p AD=0.1428p PS=0.8u
+ PD=1.52u
M$2822 463 860 3 3 sg13_lv_pmos L=0.13u W=1.12u AS=0.42p AD=0.2114p PS=2.99u
+ PD=1.54u
M$2823 3 111 860 3 sg13_lv_pmos L=0.13u W=0.84u AS=0.2114p AD=0.2856p PS=1.54u
+ PD=2.36u
M$2826 3 840 839 3 sg13_lv_pmos L=0.13u W=1.12u AS=0.41165p AD=0.3864p PS=2.12u
+ PD=2.93u
M$2827 3 850 840 3 sg13_lv_pmos L=0.13u W=1.12u AS=0.41165p AD=0.4088p PS=2.12u
+ PD=2.97u
M$2830 838 840 841 3 sg13_lv_pmos L=0.13u W=1u AS=0.34p AD=0.2048p PS=2.68u
+ PD=1.63u
M$2831 841 839 848 3 sg13_lv_pmos L=0.13u W=0.42u AS=0.2048p AD=0.09345p
+ PS=1.63u PD=0.865u
M$2832 3 842 848 3 sg13_lv_pmos L=0.13u W=0.42u AS=0.204p AD=0.09345p PS=1.835u
+ PD=0.865u
M$2833 3 781 842 3 sg13_lv_pmos L=0.13u W=0.42u AS=0.204p AD=0.0798p PS=1.835u
+ PD=0.8u
M$2834 3 841 842 3 sg13_lv_pmos L=0.13u W=0.42u AS=0.4659p AD=0.0798p PS=3.65u
+ PD=0.8u
M$2837 843 841 3 3 sg13_lv_pmos L=0.13u W=1.12u AS=0.3864p AD=0.2128p PS=2.93u
+ PD=1.5u
M$2838 3 843 725 3 sg13_lv_pmos L=0.13u W=1.12u AS=0.2128p AD=0.3808p PS=1.5u
+ PD=2.92u
.ENDS dsm_and_freq_divider
