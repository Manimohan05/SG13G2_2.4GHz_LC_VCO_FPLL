# Ansys Electronics Desktop project, version 2018.0
project variables:
  $W = 30um  # optimise 7um..21um
  $F_S = 50um
  $R_out = 230um  # optimise 47.5um..142.5um
  $Theta = 22.5deg
  $R_diag = $R_out/cos($Theta)
  $R_diag3 = $R_T3/cos(22.5deg)
  $R_T3 = $R_out -2*($W+$S)
  $S = 11um  # optimise 4um..12um
  $R_diag2 = $R_T2/cos(22.5deg)
  $R_T2 = $R_out -($W+$S)
materials:
  activ: conductivity=357141
  air: permittivity=1.0006 permeability=1.0000004
  Cont: conductivity=2390000
  copper: permeability=0.999991 conductivity=58000000
  EPI: permittivity=11.9 conductivity=5
  FOX: permittivity=3.9
  FR4_epoxy: permittivity=4.4 dielectric_loss_tangent=0.02
  LOWLOSS: conductivity=10000000000
  met1: permittivity=1 conductivity=22200000
  met2: permittivity=1 conductivity=22200000
  met3: permittivity=1 conductivity=25179400
  met4: permittivity=1 conductivity=25179400
  met5: permittivity=1 conductivity=27847400
  Metal1: conductivity=21640000
  Metal4: conductivity=23190000
  Metal5: conductivity=23190000
  MIM_equiv: permittivity=16.87
  Passive: permittivity=6.6
  pec: conductivity=1e+030
  silicon_dioxide: permittivity=4
  Sub: permittivity=11.9 conductivity=2
  Sub_Metal1: permittivity=4.5
  Sub_Metal2: permittivity=4.2
  Sub_Metal3: permittivity=4.1
  Sub_Metal4: permittivity=4
  Sub_Metal5: permittivity=3.5
  TopMetal1: conductivity=27800000
  TopMetal2: conductivity=30300000
  TopVia1: conductivity=2191000
  TopVia2: conductivity=3143000
  vacuum: permittivity=1
  via1: permittivity=1 conductivity=3620000
  via2: permittivity=1 conductivity=3490000
  Via3: conductivity=1660000
  Via4: conductivity=1660000

design EMDesign1 (HFSS 3D Layout)
ports:
  Port1: Properties{Impedance=50ohm Magnitude=1V Phase=0deg PostProcess Renormalize="50ohm + 0i ohm" Deembed=0mm DeembedGapPortInductance Type="Single Strip Gap Source Differential InternalPort1" HFSS_Type=Gap Orientation=Horizontal Layer_Alignment=Upper Horizontal_Extent_Factor=5 Vertical_Extent_Factor=3 PEC_Launch_Width=2um} Type=EdgePort OrderId=5
  Port2: Properties{Impedance=50ohm Magnitude=1V Phase=0deg PostProcess Renormalize="50ohm + 0i ohm" Deembed=0mm DeembedGapPortInductance Type="Single Strip Gap Source Differential InternalPort2" HFSS_Type=Gap Orientation=Horizontal Layer_Alignment=Upper Horizontal_Extent_Factor=5 Vertical_Extent_Factor=3 PEC_Launch_Width=2um} Type=EdgePort OrderId=6
setups:
  HFSS Setup 1: SolveSetupType=HFSS PercentRefinementPerPass=30 MinNumberOfPasses=1 MinNumberOfConvergedPasses=1 Frequency=10GHz MeshSizeFactor=1.5 ViaNumSides=6 ViaMaterial=copper Style25DVia=Mesh
    sweep Sweep 1: LIN 0GHz 15GHz 0.05GHz; FastSweep SAbsError=0.005 ZoPercentError=1 PassivityTolerance=0.0001 UseQ3DForDC MaxSolutions=250 InterpUseSMatrix InterpUsePortImpedance InterpUseFullBasis MagMinThreshold=0.01
output variables:
  L = im(Z(Port1,Port1) + Z(Port2,Port2) - Z(Port1,Port2) - Z(Port2,Port1)) / (2 * pi * Freq) * 1e9
  Q = im(Z(Port1,Port1) + Z(Port2,Port2) - Z(Port1,Port2) - Z(Port2,Port1)) / re(Z(Port1,Port1) + Z(Port2,Port2) - Z(Port1,Port2) - Z(Port2,Port1))
reports:
  Output Variables Plot 1: Q vs F on HFSS Setup 1 : Sweep 1
  Output Variables Plot 2: Q vs F on HFSS Setup 1 : Sweep 1 [$W=all $R_out=all $S=all]
  Output Variables Plot 3: Q vs F on HFSS Setup 1 : Sweep 1
  Output Variables Plot 4: L vs F on HFSS Setup 1 : Sweep 1; markers MX1 at x=2.400042e+09
  Output Variables Plot 5: Q vs F on HFSS Setup 1 : Sweep 1 [$R_out=180um,190um,200um,210um,220um,230um,240um,250um,260um,270um,280um]; markers MX1 at x=2.3977087e+09
  Output Variables Plot 6: L vs F on HFSS Setup 1 : Sweep 1 [$R_out=180um,190um,200um,210um,220um,230um,240um,250um,260um,270um,280um]; markers MX1 at x=2.3942782e+09
  Output Variables Plot 7: L vs F on HFSS Setup 1 : Sweep 1; markers MX1 at x=2.0005604e+09, MX2 at x=2.7992228e+09, MX3 at x=2.3992784e+09
  Output Variables Plot 8: Q vs F on HFSS Setup 1 : Sweep 1; markers MX1 at x=2.3991804e+09
  Output Variables Plot 9: L vs F on HFSS Setup 1 : Sweep 1; markers MX1 at x=2.4025511e+09

design EMDesign4 (HFSS 3D Layout)
ports:
  Port1: Properties{Impedance=50ohm Magnitude=1V Phase=0deg PostProcess Renormalize="50ohm + 0i ohm" Deembed=0mm DeembedGapPortInductance Type="Single Strip Gap Source Differential InternalPort1" HFSS_Type=Gap Orientation=Horizontal Layer_Alignment=Upper Horizontal_Extent_Factor=5 Vertical_Extent_Factor=3 PEC_Launch_Width=0mm} Type=EdgePort OrderId=3
setups:
  HFSS Setup 1: SolveSetupType=HFSS PercentRefinementPerPass=30 MinNumberOfPasses=1 MinNumberOfConvergedPasses=1 Frequency=10GHz MeshSizeFactor=1.5 ViaNumSides=6 ViaMaterial=copper Style25DVia=Mesh
    sweep Sweep 1: LIN 0GHz 20GHz 0.05GHz; FastSweep SAbsError=0.005 ZoPercentError=1 PassivityTolerance=0.0001 UseQ3DForDC MaxSolutions=250 InterpUseSMatrix InterpUsePortImpedance InterpUseFullBasis MagMinThreshold=0.01
output variables:
  L = 1e9 * im(1 / Y(Port1,Port1)) / (2 * pi * F)
  Q = abs( im(1 / Y(Port1,Port1)) / re(1 / Y(Port1,Port1)) )
  Zdiff = 50*(1+S(Port1,Port1))/(1-S(Port1,Port1))
  omega = 2 * pi * F
  Qdiff = im(Zdiff)/re(Zdiff)
  Ldiff = 1e9*im(Zdiff)/omega
reports:
  Output Variables Plot 1: L vs F on HFSS Setup 1 : Sweep 1; markers MX1 at x=2.402633e+09
  Output Variables Plot 2: Q vs F on HFSS Setup 1 : Sweep 1; markers MX1 at x=2.4004364e+09
  Output Variables Plot 3: Ldiff vs F on HFSS Setup 1 : Sweep 1; markers MX1 at x=2.4005318e+09
  Output Variables Plot 4: Qdiff vs F on HFSS Setup 1 : Sweep 1; markers MX1 at x=2.407982e+09

design EMDesign2 (HFSS 3D Layout)
ports:
  Port1: Properties{Reference=Metal1:rect_20 Impedance=50ohm Magnitude=1V Phase=0deg PostProcess Renormalize="50ohm + 0i ohm" Deembed=0mm DeembedGapPortInductance Type="Single Strip Gap Source" HFSS_Type=Gap Orientation=Vertical Layer_Alignment=Upper Horizontal_Extent_Factor=5 Vertical_Extent_Factor=3 PEC_Launch_Width=0mm} Type=EdgePort OrderId=13
  Port2: Properties{Reference=Metal1:rect_20 Impedance=50ohm Magnitude=1V Phase=0deg PostProcess Renormalize="50ohm + 0i ohm" Deembed=0mm DeembedGapPortInductance Type="Single Strip Gap Source" HFSS_Type=Gap Orientation=Vertical Layer_Alignment=Upper Horizontal_Extent_Factor=5 Vertical_Extent_Factor=3 PEC_Launch_Width=0mm} Type=EdgePort OrderId=14
setups:
  HFSS Setup 1: SolveSetupType=HFSS PercentRefinementPerPass=30 MinNumberOfPasses=1 MinNumberOfConvergedPasses=1 Frequency=10GHz MeshSizeFactor=1.5 ViaNumSides=6 ViaMaterial=copper Style25DVia=Mesh
    sweep Sweep 1: LIN 0GHz 15GHz 0.05GHz; FastSweep SAbsError=0.005 ZoPercentError=1 PassivityTolerance=0.0001 UseQ3DForDC MaxSolutions=250 InterpUseSMatrix InterpUsePortImpedance InterpUseFullBasis MagMinThreshold=0.01
optimetrics:
  ParametricSetup1: Parametric Sim._Setups=[HFSS Setup 1]
    sweep $W: LIN 15um 40um 2.5um
    sweep $S: LIN 6um 20um 2um
    table edits: del(15um, 6um) del(15um, 8um) del(17.5um, 20um) del(17.5um, 18um) del(17.5um, 16um) del(17.5um, 14um) del(17.5um, 12um) del(17.5um, 8um) del(17.5um, 6um) del(15um, 20um) del(15um, 18um) del(15um, 16um) del(15um, 14um) del(15um, 12um) del(20um, 20um) del(20um, 18um) del(20um, 16um) del(20um, 14um) del(20um, 12um) del(20um, 8um) del(20um, 6um) del(22.5um, 20um) del(22.5um, 18um) del(22.5um, 16um) del(22.5um, 14um) del(22.5um, 12um) del(22.5um, 8um) del(22.5um, 6um) del(25um, 20um) del(25um, 18um) del(25um, 16um) del(25um, 14um) del(25um, 12um) del(25um, 8um) del(25um, 6um) del(32.5um, 20um) del(32.5um, 18um) del(32.5um, 16um) del(32.5um, 14um) del(32.5um, 12um) del(32.5um, 8um) del(32.5um, 6um) del(30um, 6um) del(40um, 20um) del(40um, 18um) del(40um, 16um) del(40um, 14um) del(40um, 12um) del(40um, 8um) del(40um, 6um) del(37.5um, 20um) del(37.5um, 18um) del(37.5um, 16um) del(37.5um, 14um) del(37.5um, 12um) del(37.5um, 8um) del(37.5um, 6um) edit(15um, 10um, 15um, 11um) edit(17.5um, 10um, 17.5um, 11um) edit(20um, 10um, 20um, 11um)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
output variables:
  Zdiff = Z(Port1,Port1)-Z(Port1,Port2)-Z(Port2,Port1)+Z(Port2,Port2)
  omega = 2*pi*F
  Ldiff = 1e9*im(Zdiff)/omega
  Qdiff = im(Zdiff)/re(Zdiff)
reports:
  Output Variables Plot 1: Qdiff, Ldiff vs F on HFSS Setup 1 : Sweep 1; markers MX1 at x=2.402633e+09
  Z Parameter Plot 1: dB(Z(Port1,Port1)), dB(Z(Port1,Port2)), dB(Z(Port2,Port1)), dB(Z(Port2,Port2)) vs F on HFSS Setup 1 : Sweep 1
  Output Variables Plot 2: Ldiff, Qdiff vs F on HFSS Setup 1 : Sweep 1 [$R_out=all]; markers MX1 at x=2.3952435e+09
  Width_variations: Ldiff, Qdiff vs F on HFSS Setup 1 : Sweep 1 [$W=all]
  Seperation_variations: Ldiff, Qdiff vs F on HFSS Setup 1 : Sweep 1 [$S=all]
