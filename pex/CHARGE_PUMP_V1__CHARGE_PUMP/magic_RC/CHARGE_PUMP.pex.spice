* NGSPICE file created from CHARGE_PUMP.ext - technology: ihp-sg13g2

.subckt CHARGE_PUMP_PEX UP VDD VCP VBGR VSS DN
X0 a_7067_7119.t11 VSS.t18 VDD.t15 VDD.t1 sg13_lv_pmos ad=1.1248p pd=6.3u as=1.1248p ps=6.3u w=5.92u l=2u
X1 a_6599_9155.t9 a_6599_9155.t8 a_7067_9155.t3 VDD.t10 sg13_lv_pmos ad=1.5542p pd=8.56u as=1.5542p ps=8.56u w=8.18u l=2u
X2 a_6599_9155.t30 a_6599_9155.t29 a_7067_9155.t1 VDD.t1 sg13_lv_pmos ad=2.7812p pd=17.04u as=1.5542p ps=8.56u w=8.18u l=2u
X3 a_7067_7119.t9 a_6599_9155.t43 a_6599_7119.t10 VDD.t7 sg13_lv_pmos ad=1.5542p pd=8.56u as=1.5542p ps=8.56u w=8.18u l=2u
X4 a_7067_9155.t11 VSS.t23 VDD.t6 VDD.t27 sg13_lv_pmos ad=1.1248p pd=6.3u as=1.1248p ps=6.3u w=5.92u l=2u
X5 a_7067_7119.t7 a_6599_9155.t45 a_6599_7119.t3 VDD.t12 sg13_lv_pmos ad=1.5542p pd=8.56u as=1.5542p ps=8.56u w=8.18u l=2u
X6 a_7067_7119.t5 a_6599_9155.t39 a_6599_7119.t2 VDD.t1 sg13_lv_pmos ad=1.5542p pd=8.56u as=1.5542p ps=8.56u w=8.18u l=2u
X7 a_7067_5083.t1 a_6599_9155.t51 VCP.t2 VDD.t4 sg13_lv_pmos ad=1.5542p pd=8.56u as=2.7812p ps=17.04u w=8.18u l=2u
X8 VCP.t1 a_6599_7119.t23 a_9470_2433.t1 VSS.t2 sg13_lv_nmos ad=1.5466p pd=8.52u as=2.7676p ps=16.96u w=8.14u l=2u
X9 a_7067_9155.t4 a_6599_9155.t4 a_6599_9155.t3 VDD.t4 sg13_lv_pmos ad=1.5542p pd=8.56u as=1.5542p ps=8.56u w=8.18u l=2u
X10 a_6599_9155.t6 a_6599_9155.t5 a_7067_9155.t4 VDD.t11 sg13_lv_pmos ad=1.5542p pd=8.56u as=1.5542p ps=8.56u w=8.18u l=2u
X11 a_7067_5083.t2 a_6599_9155.t41 VCP.t6 VDD.t0 sg13_lv_pmos ad=1.5542p pd=8.56u as=1.5542p ps=8.56u w=8.18u l=2u
X12 a_7067_7119.t3 a_6599_9155.t47 a_6599_7119.t6 VDD.t8 sg13_lv_pmos ad=1.5542p pd=8.56u as=1.5542p ps=8.56u w=8.18u l=2u
X13 VCP.t13 a_6599_7119.t19 a_9470_2433.t2 VSS.t15 sg13_lv_nmos ad=2.7676p pd=16.96u as=1.5466p ps=8.52u w=8.14u l=2u
X14 a_6599_9155.t31 VBGR.t0 VSS.t7 VSS.t6 sg13_lv_nmos ad=1.326p pd=8.48u as=1.326p ps=8.48u w=3.9u l=2u
X15 a_7067_9155.t5 a_6599_9155.t0 a_6599_9155.t1 VDD.t4 sg13_lv_pmos ad=1.5542p pd=8.56u as=2.7812p ps=17.04u w=8.18u l=2u
X16 a_7067_7119.t6 a_6599_9155.t37 a_6599_7119.t8 VDD.t1 sg13_lv_pmos ad=1.5542p pd=8.56u as=1.5542p ps=8.56u w=8.18u l=2u
X17 a_7067_5083.t9 a_6599_9155.t43 VCP.t11 VDD.t7 sg13_lv_pmos ad=1.5542p pd=8.56u as=1.5542p ps=8.56u w=8.18u l=2u
X18 VDD.t6 VSS.t24 a_7067_9155.t10 VDD.t5 sg13_lv_pmos ad=1.1248p pd=6.3u as=1.1248p ps=6.3u w=5.92u l=2u
X19 a_7067_9155.t0 a_6599_9155.t16 a_6599_9155.t15 VDD.t0 sg13_lv_pmos ad=1.5542p pd=8.56u as=1.5542p ps=8.56u w=8.18u l=2u
X20 a_7067_7119.t0 a_6599_9155.t33 a_6599_7119.t7 VDD.t1 sg13_lv_pmos ad=1.5542p pd=8.56u as=1.5542p ps=8.56u w=8.18u l=2u
X21 a_7067_5083.t7 a_6599_9155.t45 VCP.t4 VDD.t12 sg13_lv_pmos ad=1.5542p pd=8.56u as=1.5542p ps=8.56u w=8.18u l=2u
X22 a_7067_5083.t5 a_6599_9155.t39 VCP.t3 VDD.t1 sg13_lv_pmos ad=1.5542p pd=8.56u as=1.5542p ps=8.56u w=8.18u l=2u
X23 a_6684_2433.t2 a_6599_7119.t13 a_6599_7119.t12 VSS.t14 sg13_lv_nmos ad=1.5466p pd=8.52u as=1.5466p ps=8.52u w=8.14u l=2u
X24 a_7067_7119.t12 VSS.t16 VDD.t2 VDD.t1 sg13_lv_pmos ad=2.0128p pd=12.52u as=1.1248p ps=6.3u w=5.92u l=2u
X25 VCP.t12 a_6599_7119.t21 a_9470_2433.t0 VSS.t11 sg13_lv_nmos ad=1.5466p pd=8.52u as=1.5466p ps=8.52u w=8.14u l=2u
X26 a_6599_7119.t2 a_6599_9155.t40 a_7067_7119.t2 VDD.t1 sg13_lv_pmos ad=1.5542p pd=8.56u as=1.5542p ps=8.56u w=8.18u l=2u
X27 a_9470_2433.t3 DN.t0 VSS.t13 VSS.t12 sg13_lv_nmos ad=2.04p pd=12.68u as=2.04p ps=12.68u w=6u l=2u
X28 VDD.t20 UP.t4 a_7067_5083.t10 VDD.t1 sg13_lv_pmos ad=1.1248p pd=6.3u as=2.0128p ps=12.52u w=5.92u l=2u
X29 a_7067_9155.t2 a_6599_9155.t13 a_6599_9155.t12 VDD.t7 sg13_lv_pmos ad=1.5542p pd=8.56u as=1.5542p ps=8.56u w=8.18u l=2u
X30 a_6599_7119.t4 a_6599_9155.t36 a_7067_7119.t6 VDD.t1 sg13_lv_pmos ad=1.5542p pd=8.56u as=1.5542p ps=8.56u w=8.18u l=2u
X31 a_7067_7119.t4 a_6599_9155.t35 a_6599_7119.t4 VDD.t1 sg13_lv_pmos ad=1.5542p pd=8.56u as=1.5542p ps=8.56u w=8.18u l=2u
X32 VDD.t2 VSS.t17 a_7067_7119.t11 VDD.t1 sg13_lv_pmos ad=1.1248p pd=6.3u as=1.1248p ps=6.3u w=5.92u l=2u
X33 a_7067_5083.t3 a_6599_9155.t47 VCP.t7 VDD.t8 sg13_lv_pmos ad=1.5542p pd=8.56u as=1.5542p ps=8.56u w=8.18u l=2u
X34 a_7067_9155.t9 a_6599_9155.t10 a_6599_9155.t9 VDD.t12 sg13_lv_pmos ad=1.5542p pd=8.56u as=1.5542p ps=8.56u w=8.18u l=2u
X35 a_7067_9155.t8 a_6599_9155.t19 a_6599_9155.t18 VDD.t1 sg13_lv_pmos ad=1.5542p pd=8.56u as=1.5542p ps=8.56u w=8.18u l=2u
X36 a_7067_5083.t6 a_6599_9155.t37 VCP.t9 VDD.t1 sg13_lv_pmos ad=1.5542p pd=8.56u as=1.5542p ps=8.56u w=8.18u l=2u
X37 a_9470_2433.t2 a_6599_7119.t20 VCP.t12 VSS.t10 sg13_lv_nmos ad=1.5466p pd=8.52u as=1.5466p ps=8.52u w=8.14u l=2u
X38 a_6599_7119.t5 a_6599_9155.t42 a_7067_7119.t9 VDD.t9 sg13_lv_pmos ad=1.5542p pd=8.56u as=1.5542p ps=8.56u w=8.18u l=2u
X39 a_7067_5083.t0 a_6599_9155.t33 VCP.t8 VDD.t1 sg13_lv_pmos ad=1.5542p pd=8.56u as=1.5542p ps=8.56u w=8.18u l=2u
X40 a_7067_5083.t11 UP.t3 VDD.t20 VDD.t1 sg13_lv_pmos ad=1.1248p pd=6.3u as=1.1248p ps=6.3u w=5.92u l=2u
X41 a_6599_7119.t10 a_6599_9155.t44 a_7067_7119.t7 VDD.t13 sg13_lv_pmos ad=1.5542p pd=8.56u as=1.5542p ps=8.56u w=8.18u l=2u
X42 a_6599_7119.t8 a_6599_9155.t38 a_7067_7119.t5 VDD.t1 sg13_lv_pmos ad=1.5542p pd=8.56u as=1.5542p ps=8.56u w=8.18u l=2u
X43 VDD.t17 VSS.t22 a_7067_9155.t11 VDD.t16 sg13_lv_pmos ad=1.1248p pd=6.3u as=1.1248p ps=6.3u w=5.92u l=2u
X44 a_7067_9155.t3 a_6599_9155.t7 a_6599_9155.t6 VDD.t8 sg13_lv_pmos ad=1.5542p pd=8.56u as=1.5542p ps=8.56u w=8.18u l=2u
X45 a_6599_7119.t7 a_6599_9155.t34 a_7067_7119.t4 VDD.t1 sg13_lv_pmos ad=1.5542p pd=8.56u as=1.5542p ps=8.56u w=8.18u l=2u
X46 VCP.t3 a_6599_9155.t40 a_7067_5083.t2 VDD.t1 sg13_lv_pmos ad=1.5542p pd=8.56u as=1.5542p ps=8.56u w=8.18u l=2u
X47 a_7067_5083.t4 a_6599_9155.t35 VCP.t5 VDD.t1 sg13_lv_pmos ad=1.5542p pd=8.56u as=1.5542p ps=8.56u w=8.18u l=2u
X48 a_7067_9155.t6 a_6599_9155.t22 a_6599_9155.t21 VDD.t1 sg13_lv_pmos ad=1.5542p pd=8.56u as=1.5542p ps=8.56u w=8.18u l=2u
X49 VCP.t5 a_6599_9155.t36 a_7067_5083.t6 VDD.t1 sg13_lv_pmos ad=1.5542p pd=8.56u as=1.5542p ps=8.56u w=8.18u l=2u
X50 a_7067_9155.t1 a_6599_9155.t28 a_6599_9155.t27 VDD.t1 sg13_lv_pmos ad=1.5542p pd=8.56u as=1.5542p ps=8.56u w=8.18u l=2u
X51 VDD.t22 UP.t2 a_7067_5083.t11 VDD.t1 sg13_lv_pmos ad=1.1248p pd=6.3u as=1.1248p ps=6.3u w=5.92u l=2u
X52 a_6599_7119.t9 a_6599_9155.t50 a_7067_7119.t1 VDD.t4 sg13_lv_pmos ad=1.5542p pd=8.56u as=1.5542p ps=8.56u w=8.18u l=2u
X53 VCP.t6 a_6599_9155.t42 a_7067_5083.t9 VDD.t9 sg13_lv_pmos ad=1.5542p pd=8.56u as=1.5542p ps=8.56u w=8.18u l=2u
X54 a_9470_2433.t0 a_6599_7119.t22 VCP.t1 VSS.t0 sg13_lv_nmos ad=1.5466p pd=8.52u as=1.5466p ps=8.52u w=8.14u l=2u
X55 a_6684_2433.t3 VDD.t28 VSS.t9 VSS.t8 sg13_lv_nmos ad=2.04p pd=12.68u as=2.04p ps=12.68u w=6u l=2u
X56 a_7067_7119.t10 VSS.t20 VDD.t14 VDD.t9 sg13_lv_pmos ad=1.1248p pd=6.3u as=2.0128p ps=12.52u w=5.92u l=2u
X57 a_6599_9155.t18 a_6599_9155.t17 a_7067_9155.t0 VDD.t1 sg13_lv_pmos ad=1.5542p pd=8.56u as=1.5542p ps=8.56u w=8.18u l=2u
X58 a_6599_7119.t3 a_6599_9155.t46 a_7067_7119.t3 VDD.t10 sg13_lv_pmos ad=1.5542p pd=8.56u as=1.5542p ps=8.56u w=8.18u l=2u
X59 a_6599_7119.t0 a_6599_9155.t32 a_7067_7119.t0 VDD.t1 sg13_lv_pmos ad=2.7812p pd=17.04u as=1.5542p ps=8.56u w=8.18u l=2u
X60 VCP.t11 a_6599_9155.t44 a_7067_5083.t7 VDD.t13 sg13_lv_pmos ad=1.5542p pd=8.56u as=1.5542p ps=8.56u w=8.18u l=2u
X61 VCP.t9 a_6599_9155.t38 a_7067_5083.t5 VDD.t1 sg13_lv_pmos ad=1.5542p pd=8.56u as=1.5542p ps=8.56u w=8.18u l=2u
X62 a_6684_2433.t1 a_6599_7119.t16 a_6599_7119.t15 VSS.t4 sg13_lv_nmos ad=1.5466p pd=8.52u as=1.5466p ps=8.52u w=8.14u l=2u
X63 a_6599_9155.t24 a_6599_9155.t23 a_7067_9155.t6 VDD.t1 sg13_lv_pmos ad=1.5542p pd=8.56u as=1.5542p ps=8.56u w=8.18u l=2u
X64 a_7067_9155.t7 a_6599_9155.t25 a_6599_9155.t24 VDD.t1 sg13_lv_pmos ad=1.5542p pd=8.56u as=1.5542p ps=8.56u w=8.18u l=2u
X65 VCP.t8 a_6599_9155.t34 a_7067_5083.t4 VDD.t1 sg13_lv_pmos ad=1.5542p pd=8.56u as=1.5542p ps=8.56u w=8.18u l=2u
X66 a_6599_7119.t15 a_6599_7119.t14 a_6684_2433.t2 VSS.t5 sg13_lv_nmos ad=1.5466p pd=8.52u as=1.5466p ps=8.52u w=8.14u l=2u
X67 a_7067_5083.t12 UP.t1 VDD.t22 VDD.t1 sg13_lv_pmos ad=1.1248p pd=6.3u as=1.1248p ps=6.3u w=5.92u l=2u
X68 a_7067_9155.t10 VSS.t25 VDD.t26 VDD.t25 sg13_lv_pmos ad=1.1248p pd=6.3u as=2.0128p ps=12.52u w=5.92u l=2u
X69 a_6599_9155.t15 a_6599_9155.t14 a_7067_9155.t2 VDD.t9 sg13_lv_pmos ad=1.5542p pd=8.56u as=1.5542p ps=8.56u w=8.18u l=2u
X70 a_7067_7119.t8 a_6599_9155.t49 a_6599_7119.t9 VDD.t4 sg13_lv_pmos ad=1.5542p pd=8.56u as=1.5542p ps=8.56u w=8.18u l=2u
X71 a_6599_7119.t6 a_6599_9155.t48 a_7067_7119.t8 VDD.t11 sg13_lv_pmos ad=1.5542p pd=8.56u as=1.5542p ps=8.56u w=8.18u l=2u
X72 VDD.t15 VSS.t19 a_7067_7119.t10 VDD.t0 sg13_lv_pmos ad=1.1248p pd=6.3u as=1.1248p ps=6.3u w=5.92u l=2u
X73 a_6599_7119.t12 a_6599_7119.t11 a_6684_2433.t0 VSS.t1 sg13_lv_nmos ad=1.5466p pd=8.52u as=2.7676p ps=16.96u w=8.14u l=2u
X74 a_7067_9155.t12 VSS.t21 VDD.t17 VDD.t18 sg13_lv_pmos ad=2.0128p pd=12.52u as=1.1248p ps=6.3u w=5.92u l=2u
X75 a_6599_9155.t12 a_6599_9155.t11 a_7067_9155.t9 VDD.t13 sg13_lv_pmos ad=1.5542p pd=8.56u as=1.5542p ps=8.56u w=8.18u l=2u
X76 a_6599_9155.t21 a_6599_9155.t20 a_7067_9155.t8 VDD.t1 sg13_lv_pmos ad=1.5542p pd=8.56u as=1.5542p ps=8.56u w=8.18u l=2u
X77 VCP.t10 a_6599_9155.t50 a_7067_5083.t1 VDD.t4 sg13_lv_pmos ad=1.5542p pd=8.56u as=1.5542p ps=8.56u w=8.18u l=2u
X78 a_6599_7119.t18 a_6599_7119.t17 a_6684_2433.t1 VSS.t3 sg13_lv_nmos ad=2.7676p pd=16.96u as=1.5466p ps=8.52u w=8.14u l=2u
X79 a_6599_9155.t27 a_6599_9155.t26 a_7067_9155.t7 VDD.t1 sg13_lv_pmos ad=1.5542p pd=8.56u as=1.5542p ps=8.56u w=8.18u l=2u
X80 VCP.t4 a_6599_9155.t46 a_7067_5083.t3 VDD.t10 sg13_lv_pmos ad=1.5542p pd=8.56u as=1.5542p ps=8.56u w=8.18u l=2u
X81 VCP.t0 a_6599_9155.t32 a_7067_5083.t0 VDD.t1 sg13_lv_pmos ad=2.7812p pd=17.04u as=1.5542p ps=8.56u w=8.18u l=2u
X82 a_7067_7119.t1 a_6599_9155.t51 a_6599_7119.t1 VDD.t4 sg13_lv_pmos ad=1.5542p pd=8.56u as=2.7812p ps=17.04u w=8.18u l=2u
X83 a_7067_7119.t2 a_6599_9155.t41 a_6599_7119.t5 VDD.t0 sg13_lv_pmos ad=1.5542p pd=8.56u as=1.5542p ps=8.56u w=8.18u l=2u
X84 VDD.t24 UP.t0 a_7067_5083.t12 VDD.t1 sg13_lv_pmos ad=2.0128p pd=12.52u as=1.1248p ps=6.3u w=5.92u l=2u
X85 a_6599_9155.t3 a_6599_9155.t2 a_7067_9155.t5 VDD.t4 sg13_lv_pmos ad=1.5542p pd=8.56u as=1.5542p ps=8.56u w=8.18u l=2u
X86 a_7067_5083.t8 a_6599_9155.t49 VCP.t10 VDD.t4 sg13_lv_pmos ad=1.5542p pd=8.56u as=1.5542p ps=8.56u w=8.18u l=2u
X87 VCP.t7 a_6599_9155.t48 a_7067_5083.t8 VDD.t11 sg13_lv_pmos ad=1.5542p pd=8.56u as=1.5542p ps=8.56u w=8.18u l=2u
C0 VDD VBGR 0.42086f
C1 VDD DN 0.0465f
C2 VDD UP 16.0526f
C3 VDD VCP 3.75686f
R0 DN DN.t0 3.54854
R1 VCP.n12 VCP.n11 13.2044
R2 VCP.n0 VCP.t0 4.68252
R3 VCP.n10 VCP.t1 4.67863
R4 VCP.n9 VCP.t2 2.81309
R5 VCP.n11 VCP.t13 2.80807
R6 VCP.n12 VCP.n9 2.66504
R7 VCP.n1 VCP.n0 2.49383
R8 VCP.n2 VCP.n1 2.49383
R9 VCP.n3 VCP.n2 2.49383
R10 VCP.n4 VCP.n3 2.49383
R11 VCP.n5 VCP.n4 2.49383
R12 VCP.n6 VCP.n5 2.49383
R13 VCP.n7 VCP.n6 2.49383
R14 VCP.n8 VCP.n7 2.49383
R15 VCP.n8 VCP.t10 2.18975
R16 VCP.n7 VCP.t7 2.18975
R17 VCP.n6 VCP.t4 2.18975
R18 VCP.n5 VCP.t11 2.18975
R19 VCP.n4 VCP.t6 2.18975
R20 VCP.n3 VCP.t3 2.18975
R21 VCP.n2 VCP.t9 2.18975
R22 VCP.n1 VCP.t5 2.18975
R23 VCP.n0 VCP.t8 2.18975
R24 VCP.n10 VCP.t12 2.1853
R25 VCP.n9 VCP.n8 1.8705
R26 VCP.n11 VCP.n10 1.8705
R27 VCP VCP.n12 1.04364
R28 UP.t2 UP.n0 4.39573
R29 UP.n4 UP.t0 3.55242
R30 UP.n2 UP.t4 3.5502
R31 UP.n1 UP.t4 2.94411
R32 UP.t3 UP.n1 2.9438
R33 UP.n5 UP.t0 2.94359
R34 UP.n5 UP.t1 2.94128
R35 UP.n1 UP.n0 2.4713
R36 UP.n3 UP.t2 2.33654
R37 UP.n2 UP.t3 2.33654
R38 UP.t1 UP.n4 2.33622
R39 UP UP.n6 2.12476
R40 UP.n6 UP.n0 1.5713
R41 UP.n3 UP.n2 1.21656
R42 UP.n4 UP.n3 1.21611
R43 UP.n6 UP.n5 0.9005
R44 VBGR VBGR.n0 5.52726
R45 VBGR VBGR.n3 5.48166
R46 VBGR.t0 VBGR.n1 2.30298
R47 VBGR.n2 VBGR.t0 1.99081
R48 VBGR.n2 VBGR.n0 1.2107
R49 VBGR.n3 VBGR.n2 1.20984
R50 VBGR.n1 VBGR.n0 0.587811
R51 VBGR.n3 VBGR.n1 0.587672
R52 VDD.n672 VDD.n48 17.0005
R53 VDD.n672 VDD.n47 17.0005
R54 VDD.n672 VDD.n46 17.0005
R55 VDD.n672 VDD.n45 17.0005
R56 VDD.n672 VDD.n44 17.0005
R57 VDD.n672 VDD.n43 17.0005
R58 VDD.n672 VDD.n42 17.0005
R59 VDD.n672 VDD.n40 17.0005
R60 VDD.n672 VDD.n39 17.0005
R61 VDD.n672 VDD.n37 17.0005
R62 VDD.n672 VDD.n36 17.0005
R63 VDD.n672 VDD.n35 17.0005
R64 VDD.n672 VDD.n21 17.0005
R65 VDD.n672 VDD.n22 17.0005
R66 VDD.n672 VDD.n23 17.0005
R67 VDD.n672 VDD.n24 17.0005
R68 VDD.n672 VDD.n26 17.0005
R69 VDD.n672 VDD.n27 17.0005
R70 VDD.n672 VDD.n29 17.0005
R71 VDD.n672 VDD.n30 17.0005
R72 VDD.n672 VDD.n31 17.0005
R73 VDD.n672 VDD.n32 17.0005
R74 VDD.n672 VDD.n33 17.0005
R75 VDD.n673 VDD.n672 17.0005
R76 VDD.n672 VDD.n50 17.0005
R77 VDD.n672 VDD.n51 17.0005
R78 VDD.n672 VDD.n52 17.0005
R79 VDD.n672 VDD.n53 17.0005
R80 VDD.n672 VDD.n55 17.0005
R81 VDD.n672 VDD.n56 17.0005
R82 VDD.n672 VDD.n57 17.0005
R83 VDD.n672 VDD.n131 17.0005
R84 VDD.n672 VDD.n244 17.0005
R85 VDD.n672 VDD.n241 17.0005
R86 VDD.n672 VDD.n237 17.0005
R87 VDD.n672 VDD.n234 17.0005
R88 VDD.n672 VDD.n230 17.0005
R89 VDD.n672 VDD.n227 17.0005
R90 VDD.n672 VDD.n223 17.0005
R91 VDD.n672 VDD.n220 17.0005
R92 VDD.n672 VDD.n216 17.0005
R93 VDD.n672 VDD.n215 17.0005
R94 VDD.n672 VDD.n211 17.0005
R95 VDD.n672 VDD.n208 17.0005
R96 VDD.n672 VDD.n204 17.0005
R97 VDD.n672 VDD.n201 17.0005
R98 VDD.n672 VDD.n197 17.0005
R99 VDD.n672 VDD.n194 17.0005
R100 VDD.n672 VDD.n190 17.0005
R101 VDD.n672 VDD.n189 17.0005
R102 VDD.n672 VDD.n185 17.0005
R103 VDD.n672 VDD.n182 17.0005
R104 VDD.n672 VDD.n179 17.0005
R105 VDD.n672 VDD.n176 17.0005
R106 VDD.n672 VDD.n174 17.0005
R107 VDD.n672 VDD.n173 17.0005
R108 VDD.n672 VDD.n171 17.0005
R109 VDD.n672 VDD.n169 17.0005
R110 VDD.n672 VDD.n167 17.0005
R111 VDD.n672 VDD.n165 17.0005
R112 VDD.n672 VDD.n163 17.0005
R113 VDD.n672 VDD.n161 17.0005
R114 VDD.n672 VDD.n159 17.0005
R115 VDD.n672 VDD.n158 17.0005
R116 VDD.n672 VDD.n156 17.0005
R117 VDD.n672 VDD.n154 17.0005
R118 VDD.n672 VDD.n152 17.0005
R119 VDD.n672 VDD.n150 17.0005
R120 VDD.n672 VDD.n148 17.0005
R121 VDD.n672 VDD.n146 17.0005
R122 VDD.n672 VDD.n144 17.0005
R123 VDD.n672 VDD.n142 17.0005
R124 VDD.n672 VDD.n140 17.0005
R125 VDD.n672 VDD.n139 17.0005
R126 VDD.n672 VDD.n137 17.0005
R127 VDD.n672 VDD.n135 17.0005
R128 VDD.n672 VDD.n133 17.0005
R129 VDD.n660 VDD.n314 17.0005
R130 VDD.n660 VDD.n313 17.0005
R131 VDD.n660 VDD.n302 17.0005
R132 VDD.n660 VDD.n300 17.0005
R133 VDD.n661 VDD.n660 17.0005
R134 VDD.n660 VDD.n298 17.0005
R135 VDD.n660 VDD.n296 17.0005
R136 VDD.n660 VDD.n294 17.0005
R137 VDD.n653 VDD.n407 17.0005
R138 VDD.n653 VDD.n410 17.0005
R139 VDD.n653 VDD.n402 17.0005
R140 VDD.n653 VDD.n418 17.0005
R141 VDD.n653 VDD.n401 17.0005
R142 VDD.n653 VDD.n426 17.0005
R143 VDD.n653 VDD.n397 17.0005
R144 VDD.n653 VDD.n434 17.0005
R145 VDD.n653 VDD.n393 17.0005
R146 VDD.n653 VDD.n442 17.0005
R147 VDD.n653 VDD.n389 17.0005
R148 VDD.n653 VDD.n452 17.0005
R149 VDD.n653 VDD.n385 17.0005
R150 VDD.n653 VDD.n455 17.0005
R151 VDD.n653 VDD.n381 17.0005
R152 VDD.n653 VDD.n463 17.0005
R153 VDD.n653 VDD.n377 17.0005
R154 VDD.n653 VDD.n471 17.0005
R155 VDD.n653 VDD.n373 17.0005
R156 VDD.n653 VDD.n484 17.0005
R157 VDD.n653 VDD.n369 17.0005
R158 VDD.n653 VDD.n652 17.0005
R159 VDD.n648 VDD.n365 17.0005
R160 VDD.n646 VDD.n365 17.0005
R161 VDD.n645 VDD.n644 17.0005
R162 VDD.n644 VDD.n643 17.0005
R163 VDD.n639 VDD.n638 17.0005
R164 VDD.n638 VDD.n637 17.0005
R165 VDD.n636 VDD.n635 17.0005
R166 VDD.n635 VDD.n634 17.0005
R167 VDD.n630 VDD.n629 17.0005
R168 VDD.n629 VDD.n628 17.0005
R169 VDD.n627 VDD.n626 17.0005
R170 VDD.n626 VDD.n625 17.0005
R171 VDD.n621 VDD.n620 17.0005
R172 VDD.n620 VDD.n619 17.0005
R173 VDD.n618 VDD.n617 17.0005
R174 VDD.n617 VDD.n616 17.0005
R175 VDD.n612 VDD.n611 17.0005
R176 VDD.n611 VDD.n610 17.0005
R177 VDD.n606 VDD.n605 17.0005
R178 VDD.n605 VDD.n604 17.0005
R179 VDD.n603 VDD.n602 17.0005
R180 VDD.n602 VDD.n601 17.0005
R181 VDD.n597 VDD.n596 17.0005
R182 VDD.n596 VDD.n595 17.0005
R183 VDD.n594 VDD.n593 17.0005
R184 VDD.n593 VDD.n592 17.0005
R185 VDD.n588 VDD.n587 17.0005
R186 VDD.n587 VDD.n586 17.0005
R187 VDD.n585 VDD.n584 17.0005
R188 VDD.n584 VDD.n583 17.0005
R189 VDD.n579 VDD.n578 17.0005
R190 VDD.n578 VDD.n577 17.0005
R191 VDD.n573 VDD.n572 17.0005
R192 VDD.n572 VDD.n571 17.0005
R193 VDD.n570 VDD.n569 17.0005
R194 VDD.n569 VDD.n568 17.0005
R195 VDD.n564 VDD.n563 17.0005
R196 VDD.n563 VDD.n562 17.0005
R197 VDD.n561 VDD.n335 17.0005
R198 VDD.n559 VDD.n335 17.0005
R199 VDD.t1 VDD.n336 8.501
R200 VDD.t1 VDD.n337 8.501
R201 VDD.t1 VDD.n338 8.501
R202 VDD.t1 VDD.n339 8.501
R203 VDD.t1 VDD.n340 8.501
R204 VDD.t1 VDD.n341 8.501
R205 VDD.t1 VDD.n342 8.501
R206 VDD.t1 VDD.n343 8.501
R207 VDD.t1 VDD.n344 8.501
R208 VDD.t1 VDD.n345 8.501
R209 VDD.t1 VDD.n346 8.501
R210 VDD.t1 VDD.n347 8.501
R211 VDD.t1 VDD.n348 8.501
R212 VDD.t1 VDD.n349 8.501
R213 VDD.t1 VDD.n350 8.501
R214 VDD.t1 VDD.n351 8.501
R215 VDD.t1 VDD.n352 8.501
R216 VDD.t1 VDD.n353 8.501
R217 VDD.t1 VDD.n354 8.501
R218 VDD.t1 VDD.n355 8.501
R219 VDD.t1 VDD.n356 8.501
R220 VDD.t1 VDD.n357 8.501
R221 VDD.t1 VDD.n358 8.501
R222 VDD.t1 VDD.n359 8.501
R223 VDD.t1 VDD.n360 8.501
R224 VDD.t1 VDD.n361 8.501
R225 VDD.t1 VDD.n362 8.501
R226 VDD.t1 VDD.n363 8.501
R227 VDD.t1 VDD.n364 8.501
R228 VDD.n655 VDD.t1 8.501
R229 VDD.n660 VDD.n315 8.5005
R230 VDD.n660 VDD.n316 8.5005
R231 VDD.n660 VDD.t11 8.5005
R232 VDD.n660 VDD.t25 8.5005
R233 VDD.n660 VDD.n317 8.5005
R234 VDD.n660 VDD.t8 8.5005
R235 VDD.n660 VDD.t5 8.5005
R236 VDD.n660 VDD.n318 8.5005
R237 VDD.n660 VDD.n319 8.5005
R238 VDD.n660 VDD.t10 8.5005
R239 VDD.n660 VDD.t27 8.5005
R240 VDD.n660 VDD.n320 8.5005
R241 VDD.n660 VDD.t12 8.5005
R242 VDD.n660 VDD.t16 8.5005
R243 VDD.n660 VDD.n321 8.5005
R244 VDD.n660 VDD.n322 8.5005
R245 VDD.n660 VDD.t13 8.5005
R246 VDD.n660 VDD.t18 8.5005
R247 VDD.n660 VDD.n323 8.5005
R248 VDD.n660 VDD.t7 8.5005
R249 VDD.n660 VDD.n324 8.5005
R250 VDD.n660 VDD.n325 8.5005
R251 VDD.n660 VDD.n326 8.5005
R252 VDD.n660 VDD.t9 8.5005
R253 VDD.n660 VDD.n327 8.5005
R254 VDD.n660 VDD.n328 8.5005
R255 VDD.n660 VDD.n329 8.5005
R256 VDD.n660 VDD.n330 8.5005
R257 VDD.n653 VDD.n315 8.5005
R258 VDD.n653 VDD.n316 8.5005
R259 VDD.n653 VDD.t11 8.5005
R260 VDD.n653 VDD.t25 8.5005
R261 VDD.n653 VDD.n317 8.5005
R262 VDD.n653 VDD.t8 8.5005
R263 VDD.n653 VDD.t5 8.5005
R264 VDD.n653 VDD.n318 8.5005
R265 VDD.n653 VDD.n319 8.5005
R266 VDD.n653 VDD.t10 8.5005
R267 VDD.n653 VDD.t27 8.5005
R268 VDD.n653 VDD.n320 8.5005
R269 VDD.n653 VDD.t12 8.5005
R270 VDD.n653 VDD.t16 8.5005
R271 VDD.n653 VDD.n321 8.5005
R272 VDD.n653 VDD.n322 8.5005
R273 VDD.n653 VDD.t13 8.5005
R274 VDD.n653 VDD.t18 8.5005
R275 VDD.n653 VDD.n323 8.5005
R276 VDD.n653 VDD.t7 8.5005
R277 VDD.n653 VDD.n324 8.5005
R278 VDD.n653 VDD.n325 8.5005
R279 VDD.n653 VDD.n326 8.5005
R280 VDD.n653 VDD.t9 8.5005
R281 VDD.n653 VDD.n327 8.5005
R282 VDD.n653 VDD.n328 8.5005
R283 VDD.n653 VDD.n329 8.5005
R284 VDD.n653 VDD.n330 8.5005
R285 VDD.n672 VDD.n25 8.46995
R286 VDD.n672 VDD.n28 8.46995
R287 VDD.n672 VDD.n246 8.46995
R288 VDD.n672 VDD.n239 8.46995
R289 VDD.n672 VDD.n232 8.46995
R290 VDD.n672 VDD.n225 8.46995
R291 VDD.n672 VDD.n218 8.46995
R292 VDD.n672 VDD.n213 8.46995
R293 VDD.n672 VDD.n206 8.46995
R294 VDD.n672 VDD.n199 8.46995
R295 VDD.n672 VDD.n192 8.46995
R296 VDD.n672 VDD.n187 8.46995
R297 VDD.n672 VDD.n181 8.46995
R298 VDD.n672 VDD.n172 8.46995
R299 VDD.n672 VDD.n168 8.46995
R300 VDD.n672 VDD.n164 8.46995
R301 VDD.n672 VDD.n160 8.46995
R302 VDD.n672 VDD.n157 8.46995
R303 VDD.n672 VDD.n153 8.46995
R304 VDD.n672 VDD.n149 8.46995
R305 VDD.n672 VDD.n145 8.46995
R306 VDD.n672 VDD.n141 8.46995
R307 VDD.n672 VDD.n138 8.46995
R308 VDD.n672 VDD.n134 8.46995
R309 VDD.n660 VDD.n311 8.46995
R310 VDD.n660 VDD.n299 8.46995
R311 VDD.n660 VDD.n297 8.46995
R312 VDD.n660 VDD.n292 8.46995
R313 VDD.n653 VDD.n403 8.46995
R314 VDD.n653 VDD.n415 8.46995
R315 VDD.n653 VDD.n423 8.46995
R316 VDD.n653 VDD.n398 8.46995
R317 VDD.n653 VDD.n431 8.46995
R318 VDD.n653 VDD.n394 8.46995
R319 VDD.n653 VDD.n439 8.46995
R320 VDD.n653 VDD.n390 8.46995
R321 VDD.n653 VDD.n447 8.46995
R322 VDD.n653 VDD.n386 8.46995
R323 VDD.n653 VDD.n382 8.46995
R324 VDD.n653 VDD.n460 8.46995
R325 VDD.n653 VDD.n378 8.46995
R326 VDD.n653 VDD.n468 8.46995
R327 VDD.n653 VDD.n374 8.46995
R328 VDD.n653 VDD.n474 8.46995
R329 VDD.n653 VDD.n481 8.46995
R330 VDD.n653 VDD.n370 8.46995
R331 VDD.n653 VDD.n489 8.46995
R332 VDD.n653 VDD.n366 8.46995
R333 VDD.n641 VDD.n495 8.46995
R334 VDD.n632 VDD.n502 8.46995
R335 VDD.n623 VDD.n509 8.46995
R336 VDD.n614 VDD.n516 8.46995
R337 VDD.n608 VDD.n521 8.46995
R338 VDD.n599 VDD.n528 8.46995
R339 VDD.n590 VDD.n535 8.46995
R340 VDD.n581 VDD.n542 8.46995
R341 VDD.n575 VDD.n547 8.46995
R342 VDD.n566 VDD.n554 8.46995
R343 VDD.n657 VDD.n656 8.46995
R344 VDD.n672 VDD.n41 8.46995
R345 VDD.n672 VDD.n38 8.46995
R346 VDD.n672 VDD.n242 8.46995
R347 VDD.n672 VDD.n235 8.46995
R348 VDD.n672 VDD.n228 8.46995
R349 VDD.n672 VDD.n221 8.46995
R350 VDD.n672 VDD.n209 8.46995
R351 VDD.n672 VDD.n202 8.46995
R352 VDD.n672 VDD.n195 8.46995
R353 VDD.n672 VDD.n183 8.46995
R354 VDD.n672 VDD.n177 8.46995
R355 VDD.n672 VDD.n170 8.46995
R356 VDD.n672 VDD.n166 8.46995
R357 VDD.n672 VDD.n162 8.46995
R358 VDD.n672 VDD.n155 8.46995
R359 VDD.n672 VDD.n151 8.46995
R360 VDD.n672 VDD.n147 8.46995
R361 VDD.n672 VDD.n143 8.46995
R362 VDD.n672 VDD.n136 8.46995
R363 VDD.n672 VDD.n132 8.46995
R364 VDD.n660 VDD.n301 8.46995
R365 VDD.n660 VDD.n290 8.46995
R366 VDD.n660 VDD.n295 8.46995
R367 VDD.t26 VDD.n18 8.46847
R368 VDD.t26 VDD.n252 8.46847
R369 VDD.t26 VDD.n257 8.46847
R370 VDD.t26 VDD.n262 8.46847
R371 VDD.t26 VDD.n263 8.46847
R372 VDD.t26 VDD.n272 8.46847
R373 VDD.t26 VDD.n279 8.46847
R374 VDD.n105 VDD.t24 8.46847
R375 VDD.n100 VDD.t24 8.46847
R376 VDD.n95 VDD.t24 8.46847
R377 VDD.n90 VDD.t24 8.46847
R378 VDD.n69 VDD.t24 8.46847
R379 VDD.n81 VDD.t24 8.46847
R380 VDD.n76 VDD.t24 8.46847
R381 VDD.n687 VDD.n686 7.45877
R382 VDD.t1 VDD.n654 5.66767
R383 VDD.n660 VDD.t0 5.66717
R384 VDD.n653 VDD.t0 5.66717
R385 VDD.n72 VDD.t24 5.66115
R386 VDD.n280 VDD.t26 5.66082
R387 VDD.n688 VDD.t28 4.89758
R388 VDD.n672 VDD.n243 4.251
R389 VDD.n672 VDD.n240 4.251
R390 VDD.n672 VDD.n238 4.251
R391 VDD.n672 VDD.n236 4.251
R392 VDD.n672 VDD.n233 4.251
R393 VDD.n672 VDD.n231 4.251
R394 VDD.n672 VDD.n229 4.251
R395 VDD.n672 VDD.n226 4.251
R396 VDD.n672 VDD.n224 4.251
R397 VDD.n672 VDD.n222 4.251
R398 VDD.n672 VDD.n219 4.251
R399 VDD.n672 VDD.n217 4.251
R400 VDD.n672 VDD.n214 4.251
R401 VDD.n672 VDD.n212 4.251
R402 VDD.n672 VDD.n210 4.251
R403 VDD.n672 VDD.n207 4.251
R404 VDD.n672 VDD.n205 4.251
R405 VDD.n672 VDD.n203 4.251
R406 VDD.n672 VDD.n200 4.251
R407 VDD.n672 VDD.n198 4.251
R408 VDD.n672 VDD.n196 4.251
R409 VDD.n672 VDD.n193 4.251
R410 VDD.n672 VDD.n191 4.251
R411 VDD.n672 VDD.n188 4.251
R412 VDD.n672 VDD.n180 4.251
R413 VDD.n672 VDD.n178 4.251
R414 VDD.n107 VDD.n63 3.8949
R415 VDD.n678 VDD.n677 3.37176
R416 VDD.n672 VDD.n186 2.83433
R417 VDD.n672 VDD.n184 2.83433
R418 VDD.n109 VDD.n108 2.49383
R419 VDD.n117 VDD.n62 2.49383
R420 VDD.n127 VDD.n17 2.49383
R421 VDD.n680 VDD.n10 2.30226
R422 VDD.n696 VDD.n1 2.28717
R423 VDD.n13 VDD.n4 2.28013
R424 VDD.n694 VDD.n693 2.28013
R425 VDD.n109 VDD.t20 2.26595
R426 VDD.n108 VDD.t22 2.26595
R427 VDD.n686 VDD.n4 2.26577
R428 VDD.n14 VDD.n13 2.26577
R429 VDD.n693 VDD.n687 2.26577
R430 VDD.n695 VDD.n694 2.26577
R431 VDD.n17 VDD.t6 2.26371
R432 VDD.n127 VDD.t17 2.26371
R433 VDD.n122 VDD.t14 2.26371
R434 VDD.n62 VDD.t15 2.26371
R435 VDD.n117 VDD.t2 2.26371
R436 VDD.n1 VDD.n0 2.2505
R437 VDD.n696 VDD.n695 2.2505
R438 VDD.n2 VDD.n0 2.2505
R439 VDD.n691 VDD.n690 2.2505
R440 VDD.n688 VDD.n687 2.2505
R441 VDD.n3 VDD.n2 2.2505
R442 VDD.n692 VDD.n691 2.2505
R443 VDD.n11 VDD.n5 2.2505
R444 VDD.n15 VDD.n12 2.2505
R445 VDD.n686 VDD.n685 2.2505
R446 VDD.n6 VDD.n5 2.2505
R447 VDD.n679 VDD.n15 2.2505
R448 VDD.n14 VDD.n10 2.2505
R449 VDD.n685 VDD.n684 2.2505
R450 VDD.n682 VDD.n6 2.2505
R451 VDD.n680 VDD.n679 2.2505
R452 VDD.n120 VDD.n119 2.0949
R453 VDD.n677 VDD.n16 2.0949
R454 VDD.n672 VDD.n671 1.98947
R455 VDD.n672 VDD.n34 1.97621
R456 VDD.n108 VDD.n107 1.8705
R457 VDD.n121 VDD.n62 1.8705
R458 VDD.n676 VDD.n17 1.8705
R459 VDD.n677 VDD.n676 1.8005
R460 VDD.n128 VDD.n16 1.8005
R461 VDD.n121 VDD.n120 1.8005
R462 VDD.n119 VDD.n118 1.8005
R463 VDD.n110 VDD.n63 1.8005
R464 VDD.n659 VDD.n658 1.52982
R465 VDD.n674 VDD.n19 1.43536
R466 VDD.n68 VDD.n49 1.43201
R467 VDD.n659 VDD.n9 1.43197
R468 VDD.n61 VDD.n54 1.38155
R469 VDD.n64 VDD.n54 1.37725
R470 VDD.n111 VDD.n49 1.36801
R471 VDD.n130 VDD.n19 1.36345
R472 VDD.n281 VDD.n280 1.18607
R473 VDD.n72 VDD.n71 1.18574
R474 VDD.n689 VDD.n1 1.16442
R475 VDD.n248 VDD.n247 1.14175
R476 VDD.n278 VDD.n277 1.14175
R477 VDD.n276 VDD.n273 1.14175
R478 VDD.n275 VDD.n274 1.14175
R479 VDD.n271 VDD.n264 1.14175
R480 VDD.n270 VDD.n269 1.14175
R481 VDD.n268 VDD.n267 1.14175
R482 VDD.n266 VDD.n265 1.14175
R483 VDD.n261 VDD.n258 1.14175
R484 VDD.n260 VDD.n259 1.14175
R485 VDD.n256 VDD.n253 1.14175
R486 VDD.n255 VDD.n254 1.14175
R487 VDD.n251 VDD.n249 1.14175
R488 VDD.n250 VDD.n20 1.14175
R489 VDD.n675 VDD.n674 1.14175
R490 VDD.n73 VDD.n70 1.14175
R491 VDD.n75 VDD.n74 1.14175
R492 VDD.n78 VDD.n77 1.14175
R493 VDD.n80 VDD.n79 1.14175
R494 VDD.n83 VDD.n82 1.14175
R495 VDD.n85 VDD.n84 1.14175
R496 VDD.n87 VDD.n86 1.14175
R497 VDD.n89 VDD.n88 1.14175
R498 VDD.n92 VDD.n91 1.14175
R499 VDD.n94 VDD.n93 1.14175
R500 VDD.n97 VDD.n96 1.14175
R501 VDD.n99 VDD.n98 1.14175
R502 VDD.n102 VDD.n101 1.14175
R503 VDD.n104 VDD.n103 1.14175
R504 VDD.n106 VDD.n68 1.14175
R505 VDD.n113 VDD.n67 1.06612
R506 VDD.n114 VDD.n66 1.06612
R507 VDD.n115 VDD.n65 1.06612
R508 VDD.n116 VDD.n64 1.06612
R509 VDD.n123 VDD.n61 1.06612
R510 VDD.n124 VDD.n60 1.06612
R511 VDD.n125 VDD.n59 1.06612
R512 VDD.n126 VDD.n58 1.06612
R513 VDD.n130 VDD.n129 1.06612
R514 VDD.n112 VDD.n111 1.06612
R515 VDD.n119 VDD.n63 0.9399
R516 VDD.n120 VDD.n16 0.9399
R517 VDD.n676 VDD.n675 0.843833
R518 VDD.n107 VDD.n106 0.843833
R519 VDD.n118 VDD.n116 0.757405
R520 VDD.n129 VDD.n128 0.757405
R521 VDD.n112 VDD.n110 0.746929
R522 VDD.n110 VDD.n109 0.623833
R523 VDD.n118 VDD.n117 0.623833
R524 VDD.n122 VDD.n121 0.623833
R525 VDD.n128 VDD.n127 0.623833
R526 VDD.n71 VDD.n34 0.525183
R527 VDD.n671 VDD.n281 0.509337
R528 VDD.n672 VDD.n245 0.48667
R529 VDD.n576 VDD.n546 0.48175
R530 VDD.n613 VDD.n517 0.48175
R531 VDD.n477 VDD.n476 0.48175
R532 VDD.n441 VDD.n440 0.48175
R533 VDD.n406 VDD.n282 0.48175
R534 VDD.n405 VDD.n404 0.48175
R535 VDD.n409 VDD.n408 0.48175
R536 VDD.n412 VDD.n411 0.48175
R537 VDD.n414 VDD.n413 0.48175
R538 VDD.n417 VDD.n416 0.48175
R539 VDD.n420 VDD.n419 0.48175
R540 VDD.n422 VDD.n421 0.48175
R541 VDD.n400 VDD.n399 0.48175
R542 VDD.n425 VDD.n424 0.48175
R543 VDD.n428 VDD.n427 0.48175
R544 VDD.n430 VDD.n429 0.48175
R545 VDD.n396 VDD.n395 0.48175
R546 VDD.n433 VDD.n432 0.48175
R547 VDD.n436 VDD.n435 0.48175
R548 VDD.n438 VDD.n437 0.48175
R549 VDD.n392 VDD.n391 0.48175
R550 VDD.n444 VDD.n443 0.48175
R551 VDD.n446 VDD.n445 0.48175
R552 VDD.n388 VDD.n387 0.48175
R553 VDD.n451 VDD.n450 0.48175
R554 VDD.n449 VDD.n448 0.48175
R555 VDD.n384 VDD.n383 0.48175
R556 VDD.n454 VDD.n453 0.48175
R557 VDD.n457 VDD.n456 0.48175
R558 VDD.n459 VDD.n458 0.48175
R559 VDD.n380 VDD.n379 0.48175
R560 VDD.n462 VDD.n461 0.48175
R561 VDD.n465 VDD.n464 0.48175
R562 VDD.n467 VDD.n466 0.48175
R563 VDD.n376 VDD.n375 0.48175
R564 VDD.n470 VDD.n469 0.48175
R565 VDD.n473 VDD.n472 0.48175
R566 VDD.n478 VDD.n475 0.48175
R567 VDD.n480 VDD.n479 0.48175
R568 VDD.n372 VDD.n371 0.48175
R569 VDD.n483 VDD.n482 0.48175
R570 VDD.n486 VDD.n485 0.48175
R571 VDD.n488 VDD.n487 0.48175
R572 VDD.n368 VDD.n367 0.48175
R573 VDD.n651 VDD.n650 0.48175
R574 VDD.n649 VDD.n490 0.48175
R575 VDD.n647 VDD.n491 0.48175
R576 VDD.n493 VDD.n492 0.48175
R577 VDD.n642 VDD.n494 0.48175
R578 VDD.n640 VDD.n496 0.48175
R579 VDD.n498 VDD.n497 0.48175
R580 VDD.n500 VDD.n499 0.48175
R581 VDD.n633 VDD.n501 0.48175
R582 VDD.n631 VDD.n503 0.48175
R583 VDD.n505 VDD.n504 0.48175
R584 VDD.n507 VDD.n506 0.48175
R585 VDD.n624 VDD.n508 0.48175
R586 VDD.n622 VDD.n510 0.48175
R587 VDD.n512 VDD.n511 0.48175
R588 VDD.n514 VDD.n513 0.48175
R589 VDD.n615 VDD.n515 0.48175
R590 VDD.n519 VDD.n518 0.48175
R591 VDD.n609 VDD.n520 0.48175
R592 VDD.n607 VDD.n522 0.48175
R593 VDD.n524 VDD.n523 0.48175
R594 VDD.n526 VDD.n525 0.48175
R595 VDD.n600 VDD.n527 0.48175
R596 VDD.n598 VDD.n529 0.48175
R597 VDD.n531 VDD.n530 0.48175
R598 VDD.n533 VDD.n532 0.48175
R599 VDD.n591 VDD.n534 0.48175
R600 VDD.n589 VDD.n536 0.48175
R601 VDD.n538 VDD.n537 0.48175
R602 VDD.n540 VDD.n539 0.48175
R603 VDD.n582 VDD.n541 0.48175
R604 VDD.n580 VDD.n543 0.48175
R605 VDD.n545 VDD.n544 0.48175
R606 VDD.n574 VDD.n548 0.48175
R607 VDD.n550 VDD.n549 0.48175
R608 VDD.n552 VDD.n551 0.48175
R609 VDD.n567 VDD.n553 0.48175
R610 VDD.n565 VDD.n555 0.48175
R611 VDD.n557 VDD.n556 0.48175
R612 VDD.n560 VDD.n558 0.48175
R613 VDD.n334 VDD.n333 0.48175
R614 VDD.n658 VDD.n332 0.48175
R615 VDD.n665 VDD.n287 0.48175
R616 VDD.n666 VDD.n286 0.48175
R617 VDD.n667 VDD.n285 0.48175
R618 VDD.n668 VDD.n284 0.48175
R619 VDD.n669 VDD.n283 0.48175
R620 VDD.n664 VDD.n288 0.48175
R621 VDD.n663 VDD.n662 0.48175
R622 VDD.n332 VDD.n34 0.471337
R623 VDD.n312 VDD.n7 0.468
R624 VDD.n306 VDD.n305 0.468
R625 VDD.n307 VDD.n304 0.468
R626 VDD.n308 VDD.n303 0.468
R627 VDD.n310 VDD.n309 0.468
R628 VDD.n683 VDD.n8 0.468
R629 VDD.n681 VDD.n9 0.468
R630 VDD.n291 VDD.n289 0.468
R631 VDD.n671 VDD.n670 0.290822
R632 VDD.n113 VDD.n112 0.183833
R633 VDD.n114 VDD.n113 0.183833
R634 VDD.n115 VDD.n114 0.183833
R635 VDD.n116 VDD.n115 0.183833
R636 VDD.n124 VDD.n123 0.183833
R637 VDD.n125 VDD.n124 0.183833
R638 VDD.n126 VDD.n125 0.183833
R639 VDD.n129 VDD.n126 0.183833
R640 VDD.n478 VDD.n477 0.183833
R641 VDD.n672 VDD.n54 0.144068
R642 VDD.n278 VDD.n248 0.131125
R643 VDD.n276 VDD.n275 0.131125
R644 VDD.n271 VDD.n270 0.131125
R645 VDD.n267 VDD.n266 0.131125
R646 VDD.n261 VDD.n260 0.131125
R647 VDD.n256 VDD.n255 0.131125
R648 VDD.n251 VDD.n250 0.131125
R649 VDD.n75 VDD.n73 0.131125
R650 VDD.n80 VDD.n78 0.131125
R651 VDD.n84 VDD.n83 0.131125
R652 VDD.n89 VDD.n87 0.131125
R653 VDD.n94 VDD.n92 0.131125
R654 VDD.n99 VDD.n97 0.131125
R655 VDD.n104 VDD.n102 0.131125
R656 VDD.n269 VDD.n268 0.128833
R657 VDD.n86 VDD.n85 0.128833
R658 VDD.n265 VDD.n27 0.125167
R659 VDD.n274 VDD.n24 0.125167
R660 VDD.n88 VDD.n42 0.125167
R661 VDD.n79 VDD.n39 0.125167
R662 VDD.n546 VDD.n140 0.125167
R663 VDD.n517 VDD.n158 0.125167
R664 VDD.n650 VDD.n174 0.125167
R665 VDD.n476 VDD.n189 0.125167
R666 VDD.n440 VDD.n216 0.125167
R667 VDD.n562 VDD.n561 0.125167
R668 VDD.n571 VDD.n570 0.125167
R669 VDD.n577 VDD.n576 0.125167
R670 VDD.n586 VDD.n585 0.125167
R671 VDD.n595 VDD.n594 0.125167
R672 VDD.n604 VDD.n603 0.125167
R673 VDD.n613 VDD.n612 0.125167
R674 VDD.n619 VDD.n618 0.125167
R675 VDD.n628 VDD.n627 0.125167
R676 VDD.n637 VDD.n636 0.125167
R677 VDD.n646 VDD.n645 0.125167
R678 VDD.n652 VDD.n651 0.125167
R679 VDD.n452 VDD.n451 0.125167
R680 VDD.n414 VDD.n402 0.125167
R681 VDD.n313 VDD.n312 0.125167
R682 VDD.n123 VDD.n122 0.123595
R683 VDD.n111 VDD.n50 0.123333
R684 VDD.n293 VDD.t4 0.122429
R685 VDD.n544 VDD.n141 0.121772
R686 VDD.n518 VDD.n157 0.121772
R687 VDD.n475 VDD.n187 0.121772
R688 VDD.n391 VDD.n218 0.121772
R689 VDD.n404 VDD.n246 0.121772
R690 VDD.n575 VDD.n574 0.121772
R691 VDD.n615 VDD.n614 0.121772
R692 VDD.n368 VDD.n366 0.121772
R693 VDD.n388 VDD.n386 0.121772
R694 VDD.n415 VDD.n412 0.121772
R695 VDD.n311 VDD.n310 0.121772
R696 VDD.n258 VDD.n29 0.1215
R697 VDD.n264 VDD.n26 0.1215
R698 VDD.n273 VDD.n23 0.1215
R699 VDD.n91 VDD.n43 0.1215
R700 VDD.n82 VDD.n40 0.1215
R701 VDD.n77 VDD.n37 0.1215
R702 VDD.n67 VDD.n51 0.119667
R703 VDD.n259 VDD.n30 0.117833
R704 VDD.n277 VDD.n22 0.117833
R705 VDD.n93 VDD.n44 0.117833
R706 VDD.n74 VDD.n36 0.117833
R707 VDD.n549 VDD.n139 0.117833
R708 VDD.n543 VDD.n142 0.117833
R709 VDD.n520 VDD.n156 0.117833
R710 VDD.n513 VDD.n159 0.117833
R711 VDD.n491 VDD.n173 0.117833
R712 VDD.n479 VDD.n185 0.117833
R713 VDD.n469 VDD.n190 0.117833
R714 VDD.n445 VDD.n215 0.117833
R715 VDD.n437 VDD.n220 0.117833
R716 VDD.n408 VDD.n244 0.117833
R717 VDD.n573 VDD.n550 0.117833
R718 VDD.n580 VDD.n579 0.117833
R719 VDD.n610 VDD.n609 0.117833
R720 VDD.n616 VDD.n514 0.117833
R721 VDD.n648 VDD.n647 0.117833
R722 VDD.n488 VDD.n369 0.117833
R723 VDD.n385 VDD.n384 0.117833
R724 VDD.n446 VDD.n389 0.117833
R725 VDD.n420 VDD.n418 0.117833
R726 VDD.n410 VDD.n409 0.117833
R727 VDD.n303 VDD.n302 0.117833
R728 VDD.n314 VDD.n9 0.117833
R729 VDD.n66 VDD.n52 0.116
R730 VDD.n131 VDD.n130 0.116
R731 VDD.n551 VDD.n138 0.114439
R732 VDD.n511 VDD.n160 0.114439
R733 VDD.n492 VDD.n172 0.114439
R734 VDD.n375 VDD.n192 0.114439
R735 VDD.n387 VDD.n213 0.114439
R736 VDD.n582 VDD.n581 0.114439
R737 VDD.n608 VDD.n607 0.114439
R738 VDD.n489 VDD.n486 0.114439
R739 VDD.n454 VDD.n382 0.114439
R740 VDD.n447 VDD.n444 0.114439
R741 VDD.n423 VDD.n422 0.114439
R742 VDD.n405 VDD.n403 0.114439
R743 VDD.n541 VDD.n143 0.114439
R744 VDD.n522 VDD.n155 0.114439
R745 VDD.n371 VDD.n183 0.114439
R746 VDD.n435 VDD.n221 0.114439
R747 VDD.n411 VDD.n242 0.114439
R748 VDD.n304 VDD.n301 0.114439
R749 VDD.n253 VDD.n31 0.114167
R750 VDD.n247 VDD.n21 0.114167
R751 VDD.n96 VDD.n45 0.114167
R752 VDD.n70 VDD.n35 0.114167
R753 VDD.n65 VDD.n53 0.112333
R754 VDD.n58 VDD.n57 0.112333
R755 VDD.n254 VDD.n32 0.1105
R756 VDD.n98 VDD.n46 0.1105
R757 VDD.n553 VDD.n137 0.1105
R758 VDD.n539 VDD.n144 0.1105
R759 VDD.n523 VDD.n154 0.1105
R760 VDD.n510 VDD.n161 0.1105
R761 VDD.n494 VDD.n171 0.1105
R762 VDD.n482 VDD.n182 0.1105
R763 VDD.n466 VDD.n194 0.1105
R764 VDD.n450 VDD.n211 0.1105
R765 VDD.n432 VDD.n223 0.1105
R766 VDD.n413 VDD.n241 0.1105
R767 VDD.n568 VDD.n567 0.1105
R768 VDD.n583 VDD.n540 0.1105
R769 VDD.n606 VDD.n524 0.1105
R770 VDD.n622 VDD.n621 0.1105
R771 VDD.n643 VDD.n642 0.1105
R772 VDD.n484 VDD.n483 0.1105
R773 VDD.n457 VDD.n455 0.1105
R774 VDD.n442 VDD.n441 0.1105
R775 VDD.n401 VDD.n400 0.1105
R776 VDD.n407 VDD.n406 0.1105
R777 VDD.n305 VDD.n300 0.1105
R778 VDD.t1 VDD.n331 0.10928
R779 VDD.n59 VDD.n56 0.108667
R780 VDD.n537 VDD.n145 0.107106
R781 VDD.n525 VDD.n153 0.107106
R782 VDD.n485 VDD.n181 0.107106
R783 VDD.n395 VDD.n225 0.107106
R784 VDD.n416 VDD.n239 0.107106
R785 VDD.n566 VDD.n565 0.107106
R786 VDD.n624 VDD.n623 0.107106
R787 VDD.n641 VDD.n640 0.107106
R788 VDD.n372 VDD.n370 0.107106
R789 VDD.n474 VDD.n473 0.107106
R790 VDD.n460 VDD.n459 0.107106
R791 VDD.n392 VDD.n390 0.107106
R792 VDD.n425 VDD.n398 0.107106
R793 VDD.n292 VDD.n283 0.107106
R794 VDD.n299 VDD.n291 0.107106
R795 VDD.n555 VDD.n136 0.107106
R796 VDD.n508 VDD.n162 0.107106
R797 VDD.n496 VDD.n170 0.107106
R798 VDD.n464 VDD.n195 0.107106
R799 VDD.n448 VDD.n209 0.107106
R800 VDD.n249 VDD.n33 0.106833
R801 VDD.n101 VDD.n47 0.106833
R802 VDD.n672 VDD.n175 0.10659
R803 VDD.n60 VDD.n55 0.105
R804 VDD.n673 VDD.n20 0.103167
R805 VDD.n103 VDD.n48 0.103167
R806 VDD.n556 VDD.n135 0.103167
R807 VDD.n536 VDD.n146 0.103167
R808 VDD.n527 VDD.n152 0.103167
R809 VDD.n506 VDD.n163 0.103167
R810 VDD.n497 VDD.n169 0.103167
R811 VDD.n487 VDD.n179 0.103167
R812 VDD.n461 VDD.n197 0.103167
R813 VDD.n383 VDD.n208 0.103167
R814 VDD.n429 VDD.n227 0.103167
R815 VDD.n419 VDD.n237 0.103167
R816 VDD.n564 VDD.n557 0.103167
R817 VDD.n589 VDD.n588 0.103167
R818 VDD.n601 VDD.n600 0.103167
R819 VDD.n625 VDD.n507 0.103167
R820 VDD.n639 VDD.n498 0.103167
R821 VDD.n480 VDD.n373 0.103167
R822 VDD.n471 VDD.n470 0.103167
R823 VDD.n381 VDD.n380 0.103167
R824 VDD.n438 VDD.n393 0.103167
R825 VDD.n428 VDD.n426 0.103167
R826 VDD.n294 VDD.n284 0.103167
R827 VDD.n662 VDD.n661 0.103167
R828 VDD.n558 VDD.n134 0.0997723
R829 VDD.n534 VDD.n147 0.0997723
R830 VDD.n529 VDD.n151 0.0997723
R831 VDD.n504 VDD.n164 0.0997723
R832 VDD.n499 VDD.n168 0.0997723
R833 VDD.n367 VDD.n177 0.0997723
R834 VDD.n379 VDD.n199 0.0997723
R835 VDD.n453 VDD.n206 0.0997723
R836 VDD.n427 VDD.n228 0.0997723
R837 VDD.n421 VDD.n235 0.0997723
R838 VDD.n591 VDD.n590 0.0997723
R839 VDD.n599 VDD.n598 0.0997723
R840 VDD.n481 VDD.n478 0.0997723
R841 VDD.n376 VDD.n374 0.0997723
R842 VDD.n462 VDD.n378 0.0997723
R843 VDD.n439 VDD.n436 0.0997723
R844 VDD.n431 VDD.n430 0.0997723
R845 VDD.n295 VDD.n285 0.0997723
R846 VDD.n290 VDD.n288 0.0997723
R847 VDD.n670 VDD.n282 0.0981328
R848 VDD.n333 VDD.n133 0.0958333
R849 VDD.n532 VDD.n148 0.0958333
R850 VDD.n530 VDD.n150 0.0958333
R851 VDD.n503 VDD.n165 0.0958333
R852 VDD.n501 VDD.n167 0.0958333
R853 VDD.n650 VDD.n176 0.0958333
R854 VDD.n458 VDD.n201 0.0958333
R855 VDD.n456 VDD.n204 0.0958333
R856 VDD.n424 VDD.n230 0.0958333
R857 VDD.n399 VDD.n234 0.0958333
R858 VDD.n559 VDD.n334 0.0958333
R859 VDD.n592 VDD.n533 0.0958333
R860 VDD.n597 VDD.n531 0.0958333
R861 VDD.n631 VDD.n630 0.0958333
R862 VDD.n634 VDD.n633 0.0958333
R863 VDD.n467 VDD.n377 0.0958333
R864 VDD.n465 VDD.n463 0.0958333
R865 VDD.n434 VDD.n433 0.0958333
R866 VDD.n397 VDD.n396 0.0958333
R867 VDD.n296 VDD.n286 0.0958333
R868 VDD.n298 VDD.n287 0.0958333
R869 VDD.n669 VDD.n668 0.0937203
R870 VDD.n668 VDD.n667 0.0937203
R871 VDD.n667 VDD.n666 0.0937203
R872 VDD.n666 VDD.n665 0.0937203
R873 VDD.n532 VDD.n149 0.092439
R874 VDD.n530 VDD.n149 0.092439
R875 VDD.n424 VDD.n232 0.092439
R876 VDD.n399 VDD.n232 0.092439
R877 VDD.n658 VDD.n657 0.092439
R878 VDD.n657 VDD.n334 0.092439
R879 VDD.n632 VDD.n631 0.092439
R880 VDD.n633 VDD.n632 0.092439
R881 VDD.n468 VDD.n467 0.092439
R882 VDD.n468 VDD.n465 0.092439
R883 VDD.n433 VDD.n394 0.092439
R884 VDD.n396 VDD.n394 0.092439
R885 VDD.n297 VDD.n286 0.092439
R886 VDD.n297 VDD.n287 0.092439
R887 VDD.n332 VDD.n132 0.0924389
R888 VDD.n333 VDD.n132 0.0924389
R889 VDD.n503 VDD.n166 0.0924389
R890 VDD.n501 VDD.n166 0.0924389
R891 VDD.n458 VDD.n202 0.0924389
R892 VDD.n456 VDD.n202 0.0924389
R893 VDD.n558 VDD.n133 0.0885
R894 VDD.n534 VDD.n148 0.0885
R895 VDD.n529 VDD.n150 0.0885
R896 VDD.n504 VDD.n165 0.0885
R897 VDD.n499 VDD.n167 0.0885
R898 VDD.n367 VDD.n176 0.0885
R899 VDD.n379 VDD.n201 0.0885
R900 VDD.n453 VDD.n204 0.0885
R901 VDD.n427 VDD.n230 0.0885
R902 VDD.n421 VDD.n234 0.0885
R903 VDD.n560 VDD.n559 0.0885
R904 VDD.n592 VDD.n591 0.0885
R905 VDD.n598 VDD.n597 0.0885
R906 VDD.n630 VDD.n505 0.0885
R907 VDD.n634 VDD.n500 0.0885
R908 VDD.n377 VDD.n376 0.0885
R909 VDD.n463 VDD.n462 0.0885
R910 VDD.n436 VDD.n434 0.0885
R911 VDD.n430 VDD.n397 0.0885
R912 VDD.n296 VDD.n285 0.0885
R913 VDD.n298 VDD.n288 0.0885
R914 VDD.n280 VDD.n248 0.0881392
R915 VDD.n73 VDD.n72 0.087469
R916 VDD.n556 VDD.n134 0.0851056
R917 VDD.n506 VDD.n164 0.0851056
R918 VDD.n497 VDD.n168 0.0851056
R919 VDD.n461 VDD.n199 0.0851056
R920 VDD.n383 VDD.n206 0.0851056
R921 VDD.n590 VDD.n589 0.0851056
R922 VDD.n600 VDD.n599 0.0851056
R923 VDD.n481 VDD.n480 0.0851056
R924 VDD.n470 VDD.n374 0.0851056
R925 VDD.n380 VDD.n378 0.0851056
R926 VDD.n439 VDD.n438 0.0851056
R927 VDD.n431 VDD.n428 0.0851056
R928 VDD.n536 VDD.n147 0.0851056
R929 VDD.n527 VDD.n151 0.0851056
R930 VDD.n487 VDD.n177 0.0851056
R931 VDD.n429 VDD.n228 0.0851056
R932 VDD.n419 VDD.n235 0.0851056
R933 VDD.n295 VDD.n284 0.0851056
R934 VDD.n662 VDD.n290 0.0851056
R935 VDD.n555 VDD.n135 0.0811667
R936 VDD.n537 VDD.n146 0.0811667
R937 VDD.n525 VDD.n152 0.0811667
R938 VDD.n508 VDD.n163 0.0811667
R939 VDD.n496 VDD.n169 0.0811667
R940 VDD.n485 VDD.n179 0.0811667
R941 VDD.n464 VDD.n197 0.0811667
R942 VDD.n448 VDD.n208 0.0811667
R943 VDD.n395 VDD.n227 0.0811667
R944 VDD.n416 VDD.n237 0.0811667
R945 VDD.n565 VDD.n564 0.0811667
R946 VDD.n588 VDD.n538 0.0811667
R947 VDD.n601 VDD.n526 0.0811667
R948 VDD.n625 VDD.n624 0.0811667
R949 VDD.n640 VDD.n639 0.0811667
R950 VDD.n373 VDD.n372 0.0811667
R951 VDD.n473 VDD.n471 0.0811667
R952 VDD.n459 VDD.n381 0.0811667
R953 VDD.n393 VDD.n392 0.0811667
R954 VDD.n426 VDD.n425 0.0811667
R955 VDD.n294 VDD.n283 0.0811667
R956 VDD.n661 VDD.n291 0.0811667
R957 VDD.n539 VDD.n145 0.0777723
R958 VDD.n523 VDD.n153 0.0777723
R959 VDD.n482 VDD.n181 0.0777723
R960 VDD.n432 VDD.n225 0.0777723
R961 VDD.n413 VDD.n239 0.0777723
R962 VDD.n567 VDD.n566 0.0777723
R963 VDD.n623 VDD.n622 0.0777723
R964 VDD.n642 VDD.n641 0.0777723
R965 VDD.n483 VDD.n370 0.0777723
R966 VDD.n477 VDD.n474 0.0777723
R967 VDD.n460 VDD.n457 0.0777723
R968 VDD.n441 VDD.n390 0.0777723
R969 VDD.n400 VDD.n398 0.0777723
R970 VDD.n406 VDD.n292 0.0777723
R971 VDD.n305 VDD.n299 0.0777723
R972 VDD.n553 VDD.n136 0.0777723
R973 VDD.n510 VDD.n162 0.0777723
R974 VDD.n494 VDD.n170 0.0777723
R975 VDD.n466 VDD.n195 0.0777723
R976 VDD.n450 VDD.n209 0.0777723
R977 VDD.n665 VDD.n664 0.0744778
R978 VDD.n551 VDD.n137 0.0738333
R979 VDD.n541 VDD.n144 0.0738333
R980 VDD.n522 VDD.n154 0.0738333
R981 VDD.n511 VDD.n161 0.0738333
R982 VDD.n492 VDD.n171 0.0738333
R983 VDD.n371 VDD.n182 0.0738333
R984 VDD.n375 VDD.n194 0.0738333
R985 VDD.n387 VDD.n211 0.0738333
R986 VDD.n435 VDD.n223 0.0738333
R987 VDD.n411 VDD.n241 0.0738333
R988 VDD.n568 VDD.n552 0.0738333
R989 VDD.n583 VDD.n582 0.0738333
R990 VDD.n607 VDD.n606 0.0738333
R991 VDD.n621 VDD.n512 0.0738333
R992 VDD.n643 VDD.n493 0.0738333
R993 VDD.n486 VDD.n484 0.0738333
R994 VDD.n455 VDD.n454 0.0738333
R995 VDD.n444 VDD.n442 0.0738333
R996 VDD.n422 VDD.n401 0.0738333
R997 VDD.n407 VDD.n405 0.0738333
R998 VDD.n304 VDD.n300 0.0738333
R999 VDD.n549 VDD.n138 0.070439
R1000 VDD.n513 VDD.n160 0.070439
R1001 VDD.n491 VDD.n172 0.070439
R1002 VDD.n469 VDD.n192 0.070439
R1003 VDD.n445 VDD.n213 0.070439
R1004 VDD.n581 VDD.n580 0.070439
R1005 VDD.n609 VDD.n608 0.070439
R1006 VDD.n489 VDD.n488 0.070439
R1007 VDD.n384 VDD.n382 0.070439
R1008 VDD.n447 VDD.n446 0.070439
R1009 VDD.n423 VDD.n420 0.070439
R1010 VDD.n409 VDD.n403 0.070439
R1011 VDD.n543 VDD.n143 0.0704389
R1012 VDD.n520 VDD.n155 0.0704389
R1013 VDD.n479 VDD.n183 0.0704389
R1014 VDD.n437 VDD.n221 0.0704389
R1015 VDD.n408 VDD.n242 0.0704389
R1016 VDD.n303 VDD.n301 0.0704389
R1017 VDD.n664 VDD.n663 0.0684012
R1018 VDD.n258 VDD.n28 0.0667723
R1019 VDD.n264 VDD.n25 0.0667723
R1020 VDD.n86 VDD.n41 0.0667723
R1021 VDD.n77 VDD.n38 0.0667723
R1022 VDD.n548 VDD.n139 0.0665
R1023 VDD.n544 VDD.n142 0.0665
R1024 VDD.n518 VDD.n156 0.0665
R1025 VDD.n515 VDD.n159 0.0665
R1026 VDD.n490 VDD.n173 0.0665
R1027 VDD.n475 VDD.n185 0.0665
R1028 VDD.n472 VDD.n190 0.0665
R1029 VDD.n443 VDD.n215 0.0665
R1030 VDD.n391 VDD.n220 0.0665
R1031 VDD.n404 VDD.n244 0.0665
R1032 VDD.n574 VDD.n573 0.0665
R1033 VDD.n579 VDD.n545 0.0665
R1034 VDD.n610 VDD.n519 0.0665
R1035 VDD.n616 VDD.n615 0.0665
R1036 VDD.n649 VDD.n648 0.0665
R1037 VDD.n369 VDD.n368 0.0665
R1038 VDD.n449 VDD.n385 0.0665
R1039 VDD.n389 VDD.n388 0.0665
R1040 VDD.n418 VDD.n417 0.0665
R1041 VDD.n412 VDD.n410 0.0665
R1042 VDD.n310 VDD.n302 0.0665
R1043 VDD.n314 VDD.n8 0.0665
R1044 VDD.n279 VDD.n276 0.0660625
R1045 VDD.n272 VDD.n271 0.0660625
R1046 VDD.n267 VDD.n263 0.0660625
R1047 VDD.n262 VDD.n261 0.0660625
R1048 VDD.n257 VDD.n256 0.0660625
R1049 VDD.n252 VDD.n251 0.0660625
R1050 VDD.n250 VDD.n18 0.0660625
R1051 VDD.n255 VDD.n252 0.0660625
R1052 VDD.n260 VDD.n257 0.0660625
R1053 VDD.n266 VDD.n262 0.0660625
R1054 VDD.n270 VDD.n263 0.0660625
R1055 VDD.n275 VDD.n272 0.0660625
R1056 VDD.n279 VDD.n278 0.0660625
R1057 VDD.n675 VDD.n18 0.0660625
R1058 VDD.n78 VDD.n76 0.0660625
R1059 VDD.n83 VDD.n81 0.0660625
R1060 VDD.n87 VDD.n69 0.0660625
R1061 VDD.n92 VDD.n90 0.0660625
R1062 VDD.n97 VDD.n95 0.0660625
R1063 VDD.n102 VDD.n100 0.0660625
R1064 VDD.n105 VDD.n104 0.0660625
R1065 VDD.n100 VDD.n99 0.0660625
R1066 VDD.n95 VDD.n94 0.0660625
R1067 VDD.n90 VDD.n89 0.0660625
R1068 VDD.n84 VDD.n69 0.0660625
R1069 VDD.n81 VDD.n80 0.0660625
R1070 VDD.n76 VDD.n75 0.0660625
R1071 VDD.n106 VDD.n105 0.0660625
R1072 VDD.n274 VDD.n25 0.0631056
R1073 VDD.n265 VDD.n28 0.0631056
R1074 VDD.n546 VDD.n141 0.0631056
R1075 VDD.n440 VDD.n218 0.0631056
R1076 VDD.n282 VDD.n246 0.0631056
R1077 VDD.n476 VDD.n187 0.0631056
R1078 VDD.n517 VDD.n157 0.0631056
R1079 VDD.n614 VDD.n613 0.0631056
R1080 VDD.n651 VDD.n366 0.0631056
R1081 VDD.n451 VDD.n386 0.0631056
R1082 VDD.n415 VDD.n414 0.0631056
R1083 VDD.n312 VDD.n311 0.0631056
R1084 VDD.n576 VDD.n575 0.0631056
R1085 VDD.n88 VDD.n41 0.0631056
R1086 VDD.n79 VDD.n38 0.0631056
R1087 VDD.n663 VDD.n289 0.0628094
R1088 VDD.n548 VDD.n140 0.0591667
R1089 VDD.n515 VDD.n158 0.0591667
R1090 VDD.n490 VDD.n174 0.0591667
R1091 VDD.n472 VDD.n189 0.0591667
R1092 VDD.n443 VDD.n216 0.0591667
R1093 VDD.n577 VDD.n545 0.0591667
R1094 VDD.n612 VDD.n519 0.0591667
R1095 VDD.n652 VDD.n649 0.0591667
R1096 VDD.n452 VDD.n449 0.0591667
R1097 VDD.n417 VDD.n402 0.0591667
R1098 VDD.n313 VDD.n8 0.0591667
R1099 VDD.n306 VDD.n289 0.0544216
R1100 VDD.n307 VDD.n306 0.0544216
R1101 VDD.n308 VDD.n307 0.0544216
R1102 VDD.n309 VDD.n308 0.0544216
R1103 VDD.n309 VDD.n7 0.0544216
R1104 VDD.n570 VDD.n552 0.0518333
R1105 VDD.n619 VDD.n512 0.0518333
R1106 VDD.n645 VDD.n493 0.0518333
R1107 VDD.n672 VDD.n19 0.0505254
R1108 VDD.n672 VDD.n49 0.0502672
R1109 VDD.n684 VDD.n683 0.0447157
R1110 VDD.n586 VDD.n538 0.0445
R1111 VDD.n603 VDD.n526 0.0445
R1112 VDD.n561 VDD.n560 0.0371667
R1113 VDD.n628 VDD.n505 0.0371667
R1114 VDD.n636 VDD.n500 0.0371667
R1115 VDD.n670 VDD.n669 0.0303305
R1116 VDD.n12 VDD.n11 0.0300385
R1117 VDD.n692 VDD.n3 0.0300385
R1118 VDD.n690 VDD.n0 0.0300385
R1119 VDD.n691 VDD.n687 0.0300385
R1120 VDD.n691 VDD.n2 0.0300385
R1121 VDD.n695 VDD.n2 0.0300385
R1122 VDD.n686 VDD.n5 0.0300385
R1123 VDD.n15 VDD.n5 0.0300385
R1124 VDD.n15 VDD.n14 0.0300385
R1125 VDD.n685 VDD.n6 0.0300385
R1126 VDD.n679 VDD.n6 0.0300385
R1127 VDD.n594 VDD.n533 0.0298333
R1128 VDD.n595 VDD.n531 0.0298333
R1129 VDD.n678 VDD.n10 0.0285
R1130 VDD.n682 VDD 0.0263824
R1131 VDD.n674 VDD.n673 0.0261667
R1132 VDD.n68 VDD.n48 0.0261667
R1133 VDD.n61 VDD.n55 0.0243333
R1134 VDD.n33 VDD.n20 0.0225
R1135 VDD.n103 VDD.n47 0.0225
R1136 VDD.n562 VDD.n557 0.0225
R1137 VDD.n627 VDD.n507 0.0225
R1138 VDD.n637 VDD.n498 0.0225
R1139 VDD VDD.n681 0.0209902
R1140 VDD.n60 VDD.n56 0.0206667
R1141 VDD.n249 VDD.n32 0.0188333
R1142 VDD.n101 VDD.n46 0.0188333
R1143 VDD.n64 VDD.n53 0.017
R1144 VDD.n59 VDD.n57 0.017
R1145 VDD VDD.n0 0.0165
R1146 VDD.n689 VDD.n688 0.0157923
R1147 VDD.n11 VDD.n4 0.0155798
R1148 VDD.n13 VDD.n12 0.0155798
R1149 VDD.n694 VDD.n3 0.0155798
R1150 VDD.n693 VDD.n692 0.0155798
R1151 VDD.n690 VDD.n689 0.0155551
R1152 VDD.n254 VDD.n31 0.0151667
R1153 VDD.n281 VDD.n21 0.0151667
R1154 VDD.n98 VDD.n45 0.0151667
R1155 VDD.n71 VDD.n35 0.0151667
R1156 VDD.n585 VDD.n540 0.0151667
R1157 VDD.n604 VDD.n524 0.0151667
R1158 VDD VDD.n696 0.0140385
R1159 VDD.n65 VDD.n52 0.0133333
R1160 VDD.n131 VDD.n58 0.0133333
R1161 VDD.n253 VDD.n30 0.0115
R1162 VDD.n247 VDD.n22 0.0115
R1163 VDD.n96 VDD.n44 0.0115
R1164 VDD.n70 VDD.n36 0.0115
R1165 VDD.n684 VDD.n7 0.0102059
R1166 VDD.n66 VDD.n51 0.00966667
R1167 VDD.n683 VDD.n682 0.00804902
R1168 VDD.n259 VDD.n29 0.00783333
R1169 VDD.n269 VDD.n26 0.00783333
R1170 VDD.n277 VDD.n23 0.00783333
R1171 VDD.n93 VDD.n43 0.00783333
R1172 VDD.n85 VDD.n40 0.00783333
R1173 VDD.n74 VDD.n37 0.00783333
R1174 VDD.n571 VDD.n550 0.00783333
R1175 VDD.n618 VDD.n514 0.00783333
R1176 VDD.n647 VDD.n646 0.00783333
R1177 VDD.n67 VDD.n50 0.006
R1178 VDD.n681 VDD.n680 0.00589216
R1179 VDD.n268 VDD.n27 0.00416667
R1180 VDD.n273 VDD.n24 0.00416667
R1181 VDD.n91 VDD.n42 0.00416667
R1182 VDD.n82 VDD.n39 0.00416667
R1183 VDD.n679 VDD.n678 0.00203846
R1184 VDD.n315 VDD.n245 0.00194282
R1185 VDD.t4 VDD.n245 0.00105713
R1186 VDD.n660 VDD.n659 0.00100831
R1187 VDD.n656 VDD.n331 0.001
R1188 VDD.n655 VDD.n335 0.001
R1189 VDD.n563 VDD.n364 0.001
R1190 VDD.n554 VDD.n363 0.001
R1191 VDD.n569 VDD.n362 0.001
R1192 VDD.n572 VDD.n361 0.001
R1193 VDD.n547 VDD.n360 0.001
R1194 VDD.n578 VDD.n359 0.001
R1195 VDD.n542 VDD.n358 0.001
R1196 VDD.n584 VDD.n357 0.001
R1197 VDD.n587 VDD.n356 0.001
R1198 VDD.n535 VDD.n355 0.001
R1199 VDD.n593 VDD.n354 0.001
R1200 VDD.n596 VDD.n353 0.001
R1201 VDD.n528 VDD.n352 0.001
R1202 VDD.n602 VDD.n351 0.001
R1203 VDD.n605 VDD.n350 0.001
R1204 VDD.n521 VDD.n349 0.001
R1205 VDD.n611 VDD.n348 0.001
R1206 VDD.n516 VDD.n347 0.001
R1207 VDD.n617 VDD.n346 0.001
R1208 VDD.n620 VDD.n345 0.001
R1209 VDD.n509 VDD.n344 0.001
R1210 VDD.n626 VDD.n343 0.001
R1211 VDD.n629 VDD.n342 0.001
R1212 VDD.n502 VDD.n341 0.001
R1213 VDD.n635 VDD.n340 0.001
R1214 VDD.n638 VDD.n339 0.001
R1215 VDD.n495 VDD.n338 0.001
R1216 VDD.n644 VDD.n337 0.001
R1217 VDD.n365 VDD.n336 0.001
R1218 VDD.n654 VDD.n365 0.001
R1219 VDD.n660 VDD.n293 0.001
R1220 VDD.t1 VDD.n175 0.001
R1221 VDD.n330 VDD.n178 0.001
R1222 VDD.n329 VDD.n180 0.001
R1223 VDD.t0 VDD.n184 0.001
R1224 VDD.n328 VDD.n186 0.001
R1225 VDD.n327 VDD.n188 0.001
R1226 VDD.t9 VDD.n191 0.001
R1227 VDD.n326 VDD.n193 0.001
R1228 VDD.n325 VDD.n196 0.001
R1229 VDD.n324 VDD.n198 0.001
R1230 VDD.t7 VDD.n200 0.001
R1231 VDD.n323 VDD.n203 0.001
R1232 VDD.t18 VDD.n205 0.001
R1233 VDD.t13 VDD.n207 0.001
R1234 VDD.n322 VDD.n210 0.001
R1235 VDD.n321 VDD.n212 0.001
R1236 VDD.t16 VDD.n214 0.001
R1237 VDD.t12 VDD.n217 0.001
R1238 VDD.n320 VDD.n219 0.001
R1239 VDD.t27 VDD.n222 0.001
R1240 VDD.t10 VDD.n224 0.001
R1241 VDD.n319 VDD.n226 0.001
R1242 VDD.n318 VDD.n229 0.001
R1243 VDD.t5 VDD.n231 0.001
R1244 VDD.t8 VDD.n233 0.001
R1245 VDD.n317 VDD.n236 0.001
R1246 VDD.t25 VDD.n238 0.001
R1247 VDD.t11 VDD.n240 0.001
R1248 VDD.n316 VDD.n243 0.001
R1249 VDD.n660 VDD.n331 0.001
R1250 VDD.n315 VDD.n243 0.001
R1251 VDD.n316 VDD.n240 0.001
R1252 VDD.t11 VDD.n238 0.001
R1253 VDD.t25 VDD.n236 0.001
R1254 VDD.n317 VDD.n233 0.001
R1255 VDD.t8 VDD.n231 0.001
R1256 VDD.t5 VDD.n229 0.001
R1257 VDD.n318 VDD.n226 0.001
R1258 VDD.n319 VDD.n224 0.001
R1259 VDD.t10 VDD.n222 0.001
R1260 VDD.t27 VDD.n219 0.001
R1261 VDD.n320 VDD.n217 0.001
R1262 VDD.t12 VDD.n214 0.001
R1263 VDD.t16 VDD.n212 0.001
R1264 VDD.n321 VDD.n210 0.001
R1265 VDD.n322 VDD.n207 0.001
R1266 VDD.t13 VDD.n205 0.001
R1267 VDD.t18 VDD.n203 0.001
R1268 VDD.n323 VDD.n200 0.001
R1269 VDD.t7 VDD.n198 0.001
R1270 VDD.n324 VDD.n196 0.001
R1271 VDD.n325 VDD.n193 0.001
R1272 VDD.n326 VDD.n191 0.001
R1273 VDD.t9 VDD.n188 0.001
R1274 VDD.n327 VDD.n186 0.001
R1275 VDD.n328 VDD.n184 0.001
R1276 VDD.t0 VDD.n180 0.001
R1277 VDD.n329 VDD.n178 0.001
R1278 VDD.n330 VDD.n175 0.001
R1279 VDD.n653 VDD.n293 0.001
R1280 VDD.n654 VDD.n653 0.001
R1281 VDD.n644 VDD.n336 0.001
R1282 VDD.n495 VDD.n337 0.001
R1283 VDD.n638 VDD.n338 0.001
R1284 VDD.n635 VDD.n339 0.001
R1285 VDD.n502 VDD.n340 0.001
R1286 VDD.n629 VDD.n341 0.001
R1287 VDD.n626 VDD.n342 0.001
R1288 VDD.n509 VDD.n343 0.001
R1289 VDD.n620 VDD.n344 0.001
R1290 VDD.n617 VDD.n345 0.001
R1291 VDD.n516 VDD.n346 0.001
R1292 VDD.n611 VDD.n347 0.001
R1293 VDD.n521 VDD.n348 0.001
R1294 VDD.n605 VDD.n349 0.001
R1295 VDD.n602 VDD.n350 0.001
R1296 VDD.n528 VDD.n351 0.001
R1297 VDD.n596 VDD.n352 0.001
R1298 VDD.n593 VDD.n353 0.001
R1299 VDD.n535 VDD.n354 0.001
R1300 VDD.n587 VDD.n355 0.001
R1301 VDD.n584 VDD.n356 0.001
R1302 VDD.n542 VDD.n357 0.001
R1303 VDD.n578 VDD.n358 0.001
R1304 VDD.n547 VDD.n359 0.001
R1305 VDD.n572 VDD.n360 0.001
R1306 VDD.n569 VDD.n361 0.001
R1307 VDD.n554 VDD.n362 0.001
R1308 VDD.n563 VDD.n363 0.001
R1309 VDD.n364 VDD.n335 0.001
R1310 VDD.n656 VDD.n655 0.001
R1311 VSS.n645 VSS.n644 967943
R1312 VSS.n636 VSS.n81 49.217
R1313 VSS.n298 VSS.n82 49.217
R1314 VSS.n302 VSS.n83 49.217
R1315 VSS.n303 VSS.n84 49.217
R1316 VSS.n310 VSS.n85 49.217
R1317 VSS.n311 VSS.n86 49.217
R1318 VSS.n315 VSS.n87 49.217
R1319 VSS.n316 VSS.n88 49.217
R1320 VSS.n320 VSS.n89 49.217
R1321 VSS.n328 VSS.n91 49.217
R1322 VSS.n329 VSS.n92 49.217
R1323 VSS.n333 VSS.n93 49.217
R1324 VSS.n334 VSS.n94 49.217
R1325 VSS.n338 VSS.n95 49.217
R1326 VSS.n339 VSS.n96 49.217
R1327 VSS.n347 VSS.n98 49.217
R1328 VSS.n351 VSS.n99 49.217
R1329 VSS.n352 VSS.n100 49.217
R1330 VSS.n356 VSS.n101 49.217
R1331 VSS.n357 VSS.n102 49.217
R1332 VSS.n364 VSS.n103 49.217
R1333 VSS.n369 VSS.n105 49.217
R1334 VSS.n370 VSS.n106 49.217
R1335 VSS.n374 VSS.n107 49.217
R1336 VSS.n375 VSS.n108 49.217
R1337 VSS.n382 VSS.n109 49.217
R1338 VSS.n383 VSS.n109 47.7478
R1339 VSS.n391 VSS.n111 47.7478
R1340 VSS.n395 VSS.n112 47.7478
R1341 VSS.n396 VSS.n113 47.7478
R1342 VSS.n403 VSS.n114 47.7478
R1343 VSS.n404 VSS.n115 47.7478
R1344 VSS.n408 VSS.n116 47.7478
R1345 VSS.n413 VSS.n118 47.7478
R1346 VSS.n414 VSS.n119 47.7478
R1347 VSS.n421 VSS.n120 47.7478
R1348 VSS.n426 VSS.n122 47.7478
R1349 VSS.n427 VSS.n123 47.7478
R1350 VSS.n645 VSS.t6 45.2856
R1351 VSS.t15 VSS.n90 40.4021
R1352 VSS.t11 VSS.n104 40.4021
R1353 VSS.t5 VSS.n141 40.4021
R1354 VSS.n218 VSS.t14 40.4021
R1355 VSS.t1 VSS.n149 40.4021
R1356 VSS.t12 VSS.n97 39.6675
R1357 VSS.n390 VSS.t0 38.1983
R1358 VSS.n409 VSS.t2 38.1983
R1359 VSS.t8 VSS.n121 38.1983
R1360 VSS.n431 VSS.n124 30.118
R1361 VSS.n432 VSS.n125 30.118
R1362 VSS.n439 VSS.n126 30.118
R1363 VSS.n440 VSS.n127 30.118
R1364 VSS.n444 VSS.n128 30.118
R1365 VSS.n445 VSS.n129 30.118
R1366 VSS.n449 VSS.n130 30.118
R1367 VSS.n450 VSS.n131 30.118
R1368 VSS.n457 VSS.n132 30.118
R1369 VSS.n458 VSS.n133 30.118
R1370 VSS.n462 VSS.n134 30.118
R1371 VSS.n463 VSS.n135 30.118
R1372 VSS.n470 VSS.n136 30.118
R1373 VSS.n632 VSS.n137 30.118
R1374 VSS.n205 VSS.n139 20.2316
R1375 VSS.n206 VSS.n139 20.2316
R1376 VSS.n206 VSS.n140 20.2316
R1377 VSS.n207 VSS.n140 20.2316
R1378 VSS.n208 VSS.n143 20.2316
R1379 VSS.n209 VSS.n143 20.2316
R1380 VSS.n209 VSS.n144 20.2316
R1381 VSS.n210 VSS.n144 20.2316
R1382 VSS.n210 VSS.n145 20.2316
R1383 VSS.n212 VSS.n146 20.2316
R1384 VSS.n212 VSS.n147 20.2316
R1385 VSS.n213 VSS.n147 20.2316
R1386 VSS.n213 VSS.n148 20.2316
R1387 VSS.n214 VSS.n148 20.2316
R1388 VSS.n215 VSS.n151 20.2316
R1389 VSS.n216 VSS.n151 20.2316
R1390 VSS.n216 VSS.n152 20.2316
R1391 VSS.n217 VSS.n152 20.2316
R1392 VSS.n217 VSS.n153 20.2316
R1393 VSS.n640 VSS.n153 20.2316
R1394 VSS.n641 VSS.n640 20.2316
R1395 VSS.n641 VSS.n61 20.2316
R1396 VSS.n427 VSS.n124 19.834
R1397 VSS.n431 VSS.n125 19.834
R1398 VSS.n432 VSS.n126 19.834
R1399 VSS.n439 VSS.n127 19.834
R1400 VSS.n440 VSS.n128 19.834
R1401 VSS.n444 VSS.n129 19.834
R1402 VSS.n449 VSS.n131 19.834
R1403 VSS.n450 VSS.n132 19.834
R1404 VSS.n457 VSS.n133 19.834
R1405 VSS.n458 VSS.n134 19.834
R1406 VSS.n462 VSS.n135 19.834
R1407 VSS.n463 VSS.n136 19.834
R1408 VSS.n632 VSS.n138 19.834
R1409 VSS.n676 VSS.t7 17.0005
R1410 VSS.n589 VSS.t13 17.0005
R1411 VSS.n591 VSS.t13 17.0005
R1412 VSS.n600 VSS.t13 17.0005
R1413 VSS.n602 VSS.t13 17.0005
R1414 VSS.n604 VSS.t13 17.0005
R1415 VSS.n606 VSS.t13 17.0005
R1416 VSS.n608 VSS.t13 17.0005
R1417 VSS.n610 VSS.t13 17.0005
R1418 VSS.n612 VSS.t13 17.0005
R1419 VSS.t9 VSS.n554 17.0005
R1420 VSS.t9 VSS.n551 17.0005
R1421 VSS.t9 VSS.n548 17.0005
R1422 VSS.t9 VSS.n545 17.0005
R1423 VSS.t9 VSS.n542 17.0005
R1424 VSS.t9 VSS.n539 17.0005
R1425 VSS.t9 VSS.n524 17.0005
R1426 VSS.n559 VSS.t9 17.0005
R1427 VSS.t9 VSS.n518 17.0005
R1428 VSS.n634 VSS.n470 17.0005
R1429 VSS.n634 VSS.n466 17.0005
R1430 VSS.n634 VSS.n463 17.0005
R1431 VSS.n634 VSS.n461 17.0005
R1432 VSS.n634 VSS.n462 17.0005
R1433 VSS.n634 VSS.n458 17.0005
R1434 VSS.n634 VSS.n457 17.0005
R1435 VSS.n634 VSS.n453 17.0005
R1436 VSS.n634 VSS.n450 17.0005
R1437 VSS.n634 VSS.n449 17.0005
R1438 VSS.n634 VSS.n445 17.0005
R1439 VSS.n634 VSS.n443 17.0005
R1440 VSS.n634 VSS.n444 17.0005
R1441 VSS.n634 VSS.n440 17.0005
R1442 VSS.n634 VSS.n439 17.0005
R1443 VSS.n634 VSS.n435 17.0005
R1444 VSS.n634 VSS.n432 17.0005
R1445 VSS.n634 VSS.n431 17.0005
R1446 VSS.n634 VSS.n427 17.0005
R1447 VSS.n634 VSS.n425 17.0005
R1448 VSS.n634 VSS.n426 17.0005
R1449 VSS.n634 VSS.n422 17.0005
R1450 VSS.n634 VSS.n421 17.0005
R1451 VSS.n634 VSS.n417 17.0005
R1452 VSS.n634 VSS.n414 17.0005
R1453 VSS.n634 VSS.n413 17.0005
R1454 VSS.n634 VSS.n409 17.0005
R1455 VSS.n634 VSS.n407 17.0005
R1456 VSS.n634 VSS.n408 17.0005
R1457 VSS.n634 VSS.n404 17.0005
R1458 VSS.n634 VSS.n403 17.0005
R1459 VSS.n634 VSS.n399 17.0005
R1460 VSS.n634 VSS.n396 17.0005
R1461 VSS.n634 VSS.n395 17.0005
R1462 VSS.n634 VSS.n391 17.0005
R1463 VSS.n634 VSS.n389 17.0005
R1464 VSS.n634 VSS.n390 17.0005
R1465 VSS.n634 VSS.n386 17.0005
R1466 VSS.n634 VSS.n383 17.0005
R1467 VSS.n634 VSS.n381 17.0005
R1468 VSS.n634 VSS.n382 17.0005
R1469 VSS.n634 VSS.n378 17.0005
R1470 VSS.n634 VSS.n375 17.0005
R1471 VSS.n634 VSS.n374 17.0005
R1472 VSS.n634 VSS.n370 17.0005
R1473 VSS.n634 VSS.n368 17.0005
R1474 VSS.n634 VSS.n369 17.0005
R1475 VSS.n634 VSS.n365 17.0005
R1476 VSS.n634 VSS.n364 17.0005
R1477 VSS.n634 VSS.n360 17.0005
R1478 VSS.n634 VSS.n357 17.0005
R1479 VSS.n634 VSS.n356 17.0005
R1480 VSS.n634 VSS.n352 17.0005
R1481 VSS.n634 VSS.n350 17.0005
R1482 VSS.n634 VSS.n351 17.0005
R1483 VSS.n634 VSS.n347 17.0005
R1484 VSS.n634 VSS.n346 17.0005
R1485 VSS.n634 VSS.n342 17.0005
R1486 VSS.n634 VSS.n339 17.0005
R1487 VSS.n634 VSS.n338 17.0005
R1488 VSS.n634 VSS.n334 17.0005
R1489 VSS.n634 VSS.n332 17.0005
R1490 VSS.n634 VSS.n333 17.0005
R1491 VSS.n634 VSS.n329 17.0005
R1492 VSS.n634 VSS.n328 17.0005
R1493 VSS.n634 VSS.n324 17.0005
R1494 VSS.n634 VSS.n321 17.0005
R1495 VSS.n634 VSS.n320 17.0005
R1496 VSS.n634 VSS.n316 17.0005
R1497 VSS.n634 VSS.n314 17.0005
R1498 VSS.n634 VSS.n315 17.0005
R1499 VSS.n634 VSS.n311 17.0005
R1500 VSS.n634 VSS.n310 17.0005
R1501 VSS.n634 VSS.n306 17.0005
R1502 VSS.n634 VSS.n303 17.0005
R1503 VSS.n634 VSS.n301 17.0005
R1504 VSS.n634 VSS.n302 17.0005
R1505 VSS.n634 VSS.n298 17.0005
R1506 VSS.n630 VSS.n470 17.0005
R1507 VSS.n630 VSS.n463 17.0005
R1508 VSS.n630 VSS.n462 17.0005
R1509 VSS.n630 VSS.n458 17.0005
R1510 VSS.n630 VSS.n457 17.0005
R1511 VSS.n630 VSS.n450 17.0005
R1512 VSS.n630 VSS.n449 17.0005
R1513 VSS.n630 VSS.n496 17.0005
R1514 VSS.n630 VSS.n445 17.0005
R1515 VSS.n630 VSS.n511 17.0005
R1516 VSS.n630 VSS.n444 17.0005
R1517 VSS.n630 VSS.n495 17.0005
R1518 VSS.n630 VSS.n440 17.0005
R1519 VSS.n630 VSS.n439 17.0005
R1520 VSS.n630 VSS.n432 17.0005
R1521 VSS.n630 VSS.n512 17.0005
R1522 VSS.n630 VSS.n431 17.0005
R1523 VSS.n630 VSS.n493 17.0005
R1524 VSS.n630 VSS.n427 17.0005
R1525 VSS.n630 VSS.n513 17.0005
R1526 VSS.n630 VSS.n426 17.0005
R1527 VSS.n630 VSS.n492 17.0005
R1528 VSS.n630 VSS.n422 17.0005
R1529 VSS.n630 VSS.n514 17.0005
R1530 VSS.n630 VSS.n421 17.0005
R1531 VSS.n630 VSS.n491 17.0005
R1532 VSS.n630 VSS.n414 17.0005
R1533 VSS.n630 VSS.n515 17.0005
R1534 VSS.n630 VSS.n413 17.0005
R1535 VSS.n630 VSS.n490 17.0005
R1536 VSS.n630 VSS.n409 17.0005
R1537 VSS.n630 VSS.n516 17.0005
R1538 VSS.n630 VSS.n408 17.0005
R1539 VSS.n630 VSS.n489 17.0005
R1540 VSS.n630 VSS.n404 17.0005
R1541 VSS.n630 VSS.n562 17.0005
R1542 VSS.n630 VSS.n403 17.0005
R1543 VSS.n630 VSS.n488 17.0005
R1544 VSS.n630 VSS.n396 17.0005
R1545 VSS.n630 VSS.n395 17.0005
R1546 VSS.n630 VSS.n391 17.0005
R1547 VSS.n630 VSS.n390 17.0005
R1548 VSS.n630 VSS.n383 17.0005
R1549 VSS.n630 VSS.n382 17.0005
R1550 VSS.n630 VSS.n375 17.0005
R1551 VSS.n630 VSS.n374 17.0005
R1552 VSS.n630 VSS.n370 17.0005
R1553 VSS.n630 VSS.n563 17.0005
R1554 VSS.n630 VSS.n369 17.0005
R1555 VSS.n630 VSS.n486 17.0005
R1556 VSS.n630 VSS.n365 17.0005
R1557 VSS.n630 VSS.n564 17.0005
R1558 VSS.n630 VSS.n364 17.0005
R1559 VSS.n630 VSS.n485 17.0005
R1560 VSS.n630 VSS.n357 17.0005
R1561 VSS.n630 VSS.n565 17.0005
R1562 VSS.n630 VSS.n356 17.0005
R1563 VSS.n630 VSS.n484 17.0005
R1564 VSS.n630 VSS.n352 17.0005
R1565 VSS.n630 VSS.n566 17.0005
R1566 VSS.n630 VSS.n351 17.0005
R1567 VSS.n630 VSS.n483 17.0005
R1568 VSS.n630 VSS.n347 17.0005
R1569 VSS.n630 VSS.n567 17.0005
R1570 VSS.n630 VSS.n346 17.0005
R1571 VSS.n630 VSS.n482 17.0005
R1572 VSS.n630 VSS.n339 17.0005
R1573 VSS.n630 VSS.n568 17.0005
R1574 VSS.n630 VSS.n338 17.0005
R1575 VSS.n630 VSS.n481 17.0005
R1576 VSS.n630 VSS.n334 17.0005
R1577 VSS.n630 VSS.n333 17.0005
R1578 VSS.n630 VSS.n329 17.0005
R1579 VSS.n630 VSS.n569 17.0005
R1580 VSS.n630 VSS.n328 17.0005
R1581 VSS.n630 VSS.n479 17.0005
R1582 VSS.n630 VSS.n321 17.0005
R1583 VSS.n630 VSS.n570 17.0005
R1584 VSS.n630 VSS.n320 17.0005
R1585 VSS.n630 VSS.n316 17.0005
R1586 VSS.n630 VSS.n315 17.0005
R1587 VSS.n630 VSS.n311 17.0005
R1588 VSS.n630 VSS.n310 17.0005
R1589 VSS.n630 VSS.n303 17.0005
R1590 VSS.n630 VSS.n302 17.0005
R1591 VSS.n630 VSS.n298 17.0005
R1592 VSS.n642 VSS.n150 17.0005
R1593 VSS.n642 VSS.n149 17.0005
R1594 VSS.n642 VSS.n142 17.0005
R1595 VSS.n642 VSS.n141 17.0005
R1596 VSS.n642 VSS.n138 17.0005
R1597 VSS.n642 VSS.n137 17.0005
R1598 VSS.n642 VSS.n136 17.0005
R1599 VSS.n642 VSS.n135 17.0005
R1600 VSS.n642 VSS.n134 17.0005
R1601 VSS.n642 VSS.n133 17.0005
R1602 VSS.n642 VSS.n132 17.0005
R1603 VSS.n642 VSS.n131 17.0005
R1604 VSS.n642 VSS.n130 17.0005
R1605 VSS.n642 VSS.n129 17.0005
R1606 VSS.n642 VSS.n128 17.0005
R1607 VSS.n642 VSS.n127 17.0005
R1608 VSS.n642 VSS.n126 17.0005
R1609 VSS.n642 VSS.n125 17.0005
R1610 VSS.n642 VSS.n124 17.0005
R1611 VSS.n642 VSS.n123 17.0005
R1612 VSS.n642 VSS.n122 17.0005
R1613 VSS.n642 VSS.n121 17.0005
R1614 VSS.n642 VSS.n120 17.0005
R1615 VSS.n642 VSS.n119 17.0005
R1616 VSS.n642 VSS.n118 17.0005
R1617 VSS.n642 VSS.n117 17.0005
R1618 VSS.n642 VSS.n116 17.0005
R1619 VSS.n642 VSS.n115 17.0005
R1620 VSS.n642 VSS.n114 17.0005
R1621 VSS.n642 VSS.n113 17.0005
R1622 VSS.n642 VSS.n112 17.0005
R1623 VSS.n642 VSS.n111 17.0005
R1624 VSS.n642 VSS.n110 17.0005
R1625 VSS.n642 VSS.n109 17.0005
R1626 VSS.n642 VSS.n108 17.0005
R1627 VSS.n642 VSS.n107 17.0005
R1628 VSS.n642 VSS.n106 17.0005
R1629 VSS.n642 VSS.n105 17.0005
R1630 VSS.n642 VSS.n104 17.0005
R1631 VSS.n642 VSS.n103 17.0005
R1632 VSS.n642 VSS.n102 17.0005
R1633 VSS.n642 VSS.n101 17.0005
R1634 VSS.n642 VSS.n100 17.0005
R1635 VSS.n642 VSS.n99 17.0005
R1636 VSS.n642 VSS.n98 17.0005
R1637 VSS.n642 VSS.n97 17.0005
R1638 VSS.n642 VSS.n96 17.0005
R1639 VSS.n642 VSS.n95 17.0005
R1640 VSS.n642 VSS.n94 17.0005
R1641 VSS.n642 VSS.n93 17.0005
R1642 VSS.n642 VSS.n92 17.0005
R1643 VSS.n642 VSS.n91 17.0005
R1644 VSS.n642 VSS.n90 17.0005
R1645 VSS.n642 VSS.n89 17.0005
R1646 VSS.n642 VSS.n88 17.0005
R1647 VSS.n642 VSS.n87 17.0005
R1648 VSS.n642 VSS.n86 17.0005
R1649 VSS.n642 VSS.n85 17.0005
R1650 VSS.n642 VSS.n84 17.0005
R1651 VSS.n642 VSS.n83 17.0005
R1652 VSS.n642 VSS.n82 17.0005
R1653 VSS.n642 VSS.n81 17.0005
R1654 VSS.n639 VSS.n211 17.0005
R1655 VSS.n639 VSS.n218 17.0005
R1656 VSS.n639 VSS.n137 17.0005
R1657 VSS.n639 VSS.n219 17.0005
R1658 VSS.n639 VSS.n136 17.0005
R1659 VSS.n639 VSS.n135 17.0005
R1660 VSS.n639 VSS.n134 17.0005
R1661 VSS.n639 VSS.n172 17.0005
R1662 VSS.n639 VSS.n133 17.0005
R1663 VSS.n639 VSS.n132 17.0005
R1664 VSS.n639 VSS.n131 17.0005
R1665 VSS.n639 VSS.n221 17.0005
R1666 VSS.n639 VSS.n130 17.0005
R1667 VSS.n639 VSS.n129 17.0005
R1668 VSS.n639 VSS.n128 17.0005
R1669 VSS.n639 VSS.n170 17.0005
R1670 VSS.n639 VSS.n127 17.0005
R1671 VSS.n639 VSS.n126 17.0005
R1672 VSS.n639 VSS.n125 17.0005
R1673 VSS.n639 VSS.n223 17.0005
R1674 VSS.n639 VSS.n124 17.0005
R1675 VSS.n639 VSS.n168 17.0005
R1676 VSS.n639 VSS.n123 17.0005
R1677 VSS.n639 VSS.n122 17.0005
R1678 VSS.n639 VSS.n121 17.0005
R1679 VSS.n639 VSS.n224 17.0005
R1680 VSS.n639 VSS.n120 17.0005
R1681 VSS.n639 VSS.n119 17.0005
R1682 VSS.n639 VSS.n118 17.0005
R1683 VSS.n639 VSS.n166 17.0005
R1684 VSS.n639 VSS.n117 17.0005
R1685 VSS.n639 VSS.n116 17.0005
R1686 VSS.n639 VSS.n115 17.0005
R1687 VSS.n639 VSS.n226 17.0005
R1688 VSS.n639 VSS.n114 17.0005
R1689 VSS.n639 VSS.n113 17.0005
R1690 VSS.n639 VSS.n112 17.0005
R1691 VSS.n639 VSS.n164 17.0005
R1692 VSS.n639 VSS.n111 17.0005
R1693 VSS.n639 VSS.n110 17.0005
R1694 VSS.n639 VSS.n109 17.0005
R1695 VSS.n639 VSS.n228 17.0005
R1696 VSS.n639 VSS.n108 17.0005
R1697 VSS.n639 VSS.n162 17.0005
R1698 VSS.n639 VSS.n107 17.0005
R1699 VSS.n639 VSS.n106 17.0005
R1700 VSS.n639 VSS.n105 17.0005
R1701 VSS.n639 VSS.n229 17.0005
R1702 VSS.n639 VSS.n104 17.0005
R1703 VSS.n639 VSS.n103 17.0005
R1704 VSS.n639 VSS.n102 17.0005
R1705 VSS.n639 VSS.n160 17.0005
R1706 VSS.n639 VSS.n101 17.0005
R1707 VSS.n639 VSS.n100 17.0005
R1708 VSS.n639 VSS.n99 17.0005
R1709 VSS.n639 VSS.n231 17.0005
R1710 VSS.n639 VSS.n98 17.0005
R1711 VSS.n639 VSS.n97 17.0005
R1712 VSS.n639 VSS.n96 17.0005
R1713 VSS.n639 VSS.n158 17.0005
R1714 VSS.n639 VSS.n95 17.0005
R1715 VSS.n639 VSS.n94 17.0005
R1716 VSS.n639 VSS.n93 17.0005
R1717 VSS.n639 VSS.n233 17.0005
R1718 VSS.n639 VSS.n92 17.0005
R1719 VSS.n639 VSS.n91 17.0005
R1720 VSS.n639 VSS.n90 17.0005
R1721 VSS.n639 VSS.n156 17.0005
R1722 VSS.n639 VSS.n89 17.0005
R1723 VSS.n639 VSS.n88 17.0005
R1724 VSS.n639 VSS.n87 17.0005
R1725 VSS.n639 VSS.n235 17.0005
R1726 VSS.n639 VSS.n86 17.0005
R1727 VSS.n639 VSS.n85 17.0005
R1728 VSS.n639 VSS.n84 17.0005
R1729 VSS.n639 VSS.n154 17.0005
R1730 VSS.n639 VSS.n83 17.0005
R1731 VSS.n639 VSS.n237 17.0005
R1732 VSS.n639 VSS.n82 17.0005
R1733 VSS.n639 VSS.n81 17.0005
R1734 VSS.n680 VSS.n653 17.0005
R1735 VSS.n680 VSS.n652 17.0005
R1736 VSS.n680 VSS.n651 17.0005
R1737 VSS.n680 VSS.n650 17.0005
R1738 VSS.n680 VSS.n649 17.0005
R1739 VSS.n680 VSS.n648 17.0005
R1740 VSS.n680 VSS.n646 17.0005
R1741 VSS.n445 VSS.t3 10.2845
R1742 VSS.n470 VSS.t4 10.2845
R1743 VSS.n207 VSS.n141 10.116
R1744 VSS.n218 VSS.n145 10.116
R1745 VSS.n214 VSS.n149 10.116
R1746 VSS.n644 VSS.n61 10.116
R1747 VSS.n211 VSS.n146 10.116
R1748 VSS.n215 VSS.n150 10.116
R1749 VSS.n208 VSS.n142 10.116
R1750 VSS.n205 VSS.n138 10.116
R1751 VSS.t0 VSS.n110 9.54996
R1752 VSS.t2 VSS.n117 9.54996
R1753 VSS.n422 VSS.t8 9.54996
R1754 VSS.t3 VSS.n130 9.54996
R1755 VSS.t4 VSS.n137 9.54996
R1756 VSS.n142 VSS.t5 9.54996
R1757 VSS.t14 VSS.n211 9.54996
R1758 VSS.n150 VSS.t1 9.54996
R1759 VSS.n321 VSS.t15 8.81539
R1760 VSS.n346 VSS.t10 8.81539
R1761 VSS.n365 VSS.t11 8.81539
R1762 VSS.n636 VSS.n289 8.501
R1763 VSS.n636 VSS.n290 8.501
R1764 VSS.n636 VSS.n291 8.501
R1765 VSS.n636 VSS.n292 8.501
R1766 VSS.n636 VSS.n293 8.501
R1767 VSS.n636 VSS.n294 8.501
R1768 VSS.n636 VSS.n295 8.501
R1769 VSS.n632 VSS.n631 8.501
R1770 VSS.n632 VSS.n477 8.501
R1771 VSS.n632 VSS.n476 8.501
R1772 VSS.n632 VSS.n475 8.501
R1773 VSS.n632 VSS.n474 8.501
R1774 VSS.n632 VSS.n473 8.501
R1775 VSS.n632 VSS.n472 8.501
R1776 VSS.n637 VSS.n240 8.501
R1777 VSS.n637 VSS.n241 8.501
R1778 VSS.n637 VSS.n242 8.501
R1779 VSS.n637 VSS.n243 8.501
R1780 VSS.n637 VSS.n244 8.501
R1781 VSS.n637 VSS.n245 8.501
R1782 VSS.n637 VSS.n246 8.501
R1783 VSS.n637 VSS.n247 8.501
R1784 VSS.n637 VSS.n248 8.501
R1785 VSS.n637 VSS.n249 8.501
R1786 VSS.n637 VSS.n250 8.501
R1787 VSS.n637 VSS.n251 8.501
R1788 VSS.n637 VSS.n252 8.501
R1789 VSS.n637 VSS.n253 8.501
R1790 VSS.n637 VSS.n254 8.501
R1791 VSS.n637 VSS.n288 8.501
R1792 VSS.n638 VSS.n637 8.501
R1793 VSS.n644 VSS.n76 8.501
R1794 VSS.n644 VSS.n75 8.501
R1795 VSS.n644 VSS.n74 8.501
R1796 VSS.n644 VSS.n73 8.501
R1797 VSS.n644 VSS.n72 8.501
R1798 VSS.n644 VSS.n71 8.501
R1799 VSS.n644 VSS.n70 8.501
R1800 VSS.n644 VSS.n69 8.501
R1801 VSS.n644 VSS.n68 8.501
R1802 VSS.n644 VSS.n67 8.501
R1803 VSS.n644 VSS.n66 8.501
R1804 VSS.n644 VSS.n65 8.501
R1805 VSS.n644 VSS.n64 8.501
R1806 VSS.n644 VSS.n63 8.501
R1807 VSS.n644 VSS.n62 8.501
R1808 VSS.n503 VSS.n471 8.47723
R1809 VSS.n634 VSS.n448 8.46995
R1810 VSS.n634 VSS.n430 8.46995
R1811 VSS.n634 VSS.n412 8.46995
R1812 VSS.n634 VSS.n394 8.46995
R1813 VSS.n634 VSS.n373 8.46995
R1814 VSS.n634 VSS.n355 8.46995
R1815 VSS.n634 VSS.n337 8.46995
R1816 VSS.n634 VSS.n319 8.46995
R1817 VSS.n616 VSS.n296 8.46995
R1818 VSS.n618 VSS.n617 8.46995
R1819 VSS.n620 VSS.n619 8.46995
R1820 VSS.n624 VSS.n623 8.46995
R1821 VSS.n626 VSS.n625 8.46995
R1822 VSS.n628 VSS.n627 8.46995
R1823 VSS.n509 VSS.n478 8.46995
R1824 VSS.n508 VSS.n497 8.46995
R1825 VSS.n507 VSS.n498 8.46995
R1826 VSS.n505 VSS.n500 8.46995
R1827 VSS.n504 VSS.n501 8.46995
R1828 VSS.n630 VSS.n494 8.46995
R1829 VSS.n630 VSS.n480 8.46995
R1830 VSS.n256 VSS.n255 8.46995
R1831 VSS.n258 VSS.n257 8.46995
R1832 VSS.n260 VSS.n259 8.46995
R1833 VSS.n262 VSS.n261 8.46995
R1834 VSS.n264 VSS.n263 8.46995
R1835 VSS.n266 VSS.n265 8.46995
R1836 VSS.n268 VSS.n267 8.46995
R1837 VSS.n270 VSS.n269 8.46995
R1838 VSS.n272 VSS.n271 8.46995
R1839 VSS.n274 VSS.n273 8.46995
R1840 VSS.n276 VSS.n275 8.46995
R1841 VSS.n278 VSS.n277 8.46995
R1842 VSS.n280 VSS.n279 8.46995
R1843 VSS.n282 VSS.n281 8.46995
R1844 VSS.n284 VSS.n283 8.46995
R1845 VSS.n287 VSS.n286 8.46995
R1846 VSS.n285 VSS.n239 8.46995
R1847 VSS.n203 VSS.n173 8.46995
R1848 VSS.n202 VSS.n174 8.46995
R1849 VSS.n201 VSS.n175 8.46995
R1850 VSS.n200 VSS.n176 8.46995
R1851 VSS.n199 VSS.n177 8.46995
R1852 VSS.n198 VSS.n178 8.46995
R1853 VSS.n197 VSS.n179 8.46995
R1854 VSS.n196 VSS.n180 8.46995
R1855 VSS.n195 VSS.n181 8.46995
R1856 VSS.n194 VSS.n182 8.46995
R1857 VSS.n193 VSS.n183 8.46995
R1858 VSS.n192 VSS.n184 8.46995
R1859 VSS.n191 VSS.n185 8.46995
R1860 VSS.n190 VSS.n186 8.46995
R1861 VSS.n189 VSS.n187 8.46995
R1862 VSS.n188 VSS.n78 8.46995
R1863 VSS.n639 VSS.n220 8.46995
R1864 VSS.n639 VSS.n171 8.46995
R1865 VSS.n639 VSS.n222 8.46995
R1866 VSS.n639 VSS.n169 8.46995
R1867 VSS.n639 VSS.n167 8.46995
R1868 VSS.n639 VSS.n225 8.46995
R1869 VSS.n639 VSS.n165 8.46995
R1870 VSS.n639 VSS.n227 8.46995
R1871 VSS.n639 VSS.n163 8.46995
R1872 VSS.n639 VSS.n161 8.46995
R1873 VSS.n639 VSS.n230 8.46995
R1874 VSS.n639 VSS.n159 8.46995
R1875 VSS.n639 VSS.n232 8.46995
R1876 VSS.n639 VSS.n157 8.46995
R1877 VSS.n639 VSS.n234 8.46995
R1878 VSS.n639 VSS.n155 8.46995
R1879 VSS.n639 VSS.n236 8.46995
R1880 VSS.n639 VSS.n238 8.46995
R1881 VSS.n680 VSS.n679 8.46995
R1882 VSS.n680 VSS.n647 8.46995
R1883 VSS.n634 VSS.n456 8.46995
R1884 VSS.n634 VSS.n438 8.46995
R1885 VSS.n634 VSS.n420 8.46995
R1886 VSS.n634 VSS.n402 8.46995
R1887 VSS.n634 VSS.n363 8.46995
R1888 VSS.n634 VSS.n345 8.46995
R1889 VSS.n634 VSS.n327 8.46995
R1890 VSS.n634 VSS.n309 8.46995
R1891 VSS.t7 VSS.n656 8.46676
R1892 VSS.t7 VSS.n661 8.46676
R1893 VSS.t7 VSS.n666 8.46676
R1894 VSS.t7 VSS.n675 8.46676
R1895 VSS.t7 VSS.n655 8.46676
R1896 VSS.n622 VSS.n621 8.44635
R1897 VSS.n506 VSS.n499 8.44635
R1898 VSS.n614 VSS.t13 8.44469
R1899 VSS.t9 VSS.n558 8.44383
R1900 VSS.t9 VSS.n523 8.44298
R1901 VSS.n587 VSS.t13 8.44213
R1902 VSS.n594 VSS.t13 8.44042
R1903 VSS.n597 VSS.t13 8.44042
R1904 VSS.t9 VSS.n534 8.44042
R1905 VSS.t9 VSS.n529 8.44042
R1906 VSS.n694 VSS.n693 8.16709
R1907 VSS.n644 VSS.n77 5.66778
R1908 VSS.n636 VSS.n635 5.66767
R1909 VSS.n633 VSS.n632 5.66767
R1910 VSS.n637 VSS.n80 5.66767
R1911 VSS.n644 VSS.n643 5.66767
R1912 VSS.n634 VSS.n469 5.6398
R1913 VSS.n634 VSS.n297 5.62486
R1914 VSS.t23 VSS.n14 4.39573
R1915 VSS.t18 VSS.n32 4.39573
R1916 VSS.n23 VSS.t21 3.55242
R1917 VSS.n36 VSS.t16 3.55242
R1918 VSS.n21 VSS.t25 3.5502
R1919 VSS.n34 VSS.t20 3.5502
R1920 VSS.n642 VSS.n641 3.44348
R1921 VSS.n642 VSS.n153 3.44348
R1922 VSS.n642 VSS.n152 3.44348
R1923 VSS.n642 VSS.n151 3.44348
R1924 VSS.n642 VSS.n148 3.44348
R1925 VSS.n642 VSS.n147 3.44348
R1926 VSS.n642 VSS.n146 3.44348
R1927 VSS.n642 VSS.n145 3.44348
R1928 VSS.n642 VSS.n144 3.44348
R1929 VSS.n642 VSS.n143 3.44348
R1930 VSS.n642 VSS.n140 3.44348
R1931 VSS.n642 VSS.n139 3.44348
R1932 VSS.n639 VSS.n61 3.44348
R1933 VSS.n640 VSS.n639 3.44348
R1934 VSS.n639 VSS.n217 3.44348
R1935 VSS.n639 VSS.n216 3.44348
R1936 VSS.n639 VSS.n215 3.44348
R1937 VSS.n639 VSS.n214 3.44348
R1938 VSS.n639 VSS.n213 3.44348
R1939 VSS.n639 VSS.n212 3.44348
R1940 VSS.n639 VSS.n210 3.44348
R1941 VSS.n639 VSS.n209 3.44348
R1942 VSS.n639 VSS.n208 3.44348
R1943 VSS.n639 VSS.n207 3.44348
R1944 VSS.n639 VSS.n206 3.44348
R1945 VSS.n639 VSS.n205 3.44348
R1946 VSS.t19 VSS.n33 2.94459
R1947 VSS.n20 VSS.t25 2.94411
R1948 VSS.n33 VSS.t20 2.9439
R1949 VSS.t24 VSS.n20 2.9438
R1950 VSS.n24 VSS.t21 2.94359
R1951 VSS.n37 VSS.t16 2.94359
R1952 VSS.n24 VSS.t22 2.94128
R1953 VSS.n37 VSS.t17 2.94128
R1954 VSS.n22 VSS.t23 2.33654
R1955 VSS.n21 VSS.t24 2.33654
R1956 VSS.n35 VSS.t18 2.33654
R1957 VSS.n34 VSS.t19 2.33654
R1958 VSS.t22 VSS.n23 2.33622
R1959 VSS.t17 VSS.n36 2.33622
R1960 VSS.n681 VSS.n680 2.30543
R1961 VSS.n703 VSS.n702 2.28717
R1962 VSS.n696 VSS.n695 2.28013
R1963 VSS.n684 VSS.n6 2.28013
R1964 VSS.n688 VSS.n682 2.26578
R1965 VSS.n684 VSS.n682 2.26577
R1966 VSS.n696 VSS.n1 2.26577
R1967 VSS.n686 VSS.n685 2.2505
R1968 VSS.n683 VSS.n7 2.2505
R1969 VSS.n693 VSS.n692 2.2505
R1970 VSS.n694 VSS.n4 2.2505
R1971 VSS.n699 VSS.n5 2.2505
R1972 VSS.n698 VSS.n697 2.2505
R1973 VSS.n4 VSS.n3 2.2505
R1974 VSS.n700 VSS.n699 2.2505
R1975 VSS.n698 VSS.n0 2.2505
R1976 VSS.n703 VSS.n1 2.2505
R1977 VSS.n3 VSS.n2 2.2505
R1978 VSS.n701 VSS.n700 2.2505
R1979 VSS.n702 VSS.n0 2.2505
R1980 VSS.n687 VSS.n686 2.2505
R1981 VSS.n58 VSS.n7 2.2505
R1982 VSS.n692 VSS.n691 2.2505
R1983 VSS.n383 VSS.n110 2.20422
R1984 VSS.n390 VSS.n111 2.20422
R1985 VSS.n391 VSS.n112 2.20422
R1986 VSS.n395 VSS.n113 2.20422
R1987 VSS.n396 VSS.n114 2.20422
R1988 VSS.n403 VSS.n115 2.20422
R1989 VSS.n404 VSS.n116 2.20422
R1990 VSS.n408 VSS.n117 2.20422
R1991 VSS.n409 VSS.n118 2.20422
R1992 VSS.n413 VSS.n119 2.20422
R1993 VSS.n414 VSS.n120 2.20422
R1994 VSS.n421 VSS.n121 2.20422
R1995 VSS.n422 VSS.n122 2.20422
R1996 VSS.n426 VSS.n123 2.20422
R1997 VSS.n630 VSS.n510 1.97148
R1998 VSS.n630 VSS.n629 1.97148
R1999 VSS.n630 VSS.n487 1.94569
R2000 VSS.n188 VSS.n79 1.57588
R2001 VSS.n256 VSS.n79 1.53812
R2002 VSS.n654 VSS.n59 1.4765
R2003 VSS.n689 VSS.n59 1.46544
R2004 VSS.n204 VSS.n203 1.40251
R2005 VSS.n38 VSS.n37 1.34873
R2006 VSS.n502 VSS.n2 1.29192
R2007 VSS.n467 VSS.n204 1.28634
R2008 VSS.n22 VSS.n21 1.21656
R2009 VSS.n35 VSS.n34 1.21656
R2010 VSS.n23 VSS.n22 1.21611
R2011 VSS.n36 VSS.n35 1.21611
R2012 VSS.n691 VSS.n57 1.21436
R2013 VSS.n690 VSS.n689 1.14246
R2014 VSS.n689 VSS.n688 1.14246
R2015 VSS.n523 VSS.n522 1.10362
R2016 VSS.n587 VSS.n586 1.1036
R2017 VSS.n615 VSS.n614 1.10193
R2018 VSS.n558 VSS.n557 1.10192
R2019 VSS.n656 VSS.n60 0.997598
R2020 VSS.n598 VSS.n579 0.983625
R2021 VSS.n596 VSS.n580 0.983625
R2022 VSS.n595 VSS.n581 0.983625
R2023 VSS.n593 VSS.n582 0.983625
R2024 VSS.n588 VSS.n585 0.983625
R2025 VSS.n590 VSS.n584 0.983625
R2026 VSS.n592 VSS.n583 0.983625
R2027 VSS.n599 VSS.n578 0.983625
R2028 VSS.n601 VSS.n577 0.983625
R2029 VSS.n603 VSS.n576 0.983625
R2030 VSS.n605 VSS.n575 0.983625
R2031 VSS.n607 VSS.n574 0.983625
R2032 VSS.n609 VSS.n573 0.983625
R2033 VSS.n611 VSS.n572 0.983625
R2034 VSS.n613 VSS.n571 0.983625
R2035 VSS.n528 VSS.n525 0.983625
R2036 VSS.n532 VSS.n531 0.983625
R2037 VSS.n533 VSS.n530 0.983625
R2038 VSS.n537 VSS.n536 0.983625
R2039 VSS.n556 VSS.n555 0.983625
R2040 VSS.n553 VSS.n552 0.983625
R2041 VSS.n550 VSS.n549 0.983625
R2042 VSS.n547 VSS.n546 0.983625
R2043 VSS.n544 VSS.n543 0.983625
R2044 VSS.n541 VSS.n540 0.983625
R2045 VSS.n538 VSS.n535 0.983625
R2046 VSS.n527 VSS.n526 0.983625
R2047 VSS.n520 VSS.n519 0.983625
R2048 VSS.n561 VSS.n560 0.983625
R2049 VSS.n521 VSS.n517 0.983625
R2050 VSS.n672 VSS.n671 0.928625
R2051 VSS.n674 VSS.n673 0.928625
R2052 VSS.n670 VSS.n667 0.928625
R2053 VSS.n669 VSS.n668 0.928625
R2054 VSS.n665 VSS.n662 0.928625
R2055 VSS.n664 VSS.n663 0.928625
R2056 VSS.n660 VSS.n657 0.928625
R2057 VSS.n659 VSS.n658 0.928625
R2058 VSS.n678 VSS.n677 0.928625
R2059 VSS.n676 VSS.n654 0.928625
R2060 VSS.n25 VSS.n24 0.9005
R2061 VSS.n20 VSS.n8 0.9005
R2062 VSS.n33 VSS.n26 0.9005
R2063 VSS.n45 VSS.n44 0.830185
R2064 VSS.n637 VSS.n636 0.735074
R2065 VSS.n298 VSS.n81 0.735074
R2066 VSS.n302 VSS.n82 0.735074
R2067 VSS.n303 VSS.n83 0.735074
R2068 VSS.n310 VSS.n84 0.735074
R2069 VSS.n311 VSS.n85 0.735074
R2070 VSS.n315 VSS.n86 0.735074
R2071 VSS.n316 VSS.n87 0.735074
R2072 VSS.n320 VSS.n88 0.735074
R2073 VSS.n321 VSS.n89 0.735074
R2074 VSS.n328 VSS.n90 0.735074
R2075 VSS.n329 VSS.n91 0.735074
R2076 VSS.n333 VSS.n92 0.735074
R2077 VSS.n334 VSS.n93 0.735074
R2078 VSS.n338 VSS.n94 0.735074
R2079 VSS.n339 VSS.n95 0.735074
R2080 VSS.n346 VSS.n96 0.735074
R2081 VSS.t10 VSS.t12 0.735074
R2082 VSS.n347 VSS.n97 0.735074
R2083 VSS.n351 VSS.n98 0.735074
R2084 VSS.n352 VSS.n99 0.735074
R2085 VSS.n356 VSS.n100 0.735074
R2086 VSS.n357 VSS.n101 0.735074
R2087 VSS.n364 VSS.n102 0.735074
R2088 VSS.n365 VSS.n103 0.735074
R2089 VSS.n369 VSS.n104 0.735074
R2090 VSS.n370 VSS.n105 0.735074
R2091 VSS.n374 VSS.n106 0.735074
R2092 VSS.n375 VSS.n107 0.735074
R2093 VSS.n382 VSS.n108 0.735074
R2094 VSS.n510 VSS.n509 0.555543
R2095 VSS.n629 VSS.n628 0.552761
R2096 VSS.n522 VSS.n487 0.531702
R2097 VSS.n629 VSS.n615 0.529604
R2098 VSS.n586 VSS.n487 0.527062
R2099 VSS.n557 VSS.n510 0.524988
R2100 VSS.n465 VSS.n464 0.48175
R2101 VSS.n460 VSS.n459 0.48175
R2102 VSS.n455 VSS.n454 0.48175
R2103 VSS.n452 VSS.n451 0.48175
R2104 VSS.n447 VSS.n446 0.48175
R2105 VSS.n442 VSS.n441 0.48175
R2106 VSS.n437 VSS.n436 0.48175
R2107 VSS.n434 VSS.n433 0.48175
R2108 VSS.n429 VSS.n428 0.48175
R2109 VSS.n424 VSS.n423 0.48175
R2110 VSS.n419 VSS.n418 0.48175
R2111 VSS.n416 VSS.n415 0.48175
R2112 VSS.n411 VSS.n410 0.48175
R2113 VSS.n406 VSS.n405 0.48175
R2114 VSS.n401 VSS.n400 0.48175
R2115 VSS.n398 VSS.n397 0.48175
R2116 VSS.n393 VSS.n392 0.48175
R2117 VSS.n388 VSS.n387 0.48175
R2118 VSS.n385 VSS.n384 0.48175
R2119 VSS.n380 VSS.n379 0.48175
R2120 VSS.n377 VSS.n376 0.48175
R2121 VSS.n372 VSS.n371 0.48175
R2122 VSS.n367 VSS.n366 0.48175
R2123 VSS.n362 VSS.n361 0.48175
R2124 VSS.n359 VSS.n358 0.48175
R2125 VSS.n354 VSS.n353 0.48175
R2126 VSS.n349 VSS.n348 0.48175
R2127 VSS.n344 VSS.n343 0.48175
R2128 VSS.n341 VSS.n340 0.48175
R2129 VSS.n336 VSS.n335 0.48175
R2130 VSS.n331 VSS.n330 0.48175
R2131 VSS.n326 VSS.n325 0.48175
R2132 VSS.n323 VSS.n322 0.48175
R2133 VSS.n318 VSS.n317 0.48175
R2134 VSS.n313 VSS.n312 0.48175
R2135 VSS.n308 VSS.n307 0.48175
R2136 VSS.n305 VSS.n304 0.48175
R2137 VSS.n300 VSS.n299 0.48175
R2138 VSS.n468 VSS.n467 0.48175
R2139 VSS.n681 VSS.n60 0.461428
R2140 VSS.n689 VSS.n681 0.404955
R2141 VSS.n51 VSS.n14 0.3635
R2142 VSS.n46 VSS.n19 0.3635
R2143 VSS.n47 VSS.n18 0.3635
R2144 VSS.n48 VSS.n17 0.3635
R2145 VSS.n49 VSS.n16 0.3635
R2146 VSS.n50 VSS.n15 0.3635
R2147 VSS.n52 VSS.n13 0.3635
R2148 VSS.n53 VSS.n12 0.3635
R2149 VSS.n54 VSS.n11 0.3635
R2150 VSS.n55 VSS.n10 0.3635
R2151 VSS.n56 VSS.n9 0.3635
R2152 VSS.n39 VSS.n31 0.3635
R2153 VSS.n40 VSS.n30 0.3635
R2154 VSS.n41 VSS.n29 0.3635
R2155 VSS.n42 VSS.n28 0.3635
R2156 VSS.n43 VSS.n27 0.3635
R2157 VSS.n622 VSS.n620 0.297565
R2158 VSS.n624 VSS.n622 0.297565
R2159 VSS.n506 VSS.n505 0.297565
R2160 VSS.n507 VSS.n506 0.297565
R2161 VSS.n616 VSS.n297 0.276441
R2162 VSS.n19 VSS.n18 0.2645
R2163 VSS.n18 VSS.n17 0.2645
R2164 VSS.n17 VSS.n16 0.2645
R2165 VSS.n16 VSS.n15 0.2645
R2166 VSS.n15 VSS.n14 0.2645
R2167 VSS.n14 VSS.n13 0.2645
R2168 VSS.n13 VSS.n12 0.2645
R2169 VSS.n12 VSS.n11 0.2645
R2170 VSS.n11 VSS.n10 0.2645
R2171 VSS.n10 VSS.n9 0.2645
R2172 VSS.n32 VSS.n31 0.2645
R2173 VSS.n31 VSS.n30 0.2645
R2174 VSS.n30 VSS.n29 0.2645
R2175 VSS.n29 VSS.n28 0.2645
R2176 VSS.n28 VSS.n27 0.2645
R2177 VSS.n25 VSS.n19 0.2513
R2178 VSS.n9 VSS.n8 0.2513
R2179 VSS.n27 VSS.n26 0.2513
R2180 VSS.n258 VSS.n256 0.250378
R2181 VSS.n260 VSS.n258 0.250378
R2182 VSS.n262 VSS.n260 0.250378
R2183 VSS.n264 VSS.n262 0.250378
R2184 VSS.n266 VSS.n264 0.250378
R2185 VSS.n268 VSS.n266 0.250378
R2186 VSS.n270 VSS.n268 0.250378
R2187 VSS.n272 VSS.n270 0.250378
R2188 VSS.n274 VSS.n272 0.250378
R2189 VSS.n276 VSS.n274 0.250378
R2190 VSS.n278 VSS.n276 0.250378
R2191 VSS.n280 VSS.n278 0.250378
R2192 VSS.n282 VSS.n280 0.250378
R2193 VSS.n284 VSS.n282 0.250378
R2194 VSS.n286 VSS.n284 0.250378
R2195 VSS.n286 VSS.n285 0.250378
R2196 VSS.n189 VSS.n188 0.250378
R2197 VSS.n190 VSS.n189 0.250378
R2198 VSS.n191 VSS.n190 0.250378
R2199 VSS.n192 VSS.n191 0.250378
R2200 VSS.n193 VSS.n192 0.250378
R2201 VSS.n194 VSS.n193 0.250378
R2202 VSS.n195 VSS.n194 0.250378
R2203 VSS.n196 VSS.n195 0.250378
R2204 VSS.n197 VSS.n196 0.250378
R2205 VSS.n198 VSS.n197 0.250378
R2206 VSS.n199 VSS.n198 0.250378
R2207 VSS.n200 VSS.n199 0.250378
R2208 VSS.n201 VSS.n200 0.250378
R2209 VSS.n202 VSS.n201 0.250378
R2210 VSS.n203 VSS.n202 0.250378
R2211 VSS.n618 VSS.n616 0.250378
R2212 VSS.n620 VSS.n618 0.250378
R2213 VSS.n626 VSS.n624 0.250378
R2214 VSS.n628 VSS.n626 0.250378
R2215 VSS.n505 VSS.n504 0.250378
R2216 VSS.n508 VSS.n507 0.250378
R2217 VSS.n509 VSS.n508 0.250378
R2218 VSS.n599 VSS.n598 0.244562
R2219 VSS.n596 VSS.n595 0.244562
R2220 VSS.n593 VSS.n592 0.244562
R2221 VSS.n528 VSS.n527 0.244562
R2222 VSS.n533 VSS.n532 0.244562
R2223 VSS.n538 VSS.n537 0.244562
R2224 VSS.n607 VSS.n606 0.241125
R2225 VSS.n605 VSS.n604 0.241125
R2226 VSS.n603 VSS.n602 0.241125
R2227 VSS.n601 VSS.n600 0.241125
R2228 VSS.n591 VSS.n590 0.241125
R2229 VSS.n589 VSS.n588 0.241125
R2230 VSS.n521 VSS.n518 0.241125
R2231 VSS.n560 VSS.n559 0.241125
R2232 VSS.n524 VSS.n520 0.241125
R2233 VSS.n541 VSS.n539 0.241125
R2234 VSS.n544 VSS.n542 0.241125
R2235 VSS.n547 VSS.n545 0.241125
R2236 VSS.n550 VSS.n548 0.241125
R2237 VSS.n613 VSS.n612 0.237688
R2238 VSS.n611 VSS.n610 0.237688
R2239 VSS.n609 VSS.n608 0.237688
R2240 VSS.n553 VSS.n551 0.237688
R2241 VSS.n556 VSS.n554 0.237688
R2242 VSS.n504 VSS.n503 0.235806
R2243 VSS.n285 VSS.n238 0.195378
R2244 VSS.n45 VSS.n25 0.194864
R2245 VSS.n57 VSS.n8 0.194864
R2246 VSS.n44 VSS.n26 0.194864
R2247 VSS.n639 VSS.n204 0.179037
R2248 VSS.n38 VSS.n32 0.16744
R2249 VSS.n39 VSS.n38 0.144318
R2250 VSS.n674 VSS.n672 0.138
R2251 VSS.n670 VSS.n669 0.138
R2252 VSS.n665 VSS.n664 0.138
R2253 VSS.n660 VSS.n659 0.138
R2254 VSS.n677 VSS.n676 0.138
R2255 VSS.n46 VSS.n45 0.132769
R2256 VSS.n57 VSS.n56 0.132769
R2257 VSS.n44 VSS.n43 0.132769
R2258 VSS.n668 VSS.n667 0.1325
R2259 VSS.n558 VSS.n556 0.125624
R2260 VSS.n614 VSS.n613 0.125612
R2261 VSS.n658 VSS.n646 0.125167
R2262 VSS.n678 VSS.n653 0.125167
R2263 VSS.n588 VSS.n587 0.123893
R2264 VSS.n523 VSS.n521 0.123881
R2265 VSS.n573 VSS.n569 0.123333
R2266 VSS.n546 VSS.n512 0.123333
R2267 VSS.n307 VSS.n154 0.123333
R2268 VSS.n384 VSS.n228 0.123333
R2269 VSS.n598 VSS.n597 0.122162
R2270 VSS.n595 VSS.n594 0.122162
R2271 VSS.n594 VSS.n593 0.122162
R2272 VSS.n597 VSS.n596 0.122162
R2273 VSS.n529 VSS.n528 0.122162
R2274 VSS.n534 VSS.n533 0.122162
R2275 VSS.n537 VSS.n534 0.122162
R2276 VSS.n532 VSS.n529 0.122162
R2277 VSS.n574 VSS.n481 0.1215
R2278 VSS.n549 VSS.n495 0.1215
R2279 VSS.n301 VSS.n300 0.1215
R2280 VSS.n308 VSS.n306 0.1215
R2281 VSS.n378 VSS.n377 0.1215
R2282 VSS.n385 VSS.n381 0.1215
R2283 VSS.n386 VSS.n385 0.1215
R2284 VSS.n393 VSS.n389 0.1215
R2285 VSS.n461 VSS.n460 0.1215
R2286 VSS.n468 VSS.n466 0.1215
R2287 VSS.n312 VSS.n236 0.119939
R2288 VSS.n387 VSS.n163 0.119939
R2289 VSS.n299 VSS.n237 0.119667
R2290 VSS.n376 VSS.n162 0.119667
R2291 VSS.n373 VSS.n372 0.118106
R2292 VSS.n398 VSS.n394 0.118106
R2293 VSS.n313 VSS.n309 0.118106
R2294 VSS.n456 VSS.n455 0.118106
R2295 VSS.n657 VSS.n648 0.117833
R2296 VSS.n671 VSS.n652 0.117833
R2297 VSS.n572 VSS.n479 0.117833
R2298 VSS.n543 VSS.n493 0.117833
R2299 VSS.n371 VSS.n161 0.116272
R2300 VSS.n575 VSS.n568 0.116
R2301 VSS.n552 VSS.n511 0.116
R2302 VSS.n317 VSS.n235 0.116
R2303 VSS.n392 VSS.n164 0.116
R2304 VSS.n318 VSS.n314 0.114167
R2305 VSS.n368 VSS.n367 0.114167
R2306 VSS.n401 VSS.n399 0.114167
R2307 VSS.n453 VSS.n452 0.114167
R2308 VSS.n322 VSS.n155 0.112606
R2309 VSS.n397 VSS.n227 0.112606
R2310 VSS.n571 VSS.n570 0.112333
R2311 VSS.n540 VSS.n513 0.112333
R2312 VSS.n366 VSS.n229 0.112333
R2313 VSS.n464 VSS.n219 0.112333
R2314 VSS.n323 VSS.n319 0.110772
R2315 VSS.n363 VSS.n362 0.110772
R2316 VSS.n406 VSS.n402 0.110772
R2317 VSS.n448 VSS.n447 0.110772
R2318 VSS.n300 VSS.n297 0.110691
R2319 VSS.n663 VSS.n649 0.1105
R2320 VSS.n673 VSS.n651 0.1105
R2321 VSS.n576 VSS.n482 0.1105
R2322 VSS.n555 VSS.n496 0.1105
R2323 VSS.n361 VSS.n230 0.108939
R2324 VSS.n459 VSS.n220 0.108939
R2325 VSS.n325 VSS.n156 0.108667
R2326 VSS.n400 VSS.n226 0.108667
R2327 VSS.n535 VSS.n492 0.106833
R2328 VSS.n326 VSS.n324 0.106833
R2329 VSS.n360 VSS.n359 0.106833
R2330 VSS.n411 VSS.n407 0.106833
R2331 VSS.n443 VSS.n442 0.106833
R2332 VSS.n330 VSS.n234 0.105272
R2333 VSS.n405 VSS.n165 0.105272
R2334 VSS.n577 VSS.n567 0.105
R2335 VSS.n358 VSS.n160 0.105
R2336 VSS.n454 VSS.n172 0.105
R2337 VSS.n355 VSS.n354 0.103439
R2338 VSS.n416 VSS.n412 0.103439
R2339 VSS.n331 VSS.n327 0.103439
R2340 VSS.n438 VSS.n437 0.103439
R2341 VSS.n662 VSS.n650 0.103167
R2342 VSS.n353 VSS.n159 0.101606
R2343 VSS.n451 VSS.n171 0.101606
R2344 VSS.n536 VSS.n514 0.101333
R2345 VSS.n335 VSS.n233 0.101333
R2346 VSS.n410 VSS.n166 0.101333
R2347 VSS.n433 VSS.n223 0.101333
R2348 VSS.n578 VSS.n483 0.0995
R2349 VSS.n336 VSS.n332 0.0995
R2350 VSS.n350 VSS.n349 0.0995
R2351 VSS.n419 VSS.n417 0.0995
R2352 VSS.n435 VSS.n434 0.0995
R2353 VSS.n340 VSS.n157 0.0979389
R2354 VSS.n415 VSS.n225 0.0979389
R2355 VSS.n436 VSS.n169 0.0979389
R2356 VSS.n348 VSS.n231 0.0976667
R2357 VSS.n423 VSS.n168 0.0976667
R2358 VSS.n446 VSS.n221 0.0976667
R2359 VSS.n341 VSS.n337 0.0961056
R2360 VSS.n430 VSS.n429 0.0961056
R2361 VSS.n345 VSS.n344 0.0961056
R2362 VSS.n424 VSS.n420 0.0961056
R2363 VSS.n530 VSS.n491 0.0958333
R2364 VSS.n343 VSS.n232 0.0942723
R2365 VSS.n418 VSS.n167 0.0942723
R2366 VSS.n441 VSS.n222 0.0942723
R2367 VSS.n579 VSS.n566 0.094
R2368 VSS.n343 VSS.n158 0.094
R2369 VSS.n418 VSS.n224 0.094
R2370 VSS.n441 VSS.n170 0.094
R2371 VSS.n342 VSS.n341 0.0921667
R2372 VSS.n344 VSS.n342 0.0921667
R2373 VSS.n425 VSS.n424 0.0921667
R2374 VSS.n429 VSS.n425 0.0921667
R2375 VSS.n348 VSS.n232 0.0906056
R2376 VSS.n423 VSS.n167 0.0906056
R2377 VSS.n446 VSS.n222 0.0906056
R2378 VSS.n531 VSS.n515 0.0903333
R2379 VSS.n340 VSS.n158 0.0903333
R2380 VSS.n415 VSS.n224 0.0903333
R2381 VSS.n436 VSS.n170 0.0903333
R2382 VSS.n337 VSS.n336 0.0887723
R2383 VSS.n434 VSS.n430 0.0887723
R2384 VSS.n349 VSS.n345 0.0887723
R2385 VSS.n420 VSS.n419 0.0887723
R2386 VSS.n580 VSS.n484 0.0885
R2387 VSS.n469 VSS.n468 0.0883085
R2388 VSS.n40 VSS.n39 0.0877727
R2389 VSS.n41 VSS.n40 0.0877727
R2390 VSS.n42 VSS.n41 0.0877727
R2391 VSS.n43 VSS.n42 0.0877727
R2392 VSS.n47 VSS.n46 0.0877727
R2393 VSS.n48 VSS.n47 0.0877727
R2394 VSS.n49 VSS.n48 0.0877727
R2395 VSS.n50 VSS.n49 0.0877727
R2396 VSS.n51 VSS.n50 0.0877727
R2397 VSS.n52 VSS.n51 0.0877727
R2398 VSS.n53 VSS.n52 0.0877727
R2399 VSS.n54 VSS.n53 0.0877727
R2400 VSS.n55 VSS.n54 0.0877727
R2401 VSS.n56 VSS.n55 0.0877727
R2402 VSS.n335 VSS.n157 0.0869389
R2403 VSS.n410 VSS.n225 0.0869389
R2404 VSS.n433 VSS.n169 0.0869389
R2405 VSS.n353 VSS.n231 0.0866667
R2406 VSS.n428 VSS.n168 0.0866667
R2407 VSS.n451 VSS.n221 0.0866667
R2408 VSS.n525 VSS.n490 0.0848333
R2409 VSS.n332 VSS.n331 0.0848333
R2410 VSS.n354 VSS.n350 0.0848333
R2411 VSS.n417 VSS.n416 0.0848333
R2412 VSS.n437 VSS.n435 0.0848333
R2413 VSS.n358 VSS.n159 0.0832723
R2414 VSS.n454 VSS.n171 0.0832723
R2415 VSS.n581 VSS.n565 0.083
R2416 VSS.n330 VSS.n233 0.083
R2417 VSS.n405 VSS.n166 0.083
R2418 VSS.n428 VSS.n223 0.083
R2419 VSS.n359 VSS.n355 0.081439
R2420 VSS.n412 VSS.n411 0.081439
R2421 VSS.n327 VSS.n326 0.0814389
R2422 VSS.n442 VSS.n438 0.0814389
R2423 VSS.n325 VSS.n234 0.0796056
R2424 VSS.n400 VSS.n165 0.0796056
R2425 VSS.n526 VSS.n516 0.0793333
R2426 VSS.n361 VSS.n160 0.0793333
R2427 VSS.n459 VSS.n172 0.0793333
R2428 VSS.n582 VSS.n485 0.0775
R2429 VSS.n324 VSS.n323 0.0775
R2430 VSS.n362 VSS.n360 0.0775
R2431 VSS.n407 VSS.n406 0.0775
R2432 VSS.n447 VSS.n443 0.0775
R2433 VSS.n366 VSS.n230 0.0759389
R2434 VSS.n464 VSS.n220 0.0759389
R2435 VSS.n322 VSS.n156 0.0756667
R2436 VSS.n397 VSS.n226 0.0756667
R2437 VSS.n319 VSS.n318 0.0741056
R2438 VSS.n452 VSS.n448 0.0741056
R2439 VSS.n367 VSS.n363 0.0741056
R2440 VSS.n402 VSS.n401 0.0741056
R2441 VSS.n519 VSS.n489 0.0738333
R2442 VSS.n317 VSS.n155 0.0722723
R2443 VSS.n392 VSS.n227 0.0722723
R2444 VSS.n583 VSS.n564 0.072
R2445 VSS.n371 VSS.n229 0.072
R2446 VSS.n467 VSS.n219 0.072
R2447 VSS.n657 VSS.n647 0.070439
R2448 VSS.n679 VSS.n654 0.070439
R2449 VSS.n586 VSS.n563 0.0701667
R2450 VSS.n314 VSS.n313 0.0701667
R2451 VSS.n372 VSS.n368 0.0701667
R2452 VSS.n399 VSS.n398 0.0701667
R2453 VSS.n455 VSS.n453 0.0701667
R2454 VSS.n672 VSS.n655 0.0694731
R2455 VSS.n675 VSS.n670 0.0694731
R2456 VSS.n666 VSS.n665 0.0694731
R2457 VSS.n661 VSS.n660 0.0694731
R2458 VSS.n659 VSS.n656 0.0694731
R2459 VSS.n664 VSS.n661 0.0694731
R2460 VSS.n669 VSS.n666 0.0694731
R2461 VSS.n675 VSS.n674 0.0694731
R2462 VSS.n677 VSS.n655 0.0694731
R2463 VSS.n299 VSS.n238 0.0686056
R2464 VSS.n376 VSS.n161 0.0686056
R2465 VSS.n522 VSS.n488 0.0683333
R2466 VSS.n562 VSS.n561 0.0683333
R2467 VSS.n312 VSS.n235 0.0683333
R2468 VSS.n387 VSS.n164 0.0683333
R2469 VSS.n574 VSS.n480 0.0667723
R2470 VSS.n549 VSS.n494 0.0667723
R2471 VSS.n377 VSS.n373 0.0667723
R2472 VSS.n394 VSS.n393 0.0667723
R2473 VSS.n309 VSS.n308 0.0667723
R2474 VSS.n460 VSS.n456 0.0667723
R2475 VSS.n584 VSS.n486 0.0665
R2476 VSS.n573 VSS.n480 0.0649389
R2477 VSS.n546 VSS.n494 0.0649389
R2478 VSS.n307 VSS.n236 0.0649389
R2479 VSS.n384 VSS.n163 0.0649389
R2480 VSS.n585 VSS.n486 0.0646667
R2481 VSS.n304 VSS.n237 0.0646667
R2482 VSS.n379 VSS.n162 0.0646667
R2483 VSS.n658 VSS.n647 0.0631056
R2484 VSS.n679 VSS.n678 0.0631056
R2485 VSS.n517 VSS.n488 0.0628333
R2486 VSS.n562 VSS.n517 0.0628333
R2487 VSS.n305 VSS.n301 0.0628333
R2488 VSS.n306 VSS.n305 0.0628333
R2489 VSS.n380 VSS.n378 0.0628333
R2490 VSS.n381 VSS.n380 0.0628333
R2491 VSS.n388 VSS.n386 0.0628333
R2492 VSS.n389 VSS.n388 0.0628333
R2493 VSS.n465 VSS.n461 0.0628333
R2494 VSS.n466 VSS.n465 0.0628333
R2495 VSS.n585 VSS.n563 0.061
R2496 VSS.n304 VSS.n154 0.061
R2497 VSS.n379 VSS.n228 0.061
R2498 VSS.n584 VSS.n564 0.0591667
R2499 VSS.n561 VSS.n489 0.0573333
R2500 VSS.n583 VSS.n485 0.0536667
R2501 VSS.n519 VSS.n516 0.0518333
R2502 VSS.n503 VSS.n502 0.0485334
R2503 VSS.n582 VSS.n565 0.0481667
R2504 VSS.n526 VSS.n490 0.0463333
R2505 VSS.n502 VSS.n469 0.0442377
R2506 VSS.n581 VSS.n484 0.0426667
R2507 VSS.n525 VSS.n515 0.0408333
R2508 VSS.n580 VSS.n566 0.0371667
R2509 VSS.n701 VSS.n2 0.0371667
R2510 VSS.n702 VSS.n701 0.0371667
R2511 VSS.n531 VSS.n491 0.0353333
R2512 VSS.n680 VSS.n59 0.0342355
R2513 VSS.n579 VSS.n483 0.0316667
R2514 VSS.n692 VSS.n7 0.0300385
R2515 VSS.n686 VSS.n7 0.0300385
R2516 VSS.n686 VSS.n682 0.0300385
R2517 VSS.n685 VSS.n683 0.0300385
R2518 VSS.n697 VSS.n5 0.0300385
R2519 VSS.n699 VSS.n4 0.0300385
R2520 VSS.n699 VSS.n698 0.0300385
R2521 VSS.n698 VSS.n1 0.0300385
R2522 VSS.n700 VSS.n3 0.0300385
R2523 VSS.n700 VSS.n0 0.0300385
R2524 VSS.n668 VSS.n650 0.0298333
R2525 VSS.n530 VSS.n514 0.0298333
R2526 VSS.n578 VSS.n567 0.0261667
R2527 VSS.n536 VSS.n492 0.0243333
R2528 VSS.n662 VSS.n649 0.0225
R2529 VSS.n667 VSS.n651 0.0225
R2530 VSS.n577 VSS.n482 0.0206667
R2531 VSS.n557 VSS.n496 0.0206667
R2532 VSS.n615 VSS.n570 0.0188333
R2533 VSS.n535 VSS.n513 0.0188333
R2534 VSS VSS.n0 0.0165
R2535 VSS.n691 VSS.n690 0.0157766
R2536 VSS.n693 VSS.n6 0.0157673
R2537 VSS.n695 VSS.n694 0.0157673
R2538 VSS.n685 VSS.n684 0.0155798
R2539 VSS.n683 VSS.n6 0.0155798
R2540 VSS.n697 VSS.n696 0.0155798
R2541 VSS.n695 VSS.n5 0.0155798
R2542 VSS.n688 VSS.n687 0.0155706
R2543 VSS.n690 VSS.n58 0.0155706
R2544 VSS VSS.n58 0.0152692
R2545 VSS.n687 VSS 0.0152692
R2546 VSS.n663 VSS.n648 0.0151667
R2547 VSS.n673 VSS.n652 0.0151667
R2548 VSS.n576 VSS.n568 0.0151667
R2549 VSS.n555 VSS.n511 0.0151667
R2550 VSS VSS.n703 0.0140385
R2551 VSS.n571 VSS.n479 0.0133333
R2552 VSS.n540 VSS.n493 0.0133333
R2553 VSS.n575 VSS.n481 0.00966667
R2554 VSS.n552 VSS.n495 0.00966667
R2555 VSS.n646 VSS.n60 0.00783333
R2556 VSS.n671 VSS.n653 0.00783333
R2557 VSS.n572 VSS.n569 0.00783333
R2558 VSS.n543 VSS.n512 0.00783333
R2559 VSS.n612 VSS.n611 0.007375
R2560 VSS.n610 VSS.n609 0.007375
R2561 VSS.n608 VSS.n607 0.007375
R2562 VSS.n551 VSS.n550 0.007375
R2563 VSS.n554 VSS.n553 0.007375
R2564 VSS.n642 VSS.n79 0.00493713
R2565 VSS.n606 VSS.n605 0.0039375
R2566 VSS.n604 VSS.n603 0.0039375
R2567 VSS.n602 VSS.n601 0.0039375
R2568 VSS.n600 VSS.n599 0.0039375
R2569 VSS.n592 VSS.n591 0.0039375
R2570 VSS.n590 VSS.n589 0.0039375
R2571 VSS.n560 VSS.n518 0.0039375
R2572 VSS.n559 VSS.n520 0.0039375
R2573 VSS.n527 VSS.n524 0.0039375
R2574 VSS.n539 VSS.n538 0.0039375
R2575 VSS.n542 VSS.n541 0.0039375
R2576 VSS.n545 VSS.n544 0.0039375
R2577 VSS.n548 VSS.n547 0.0039375
R2578 VSS.n173 VSS.n77 0.00166667
R2579 VSS.n639 VSS.n77 0.00133332
R2580 VSS.n680 VSS.n645 0.0010016
R2581 VSS.n255 VSS.n80 0.001
R2582 VSS.n255 VSS.n240 0.001
R2583 VSS.n257 VSS.n241 0.001
R2584 VSS.n259 VSS.n242 0.001
R2585 VSS.n261 VSS.n243 0.001
R2586 VSS.n263 VSS.n244 0.001
R2587 VSS.n265 VSS.n245 0.001
R2588 VSS.n267 VSS.n246 0.001
R2589 VSS.n269 VSS.n247 0.001
R2590 VSS.n271 VSS.n248 0.001
R2591 VSS.n273 VSS.n249 0.001
R2592 VSS.n275 VSS.n250 0.001
R2593 VSS.n277 VSS.n251 0.001
R2594 VSS.n279 VSS.n252 0.001
R2595 VSS.n281 VSS.n253 0.001
R2596 VSS.n283 VSS.n254 0.001
R2597 VSS.n288 VSS.n287 0.001
R2598 VSS.n638 VSS.n239 0.001
R2599 VSS.n643 VSS.n78 0.001
R2600 VSS.n78 VSS.n62 0.001
R2601 VSS.n187 VSS.n63 0.001
R2602 VSS.n186 VSS.n64 0.001
R2603 VSS.n185 VSS.n65 0.001
R2604 VSS.n184 VSS.n66 0.001
R2605 VSS.n183 VSS.n67 0.001
R2606 VSS.n182 VSS.n68 0.001
R2607 VSS.n181 VSS.n69 0.001
R2608 VSS.n180 VSS.n70 0.001
R2609 VSS.n179 VSS.n71 0.001
R2610 VSS.n178 VSS.n72 0.001
R2611 VSS.n177 VSS.n73 0.001
R2612 VSS.n176 VSS.n74 0.001
R2613 VSS.n175 VSS.n75 0.001
R2614 VSS.n174 VSS.n76 0.001
R2615 VSS.n635 VSS.n296 0.001
R2616 VSS.n296 VSS.n289 0.001
R2617 VSS.n617 VSS.n290 0.001
R2618 VSS.n619 VSS.n291 0.001
R2619 VSS.n621 VSS.n292 0.001
R2620 VSS.n623 VSS.n293 0.001
R2621 VSS.n625 VSS.n294 0.001
R2622 VSS.n627 VSS.n295 0.001
R2623 VSS.n633 VSS.n471 0.001
R2624 VSS.n472 VSS.n471 0.001
R2625 VSS.n501 VSS.n473 0.001
R2626 VSS.n500 VSS.n474 0.001
R2627 VSS.n499 VSS.n475 0.001
R2628 VSS.n498 VSS.n476 0.001
R2629 VSS.n497 VSS.n477 0.001
R2630 VSS.n631 VSS.n478 0.001
R2631 VSS.n634 VSS.n633 0.001
R2632 VSS.n635 VSS.n634 0.001
R2633 VSS.n617 VSS.n289 0.001
R2634 VSS.n619 VSS.n290 0.001
R2635 VSS.n621 VSS.n291 0.001
R2636 VSS.n623 VSS.n292 0.001
R2637 VSS.n625 VSS.n293 0.001
R2638 VSS.n627 VSS.n294 0.001
R2639 VSS.n478 VSS.n477 0.001
R2640 VSS.n497 VSS.n476 0.001
R2641 VSS.n498 VSS.n475 0.001
R2642 VSS.n499 VSS.n474 0.001
R2643 VSS.n500 VSS.n473 0.001
R2644 VSS.n501 VSS.n472 0.001
R2645 VSS.n631 VSS.n630 0.001
R2646 VSS.n630 VSS.n295 0.001
R2647 VSS.n643 VSS.n642 0.001
R2648 VSS.n642 VSS.n80 0.001
R2649 VSS.n257 VSS.n240 0.001
R2650 VSS.n259 VSS.n241 0.001
R2651 VSS.n261 VSS.n242 0.001
R2652 VSS.n263 VSS.n243 0.001
R2653 VSS.n265 VSS.n244 0.001
R2654 VSS.n267 VSS.n245 0.001
R2655 VSS.n269 VSS.n246 0.001
R2656 VSS.n271 VSS.n247 0.001
R2657 VSS.n273 VSS.n248 0.001
R2658 VSS.n275 VSS.n249 0.001
R2659 VSS.n277 VSS.n250 0.001
R2660 VSS.n279 VSS.n251 0.001
R2661 VSS.n281 VSS.n252 0.001
R2662 VSS.n283 VSS.n253 0.001
R2663 VSS.n287 VSS.n254 0.001
R2664 VSS.n288 VSS.n239 0.001
R2665 VSS.n173 VSS.n76 0.001
R2666 VSS.n174 VSS.n75 0.001
R2667 VSS.n175 VSS.n74 0.001
R2668 VSS.n176 VSS.n73 0.001
R2669 VSS.n177 VSS.n72 0.001
R2670 VSS.n178 VSS.n71 0.001
R2671 VSS.n179 VSS.n70 0.001
R2672 VSS.n180 VSS.n69 0.001
R2673 VSS.n181 VSS.n68 0.001
R2674 VSS.n182 VSS.n67 0.001
R2675 VSS.n183 VSS.n66 0.001
R2676 VSS.n184 VSS.n65 0.001
R2677 VSS.n185 VSS.n64 0.001
R2678 VSS.n186 VSS.n63 0.001
R2679 VSS.n187 VSS.n62 0.001
R2680 VSS.n639 VSS.n638 0.001
R2681 a_9470_2433.t3 a_9470_2433.n0 4.57012
R2682 a_9470_2433.n0 a_9470_2433.n1 2.49383
R2683 a_9470_2433.n1 a_9470_2433.t1 4.66905
R2684 a_9470_2433.n1 a_9470_2433.t0 2.17572
R2685 a_9470_2433.n0 a_9470_2433.t2 2.17572
R2686 a_6684_2433.t3 a_6684_2433.n0 4.84322
R2687 a_6684_2433.n0 a_6684_2433.n1 2.49383
R2688 a_6684_2433.n1 a_6684_2433.t0 4.66905
R2689 a_6684_2433.n1 a_6684_2433.t2 2.17572
R2690 a_6684_2433.n0 a_6684_2433.t1 2.17572
R2691 a_6599_7119.t18 a_6599_7119.n0 2.81667
R2692 a_6599_7119.n0 a_6599_7119.n1 1.8005
R2693 a_6599_7119.n27 a_6599_7119.n28 2.42383
R2694 a_6599_7119.n29 a_6599_7119.n28 2.49383
R2695 a_6599_7119.n0 a_6599_7119.n29 1.8705
R2696 a_6599_7119.n29 a_6599_7119.t15 2.1853
R2697 a_6599_7119.n28 a_6599_7119.t12 2.1853
R2698 a_6599_7119.n27 a_6599_7119.n26 12.8137
R2699 a_6599_7119.n26 a_6599_7119.n17 1.8705
R2700 a_6599_7119.n17 a_6599_7119.n18 2.49383
R2701 a_6599_7119.n18 a_6599_7119.n19 2.49383
R2702 a_6599_7119.n19 a_6599_7119.n20 2.49383
R2703 a_6599_7119.n20 a_6599_7119.n21 2.49383
R2704 a_6599_7119.n21 a_6599_7119.n22 2.49383
R2705 a_6599_7119.n22 a_6599_7119.n23 2.49383
R2706 a_6599_7119.n23 a_6599_7119.n24 2.49383
R2707 a_6599_7119.n24 a_6599_7119.n25 2.49383
R2708 a_6599_7119.n25 a_6599_7119.t0 4.68252
R2709 a_6599_7119.n25 a_6599_7119.t7 2.18975
R2710 a_6599_7119.n24 a_6599_7119.t4 2.18975
R2711 a_6599_7119.n23 a_6599_7119.t8 2.18975
R2712 a_6599_7119.n22 a_6599_7119.t2 2.18975
R2713 a_6599_7119.n21 a_6599_7119.t5 2.18975
R2714 a_6599_7119.n20 a_6599_7119.t10 2.18975
R2715 a_6599_7119.n19 a_6599_7119.t3 2.18975
R2716 a_6599_7119.n18 a_6599_7119.t6 2.18975
R2717 a_6599_7119.n17 a_6599_7119.t9 2.18975
R2718 a_6599_7119.n26 a_6599_7119.t1 2.81309
R2719 a_6599_7119.n3 a_6599_7119.n2 0.9005
R2720 a_6599_7119.n9 a_6599_7119.n8 0.9005
R2721 a_6599_7119.n3 a_6599_7119.n27 0.232188
R2722 a_6599_7119.n4 a_6599_7119.n3 1.5713
R2723 a_6599_7119.n9 a_6599_7119.n4 1.5713
R2724 a_6599_7119.n1 a_6599_7119.n9 0.232188
R2725 a_6599_7119.n11 a_6599_7119.n10 0.9005
R2726 a_6599_7119.n1 a_6599_7119.n11 2.17259
R2727 a_6599_7119.n11 a_6599_7119.n12 1.5713
R2728 a_6599_7119.n12 a_6599_7119.n16 2.4713
R2729 a_6599_7119.n16 a_6599_7119.t20 2.94128
R2730 a_6599_7119.n16 a_6599_7119.t19 2.94359
R2731 a_6599_7119.t20 a_6599_7119.n13 2.33622
R2732 a_6599_7119.t22 a_6599_7119.n14 2.33654
R2733 a_6599_7119.t21 a_6599_7119.n15 2.33654
R2734 a_6599_7119.t23 a_6599_7119.n14 3.5502
R2735 a_6599_7119.n14 a_6599_7119.n15 1.21656
R2736 a_6599_7119.n15 a_6599_7119.n13 1.21611
R2737 a_6599_7119.n13 a_6599_7119.t19 3.55242
R2738 a_6599_7119.n12 a_6599_7119.t21 4.39573
R2739 a_6599_7119.n10 a_6599_7119.t22 2.94459
R2740 a_6599_7119.n10 a_6599_7119.t23 2.9439
R2741 a_6599_7119.n8 a_6599_7119.t16 2.94128
R2742 a_6599_7119.n8 a_6599_7119.t17 2.94359
R2743 a_6599_7119.t16 a_6599_7119.n5 2.33622
R2744 a_6599_7119.t13 a_6599_7119.n6 2.33654
R2745 a_6599_7119.t14 a_6599_7119.n7 2.33654
R2746 a_6599_7119.t11 a_6599_7119.n6 3.5502
R2747 a_6599_7119.n7 a_6599_7119.n6 1.21656
R2748 a_6599_7119.n5 a_6599_7119.n7 1.21611
R2749 a_6599_7119.n5 a_6599_7119.t17 3.55242
R2750 a_6599_7119.n4 a_6599_7119.t14 4.39573
R2751 a_6599_7119.n2 a_6599_7119.t13 2.94459
R2752 a_6599_7119.n2 a_6599_7119.t11 2.9439
R2753 a_7067_5083.t12 a_7067_5083.n12 2.25545
R2754 a_7067_5083.n11 a_7067_5083.n0 1.8705
R2755 a_7067_5083.n12 a_7067_5083.n11 2.49383
R2756 a_7067_5083.n12 a_7067_5083.n1 2.46942
R2757 a_7067_5083.n0 a_7067_5083.t10 2.88313
R2758 a_7067_5083.n11 a_7067_5083.t11 2.25982
R2759 a_7067_5083.n1 a_7067_5083.n0 5.76576
R2760 a_7067_5083.n1 a_7067_5083.n2 19.1697
R2761 a_7067_5083.n9 a_7067_5083.n10 2.49383
R2762 a_7067_5083.n8 a_7067_5083.n9 2.49383
R2763 a_7067_5083.n7 a_7067_5083.n8 2.49383
R2764 a_7067_5083.n6 a_7067_5083.n7 2.49383
R2765 a_7067_5083.n5 a_7067_5083.n6 2.49383
R2766 a_7067_5083.n4 a_7067_5083.n5 2.49383
R2767 a_7067_5083.n3 a_7067_5083.n4 2.49383
R2768 a_7067_5083.n2 a_7067_5083.n3 2.49383
R2769 a_7067_5083.n10 a_7067_5083.t1 4.6735
R2770 a_7067_5083.n10 a_7067_5083.t8 2.18016
R2771 a_7067_5083.n9 a_7067_5083.t3 2.18016
R2772 a_7067_5083.n8 a_7067_5083.t7 2.18016
R2773 a_7067_5083.n7 a_7067_5083.t9 2.18016
R2774 a_7067_5083.n6 a_7067_5083.t2 2.18016
R2775 a_7067_5083.n5 a_7067_5083.t5 2.18016
R2776 a_7067_5083.n4 a_7067_5083.t6 2.18016
R2777 a_7067_5083.n3 a_7067_5083.t4 2.18016
R2778 a_7067_5083.n2 a_7067_5083.t0 2.18016
R2779 a_7067_7119.n1 a_7067_7119.n12 6.49735
R2780 a_7067_7119.n11 a_7067_7119.n12 2.49383
R2781 a_7067_7119.n0 a_7067_7119.n11 1.8705
R2782 a_7067_7119.t12 a_7067_7119.n0 2.88102
R2783 a_7067_7119.n12 a_7067_7119.t10 2.26207
R2784 a_7067_7119.n11 a_7067_7119.t11 2.26206
R2785 a_7067_7119.n1 a_7067_7119.n2 19.8431
R2786 a_7067_7119.n9 a_7067_7119.n10 2.49383
R2787 a_7067_7119.n8 a_7067_7119.n9 2.49383
R2788 a_7067_7119.n7 a_7067_7119.n8 2.49383
R2789 a_7067_7119.n6 a_7067_7119.n7 2.49383
R2790 a_7067_7119.n5 a_7067_7119.n6 2.49383
R2791 a_7067_7119.n4 a_7067_7119.n5 2.49383
R2792 a_7067_7119.n3 a_7067_7119.n4 2.49383
R2793 a_7067_7119.n2 a_7067_7119.n3 2.49383
R2794 a_7067_7119.n10 a_7067_7119.t1 4.6735
R2795 a_7067_7119.n10 a_7067_7119.t8 2.18016
R2796 a_7067_7119.n9 a_7067_7119.t3 2.18016
R2797 a_7067_7119.n8 a_7067_7119.t7 2.18016
R2798 a_7067_7119.n7 a_7067_7119.t9 2.18016
R2799 a_7067_7119.n6 a_7067_7119.t2 2.18016
R2800 a_7067_7119.n5 a_7067_7119.t5 2.18016
R2801 a_7067_7119.n4 a_7067_7119.t6 2.18016
R2802 a_7067_7119.n3 a_7067_7119.t4 2.18016
R2803 a_7067_7119.n2 a_7067_7119.t0 2.18016
R2804 a_7067_7119.n0 a_7067_7119.n1 1.89691
R2805 a_7067_9155.t11 a_7067_9155.n12 2.25769
R2806 a_7067_9155.n1 a_7067_9155.n11 6.58896
R2807 a_7067_9155.n12 a_7067_9155.n11 2.49383
R2808 a_7067_9155.n12 a_7067_9155.n0 1.8705
R2809 a_7067_9155.n11 a_7067_9155.t10 2.26207
R2810 a_7067_9155.n0 a_7067_9155.t12 2.88303
R2811 a_7067_9155.n1 a_7067_9155.n2 20.5063
R2812 a_7067_9155.n9 a_7067_9155.n10 2.49383
R2813 a_7067_9155.n8 a_7067_9155.n9 2.49383
R2814 a_7067_9155.n7 a_7067_9155.n8 2.49383
R2815 a_7067_9155.n6 a_7067_9155.n7 2.49383
R2816 a_7067_9155.n5 a_7067_9155.n6 2.49383
R2817 a_7067_9155.n4 a_7067_9155.n5 2.49383
R2818 a_7067_9155.n3 a_7067_9155.n4 2.49383
R2819 a_7067_9155.n2 a_7067_9155.n3 2.49383
R2820 a_7067_9155.n10 a_7067_9155.t5 4.6735
R2821 a_7067_9155.n10 a_7067_9155.t4 2.18016
R2822 a_7067_9155.n9 a_7067_9155.t3 2.18016
R2823 a_7067_9155.n8 a_7067_9155.t9 2.18016
R2824 a_7067_9155.n7 a_7067_9155.t2 2.18016
R2825 a_7067_9155.n6 a_7067_9155.t0 2.18016
R2826 a_7067_9155.n5 a_7067_9155.t8 2.18016
R2827 a_7067_9155.n4 a_7067_9155.t6 2.18016
R2828 a_7067_9155.n3 a_7067_9155.t7 2.18016
R2829 a_7067_9155.n2 a_7067_9155.t1 2.18016
R2830 a_7067_9155.n0 a_7067_9155.n1 1.95141
R2831 a_6599_9155.t30 a_6599_9155.n0 2.82113
R2832 a_6599_9155.n1 a_6599_9155.n101 1.8705
R2833 a_6599_9155.n101 a_6599_9155.n102 2.49383
R2834 a_6599_9155.n102 a_6599_9155.n103 2.49383
R2835 a_6599_9155.n104 a_6599_9155.n103 2.49383
R2836 a_6599_9155.n105 a_6599_9155.n104 2.49383
R2837 a_6599_9155.n106 a_6599_9155.n105 2.49383
R2838 a_6599_9155.n107 a_6599_9155.n106 2.49383
R2839 a_6599_9155.n108 a_6599_9155.n107 2.49383
R2840 a_6599_9155.n109 a_6599_9155.n108 2.49383
R2841 a_6599_9155.n0 a_6599_9155.n109 1.8705
R2842 a_6599_9155.n109 a_6599_9155.t27 2.18975
R2843 a_6599_9155.n108 a_6599_9155.t24 2.18975
R2844 a_6599_9155.n107 a_6599_9155.t21 2.18975
R2845 a_6599_9155.n106 a_6599_9155.t18 2.18975
R2846 a_6599_9155.n105 a_6599_9155.t15 2.18975
R2847 a_6599_9155.n104 a_6599_9155.t12 2.18975
R2848 a_6599_9155.n103 a_6599_9155.t9 2.18975
R2849 a_6599_9155.n102 a_6599_9155.t6 2.18975
R2850 a_6599_9155.n101 a_6599_9155.t3 2.18975
R2851 a_6599_9155.n1 a_6599_9155.t1 2.81252
R2852 a_6599_9155.n100 a_6599_9155.n1 2.0259
R2853 a_6599_9155.n100 a_6599_9155.t31 2.41061
R2854 a_6599_9155.n2 a_6599_9155.n100 0.426795
R2855 a_6599_9155.n3 a_6599_9155.n2 0.750664
R2856 a_6599_9155.n4 a_6599_9155.n3 0.750664
R2857 a_6599_9155.n5 a_6599_9155.n4 0.750664
R2858 a_6599_9155.n6 a_6599_9155.n5 0.750664
R2859 a_6599_9155.n7 a_6599_9155.n6 0.750664
R2860 a_6599_9155.n8 a_6599_9155.n7 0.750664
R2861 a_6599_9155.n99 a_6599_9155.n8 0.750664
R2862 a_6599_9155.n99 a_6599_9155.n9 1.38109
R2863 a_6599_9155.n12 a_6599_9155.n11 0.4505
R2864 a_6599_9155.n14 a_6599_9155.n13 0.4505
R2865 a_6599_9155.n16 a_6599_9155.n15 0.4505
R2866 a_6599_9155.n18 a_6599_9155.n17 0.4505
R2867 a_6599_9155.n20 a_6599_9155.n19 0.4505
R2868 a_6599_9155.n22 a_6599_9155.n21 0.4505
R2869 a_6599_9155.n24 a_6599_9155.n23 0.4505
R2870 a_6599_9155.n26 a_6599_9155.n25 0.4505
R2871 a_6599_9155.n35 a_6599_9155.n10 0.539943
R2872 a_6599_9155.n34 a_6599_9155.n35 0.375582
R2873 a_6599_9155.n12 a_6599_9155.n34 0.222664
R2874 a_6599_9155.n36 a_6599_9155.n12 0.153418
R2875 a_6599_9155.n33 a_6599_9155.n36 0.375582
R2876 a_6599_9155.n14 a_6599_9155.n33 0.159189
R2877 a_6599_9155.n37 a_6599_9155.n14 0.216893
R2878 a_6599_9155.n32 a_6599_9155.n37 0.375582
R2879 a_6599_9155.n16 a_6599_9155.n32 0.0957131
R2880 a_6599_9155.n38 a_6599_9155.n16 0.280369
R2881 a_6599_9155.n31 a_6599_9155.n38 0.375582
R2882 a_6599_9155.n18 a_6599_9155.n31 0.0322377
R2883 a_6599_9155.n39 a_6599_9155.n18 0.343844
R2884 a_6599_9155.n20 a_6599_9155.n39 0.343844
R2885 a_6599_9155.n30 a_6599_9155.n20 0.0322377
R2886 a_6599_9155.n40 a_6599_9155.n30 0.375582
R2887 a_6599_9155.n22 a_6599_9155.n40 0.280369
R2888 a_6599_9155.n29 a_6599_9155.n22 0.0957131
R2889 a_6599_9155.n41 a_6599_9155.n29 0.375582
R2890 a_6599_9155.n24 a_6599_9155.n41 0.216893
R2891 a_6599_9155.n28 a_6599_9155.n24 0.159189
R2892 a_6599_9155.n42 a_6599_9155.n28 0.375582
R2893 a_6599_9155.n26 a_6599_9155.n42 0.153418
R2894 a_6599_9155.n9 a_6599_9155.n26 0.222664
R2895 a_6599_9155.n9 a_6599_9155.n98 0.375582
R2896 a_6599_9155.n98 a_6599_9155.n27 0.539943
R2897 a_6599_9155.n97 a_6599_9155.n98 4.01079
R2898 a_6599_9155.n48 a_6599_9155.n49 0.4505
R2899 a_6599_9155.n52 a_6599_9155.n53 0.4505
R2900 a_6599_9155.n56 a_6599_9155.n57 0.4505
R2901 a_6599_9155.n60 a_6599_9155.n61 0.4505
R2902 a_6599_9155.n64 a_6599_9155.n65 0.4505
R2903 a_6599_9155.n68 a_6599_9155.n69 0.4505
R2904 a_6599_9155.n72 a_6599_9155.n73 0.4505
R2905 a_6599_9155.n76 a_6599_9155.n77 0.4505
R2906 a_6599_9155.n45 a_6599_9155.n96 0.539943
R2907 a_6599_9155.n95 a_6599_9155.n96 0.375582
R2908 a_6599_9155.n49 a_6599_9155.n95 0.222664
R2909 a_6599_9155.n49 a_6599_9155.n94 0.153418
R2910 a_6599_9155.n93 a_6599_9155.n94 0.375582
R2911 a_6599_9155.n53 a_6599_9155.n93 0.159189
R2912 a_6599_9155.n53 a_6599_9155.n92 0.216893
R2913 a_6599_9155.n91 a_6599_9155.n92 0.375582
R2914 a_6599_9155.n57 a_6599_9155.n91 0.0957131
R2915 a_6599_9155.n57 a_6599_9155.n90 0.280369
R2916 a_6599_9155.n89 a_6599_9155.n90 0.375582
R2917 a_6599_9155.n61 a_6599_9155.n89 0.0322377
R2918 a_6599_9155.n61 a_6599_9155.n88 0.343844
R2919 a_6599_9155.n65 a_6599_9155.n88 0.343844
R2920 a_6599_9155.n65 a_6599_9155.n87 0.0322377
R2921 a_6599_9155.n86 a_6599_9155.n87 0.375582
R2922 a_6599_9155.n69 a_6599_9155.n86 0.280369
R2923 a_6599_9155.n69 a_6599_9155.n85 0.0957131
R2924 a_6599_9155.n84 a_6599_9155.n85 0.375582
R2925 a_6599_9155.n73 a_6599_9155.n84 0.216893
R2926 a_6599_9155.n73 a_6599_9155.n83 0.159189
R2927 a_6599_9155.n82 a_6599_9155.n83 0.375582
R2928 a_6599_9155.n77 a_6599_9155.n82 0.153418
R2929 a_6599_9155.n77 a_6599_9155.n81 0.222664
R2930 a_6599_9155.n81 a_6599_9155.n97 0.375582
R2931 a_6599_9155.n80 a_6599_9155.n97 0.539943
R2932 a_6599_9155.n96 a_6599_9155.n35 4.01079
R2933 a_6599_9155.n95 a_6599_9155.n34 4.01079
R2934 a_6599_9155.n94 a_6599_9155.n36 4.01079
R2935 a_6599_9155.n93 a_6599_9155.n33 4.01079
R2936 a_6599_9155.n92 a_6599_9155.n37 4.01079
R2937 a_6599_9155.n91 a_6599_9155.n32 4.01079
R2938 a_6599_9155.n90 a_6599_9155.n38 4.01079
R2939 a_6599_9155.n89 a_6599_9155.n31 4.01079
R2940 a_6599_9155.n88 a_6599_9155.n39 4.01079
R2941 a_6599_9155.n87 a_6599_9155.n30 4.01079
R2942 a_6599_9155.n86 a_6599_9155.n40 4.01079
R2943 a_6599_9155.n85 a_6599_9155.n29 4.01079
R2944 a_6599_9155.n84 a_6599_9155.n41 4.01079
R2945 a_6599_9155.n83 a_6599_9155.n28 4.01079
R2946 a_6599_9155.n82 a_6599_9155.n42 4.01079
R2947 a_6599_9155.n9 a_6599_9155.n81 4.01079
R2948 a_6599_9155.t32 a_6599_9155.n80 1.40507
R2949 a_6599_9155.t33 a_6599_9155.n80 1.4008
R2950 a_6599_9155.n78 a_6599_9155.t33 0.00350209
R2951 a_6599_9155.n78 a_6599_9155.t28 0.00349651
R2952 a_6599_9155.n79 a_6599_9155.t29 0.00495865
R2953 a_6599_9155.n27 a_6599_9155.n79 1.40205
R2954 a_6599_9155.n79 a_6599_9155.t32 0.00503714
R2955 a_6599_9155.n27 a_6599_9155.n78 1.40304
R2956 a_6599_9155.t34 a_6599_9155.n76 1.40507
R2957 a_6599_9155.t35 a_6599_9155.n76 1.4008
R2958 a_6599_9155.n74 a_6599_9155.t35 0.00350209
R2959 a_6599_9155.n74 a_6599_9155.t25 0.00349651
R2960 a_6599_9155.n75 a_6599_9155.t26 0.00495865
R2961 a_6599_9155.n25 a_6599_9155.n75 1.40205
R2962 a_6599_9155.n75 a_6599_9155.t34 0.00503714
R2963 a_6599_9155.n25 a_6599_9155.n74 1.40304
R2964 a_6599_9155.t36 a_6599_9155.n72 1.40507
R2965 a_6599_9155.t37 a_6599_9155.n72 1.4008
R2966 a_6599_9155.n70 a_6599_9155.t37 0.00350209
R2967 a_6599_9155.n70 a_6599_9155.t22 0.00349651
R2968 a_6599_9155.n71 a_6599_9155.t23 0.00495865
R2969 a_6599_9155.n23 a_6599_9155.n71 1.40205
R2970 a_6599_9155.n71 a_6599_9155.t36 0.00503714
R2971 a_6599_9155.n23 a_6599_9155.n70 1.40304
R2972 a_6599_9155.t38 a_6599_9155.n68 1.40507
R2973 a_6599_9155.t39 a_6599_9155.n68 1.4008
R2974 a_6599_9155.n66 a_6599_9155.t39 0.00350209
R2975 a_6599_9155.n66 a_6599_9155.t19 0.00349651
R2976 a_6599_9155.n67 a_6599_9155.t20 0.00495865
R2977 a_6599_9155.n21 a_6599_9155.n67 1.40205
R2978 a_6599_9155.n67 a_6599_9155.t38 0.00503714
R2979 a_6599_9155.n21 a_6599_9155.n66 1.40304
R2980 a_6599_9155.t40 a_6599_9155.n64 1.40507
R2981 a_6599_9155.t41 a_6599_9155.n64 1.4008
R2982 a_6599_9155.n62 a_6599_9155.t41 0.00350209
R2983 a_6599_9155.n62 a_6599_9155.t16 0.00349651
R2984 a_6599_9155.n63 a_6599_9155.t17 0.00495865
R2985 a_6599_9155.n19 a_6599_9155.n63 1.40205
R2986 a_6599_9155.n63 a_6599_9155.t40 0.00503714
R2987 a_6599_9155.n19 a_6599_9155.n62 1.40304
R2988 a_6599_9155.t42 a_6599_9155.n60 1.40507
R2989 a_6599_9155.t43 a_6599_9155.n60 1.4008
R2990 a_6599_9155.n58 a_6599_9155.t43 0.00350209
R2991 a_6599_9155.n58 a_6599_9155.t13 0.00349651
R2992 a_6599_9155.n59 a_6599_9155.t14 0.00495865
R2993 a_6599_9155.n17 a_6599_9155.n59 1.40205
R2994 a_6599_9155.n59 a_6599_9155.t42 0.00503714
R2995 a_6599_9155.n17 a_6599_9155.n58 1.40304
R2996 a_6599_9155.t44 a_6599_9155.n56 1.40507
R2997 a_6599_9155.t45 a_6599_9155.n56 1.4008
R2998 a_6599_9155.n54 a_6599_9155.t45 0.00350209
R2999 a_6599_9155.n54 a_6599_9155.t10 0.00349651
R3000 a_6599_9155.n55 a_6599_9155.t11 0.00495865
R3001 a_6599_9155.n15 a_6599_9155.n55 1.40205
R3002 a_6599_9155.n55 a_6599_9155.t44 0.00503714
R3003 a_6599_9155.n15 a_6599_9155.n54 1.40304
R3004 a_6599_9155.t46 a_6599_9155.n52 1.40507
R3005 a_6599_9155.t47 a_6599_9155.n52 1.4008
R3006 a_6599_9155.n50 a_6599_9155.t47 0.00350209
R3007 a_6599_9155.n50 a_6599_9155.t7 0.00349651
R3008 a_6599_9155.n51 a_6599_9155.t8 0.00495865
R3009 a_6599_9155.n13 a_6599_9155.n51 1.40205
R3010 a_6599_9155.n51 a_6599_9155.t46 0.00503714
R3011 a_6599_9155.n13 a_6599_9155.n50 1.40304
R3012 a_6599_9155.t48 a_6599_9155.n48 1.40507
R3013 a_6599_9155.t49 a_6599_9155.n48 1.4008
R3014 a_6599_9155.n46 a_6599_9155.t49 0.00350209
R3015 a_6599_9155.n46 a_6599_9155.t4 0.00349651
R3016 a_6599_9155.n47 a_6599_9155.t5 0.00495865
R3017 a_6599_9155.n11 a_6599_9155.n47 1.40205
R3018 a_6599_9155.n47 a_6599_9155.t48 0.00503714
R3019 a_6599_9155.n11 a_6599_9155.n46 1.40304
R3020 a_6599_9155.t50 a_6599_9155.n45 1.40507
R3021 a_6599_9155.t51 a_6599_9155.n45 1.4008
R3022 a_6599_9155.n43 a_6599_9155.t51 0.00350209
R3023 a_6599_9155.n43 a_6599_9155.t0 0.00349651
R3024 a_6599_9155.n44 a_6599_9155.t2 0.00495865
R3025 a_6599_9155.n10 a_6599_9155.n44 1.40205
R3026 a_6599_9155.n44 a_6599_9155.t50 0.00503714
R3027 a_6599_9155.n10 a_6599_9155.n43 1.40304
R3028 a_6599_9155.n34 a_6599_9155.n2 1.38109
R3029 a_6599_9155.n33 a_6599_9155.n3 1.38109
R3030 a_6599_9155.n32 a_6599_9155.n4 1.38109
R3031 a_6599_9155.n31 a_6599_9155.n5 1.38109
R3032 a_6599_9155.n30 a_6599_9155.n6 1.38109
R3033 a_6599_9155.n29 a_6599_9155.n7 1.38109
R3034 a_6599_9155.n28 a_6599_9155.n8 1.38109
R3035 a_6599_9155.n0 a_6599_9155.n99 2.37836
C4 DN VSS 2.83799f
C5 VCP VSS 2.72202f
C6 UP VSS 1.23759f
C7 VBGR VSS 2.665f
C8 VDD VSS 47.81829f
C9 a_6599_9155.t30 VSS 0.56655f $ **FLOATING
C10 a_6599_9155.n0 VSS 0.24873f $ **FLOATING
C11 a_6599_9155.n1 VSS 0.17458f $ **FLOATING
C12 a_6599_9155.n2 VSS 0.80629f $ **FLOATING
C13 a_6599_9155.n3 VSS 0.90842f $ **FLOATING
C14 a_6599_9155.n4 VSS 0.90842f $ **FLOATING
C15 a_6599_9155.n5 VSS 0.90842f $ **FLOATING
C16 a_6599_9155.n6 VSS 0.90842f $ **FLOATING
C17 a_6599_9155.n7 VSS 0.90842f $ **FLOATING
C18 a_6599_9155.n8 VSS 0.90842f $ **FLOATING
C19 a_6599_9155.n9 VSS 0.77352f $ **FLOATING
C20 a_6599_9155.n10 VSS 0.39638f $ **FLOATING
C21 a_6599_9155.n11 VSS 0.36169f $ **FLOATING
C22 a_6599_9155.n12 VSS 0.11827f $ **FLOATING
C23 a_6599_9155.n13 VSS 0.36169f $ **FLOATING
C24 a_6599_9155.n14 VSS 0.11827f $ **FLOATING
C25 a_6599_9155.n15 VSS 0.36169f $ **FLOATING
C26 a_6599_9155.n16 VSS 0.11827f $ **FLOATING
C27 a_6599_9155.n17 VSS 0.36169f $ **FLOATING
C28 a_6599_9155.n18 VSS 0.11827f $ **FLOATING
C29 a_6599_9155.n19 VSS 0.36169f $ **FLOATING
C30 a_6599_9155.n20 VSS 0.11827f $ **FLOATING
C31 a_6599_9155.n21 VSS 0.36169f $ **FLOATING
C32 a_6599_9155.n22 VSS 0.11827f $ **FLOATING
C33 a_6599_9155.n23 VSS 0.36169f $ **FLOATING
C34 a_6599_9155.n24 VSS 0.11827f $ **FLOATING
C35 a_6599_9155.n25 VSS 0.36169f $ **FLOATING
C36 a_6599_9155.n26 VSS 0.11827f $ **FLOATING
C37 a_6599_9155.n27 VSS 0.39638f $ **FLOATING
C38 a_6599_9155.n28 VSS 0.75351f $ **FLOATING
C39 a_6599_9155.n29 VSS 0.73349f $ **FLOATING
C40 a_6599_9155.n30 VSS 0.71348f $ **FLOATING
C41 a_6599_9155.n31 VSS 0.71348f $ **FLOATING
C42 a_6599_9155.n32 VSS 0.73349f $ **FLOATING
C43 a_6599_9155.n33 VSS 0.75351f $ **FLOATING
C44 a_6599_9155.n34 VSS 0.77352f $ **FLOATING
C45 a_6599_9155.n35 VSS 0.4709f $ **FLOATING
C46 a_6599_9155.n36 VSS 0.31636f $ **FLOATING
C47 a_6599_9155.n37 VSS 0.33637f $ **FLOATING
C48 a_6599_9155.n38 VSS 0.35639f $ **FLOATING
C49 a_6599_9155.n39 VSS 0.36639f $ **FLOATING
C50 a_6599_9155.n40 VSS 0.35639f $ **FLOATING
C51 a_6599_9155.n41 VSS 0.33637f $ **FLOATING
C52 a_6599_9155.n42 VSS 0.31636f $ **FLOATING
C53 a_6599_9155.n43 VSS 0.01299f $ **FLOATING
C54 a_6599_9155.t51 VSS 5.7448f $ **FLOATING
C55 a_6599_9155.t50 VSS 5.7439f $ **FLOATING
C56 a_6599_9155.t0 VSS 2.68753f $ **FLOATING
C57 a_6599_9155.n44 VSS 0.01345f $ **FLOATING
C58 a_6599_9155.t2 VSS 2.68822f $ **FLOATING
C59 a_6599_9155.n45 VSS 0.39629f $ **FLOATING
C60 a_6599_9155.n46 VSS 0.01299f $ **FLOATING
C61 a_6599_9155.t49 VSS 5.7448f $ **FLOATING
C62 a_6599_9155.t48 VSS 5.7439f $ **FLOATING
C63 a_6599_9155.t4 VSS 2.68753f $ **FLOATING
C64 a_6599_9155.n47 VSS 0.01345f $ **FLOATING
C65 a_6599_9155.t5 VSS 2.68822f $ **FLOATING
C66 a_6599_9155.n48 VSS 0.36159f $ **FLOATING
C67 a_6599_9155.n49 VSS 0.11827f $ **FLOATING
C68 a_6599_9155.n50 VSS 0.01299f $ **FLOATING
C69 a_6599_9155.t47 VSS 5.7448f $ **FLOATING
C70 a_6599_9155.t46 VSS 5.7439f $ **FLOATING
C71 a_6599_9155.t7 VSS 2.68753f $ **FLOATING
C72 a_6599_9155.n51 VSS 0.01345f $ **FLOATING
C73 a_6599_9155.t8 VSS 2.68822f $ **FLOATING
C74 a_6599_9155.n52 VSS 0.36159f $ **FLOATING
C75 a_6599_9155.n53 VSS 0.11827f $ **FLOATING
C76 a_6599_9155.n54 VSS 0.01299f $ **FLOATING
C77 a_6599_9155.t45 VSS 5.7448f $ **FLOATING
C78 a_6599_9155.t44 VSS 5.7439f $ **FLOATING
C79 a_6599_9155.t10 VSS 2.68753f $ **FLOATING
C80 a_6599_9155.n55 VSS 0.01345f $ **FLOATING
C81 a_6599_9155.t11 VSS 2.68822f $ **FLOATING
C82 a_6599_9155.n56 VSS 0.36159f $ **FLOATING
C83 a_6599_9155.n57 VSS 0.11827f $ **FLOATING
C84 a_6599_9155.n58 VSS 0.01299f $ **FLOATING
C85 a_6599_9155.t43 VSS 5.7448f $ **FLOATING
C86 a_6599_9155.t42 VSS 5.7439f $ **FLOATING
C87 a_6599_9155.t13 VSS 2.68753f $ **FLOATING
C88 a_6599_9155.n59 VSS 0.01345f $ **FLOATING
C89 a_6599_9155.t14 VSS 2.68822f $ **FLOATING
C90 a_6599_9155.n60 VSS 0.36159f $ **FLOATING
C91 a_6599_9155.n61 VSS 0.11827f $ **FLOATING
C92 a_6599_9155.n62 VSS 0.01299f $ **FLOATING
C93 a_6599_9155.t41 VSS 5.7448f $ **FLOATING
C94 a_6599_9155.t40 VSS 5.7439f $ **FLOATING
C95 a_6599_9155.t16 VSS 2.68753f $ **FLOATING
C96 a_6599_9155.n63 VSS 0.01345f $ **FLOATING
C97 a_6599_9155.t17 VSS 2.68822f $ **FLOATING
C98 a_6599_9155.n64 VSS 0.36159f $ **FLOATING
C99 a_6599_9155.n65 VSS 0.11827f $ **FLOATING
C100 a_6599_9155.n66 VSS 0.01299f $ **FLOATING
C101 a_6599_9155.t39 VSS 5.7448f $ **FLOATING
C102 a_6599_9155.t38 VSS 5.7439f $ **FLOATING
C103 a_6599_9155.t19 VSS 2.68753f $ **FLOATING
C104 a_6599_9155.n67 VSS 0.01345f $ **FLOATING
C105 a_6599_9155.t20 VSS 2.68822f $ **FLOATING
C106 a_6599_9155.n68 VSS 0.36159f $ **FLOATING
C107 a_6599_9155.n69 VSS 0.11827f $ **FLOATING
C108 a_6599_9155.n70 VSS 0.01299f $ **FLOATING
C109 a_6599_9155.t37 VSS 5.7448f $ **FLOATING
C110 a_6599_9155.t36 VSS 5.7439f $ **FLOATING
C111 a_6599_9155.t22 VSS 2.68753f $ **FLOATING
C112 a_6599_9155.n71 VSS 0.01345f $ **FLOATING
C113 a_6599_9155.t23 VSS 2.68822f $ **FLOATING
C114 a_6599_9155.n72 VSS 0.36159f $ **FLOATING
C115 a_6599_9155.n73 VSS 0.11827f $ **FLOATING
C116 a_6599_9155.n74 VSS 0.01299f $ **FLOATING
C117 a_6599_9155.t35 VSS 5.7448f $ **FLOATING
C118 a_6599_9155.t34 VSS 5.7439f $ **FLOATING
C119 a_6599_9155.t25 VSS 2.68753f $ **FLOATING
C120 a_6599_9155.n75 VSS 0.01345f $ **FLOATING
C121 a_6599_9155.t26 VSS 2.68822f $ **FLOATING
C122 a_6599_9155.n76 VSS 0.36159f $ **FLOATING
C123 a_6599_9155.n77 VSS 0.11827f $ **FLOATING
C124 a_6599_9155.n78 VSS 0.01299f $ **FLOATING
C125 a_6599_9155.t33 VSS 5.7448f $ **FLOATING
C126 a_6599_9155.t32 VSS 5.7439f $ **FLOATING
C127 a_6599_9155.t28 VSS 2.68753f $ **FLOATING
C128 a_6599_9155.n79 VSS 0.01345f $ **FLOATING
C129 a_6599_9155.t29 VSS 2.68822f $ **FLOATING
C130 a_6599_9155.n80 VSS 0.39629f $ **FLOATING
C131 a_6599_9155.n81 VSS 0.33819f $ **FLOATING
C132 a_6599_9155.n82 VSS 0.31636f $ **FLOATING
C133 a_6599_9155.n83 VSS 0.31818f $ **FLOATING
C134 a_6599_9155.n84 VSS 0.33637f $ **FLOATING
C135 a_6599_9155.n85 VSS 0.29816f $ **FLOATING
C136 a_6599_9155.n86 VSS 0.35639f $ **FLOATING
C137 a_6599_9155.n87 VSS 0.27815f $ **FLOATING
C138 a_6599_9155.n88 VSS 0.36639f $ **FLOATING
C139 a_6599_9155.n89 VSS 0.27815f $ **FLOATING
C140 a_6599_9155.n90 VSS 0.35639f $ **FLOATING
C141 a_6599_9155.n91 VSS 0.29816f $ **FLOATING
C142 a_6599_9155.n92 VSS 0.33637f $ **FLOATING
C143 a_6599_9155.n93 VSS 0.31818f $ **FLOATING
C144 a_6599_9155.n94 VSS 0.31636f $ **FLOATING
C145 a_6599_9155.n95 VSS 0.33819f $ **FLOATING
C146 a_6599_9155.n96 VSS 0.4709f $ **FLOATING
C147 a_6599_9155.n97 VSS 0.4709f $ **FLOATING
C148 a_6599_9155.n98 VSS 0.4709f $ **FLOATING
C149 a_6599_9155.n99 VSS 1.1839f $ **FLOATING
C150 a_6599_9155.t31 VSS 0.61167f $ **FLOATING
C151 a_6599_9155.n100 VSS 1.95891f $ **FLOATING
C152 a_6599_9155.t1 VSS 0.56675f $ **FLOATING
C153 a_6599_9155.t3 VSS 0.59549f $ **FLOATING
C154 a_6599_9155.n101 VSS 0.19972f $ **FLOATING
C155 a_6599_9155.t6 VSS 0.59549f $ **FLOATING
C156 a_6599_9155.n102 VSS 0.21836f $ **FLOATING
C157 a_6599_9155.t9 VSS 0.59549f $ **FLOATING
C158 a_6599_9155.n103 VSS 0.21836f $ **FLOATING
C159 a_6599_9155.t12 VSS 0.59549f $ **FLOATING
C160 a_6599_9155.n104 VSS 0.21836f $ **FLOATING
C161 a_6599_9155.t15 VSS 0.59549f $ **FLOATING
C162 a_6599_9155.n105 VSS 0.21836f $ **FLOATING
C163 a_6599_9155.t18 VSS 0.59549f $ **FLOATING
C164 a_6599_9155.n106 VSS 0.21836f $ **FLOATING
C165 a_6599_9155.t21 VSS 0.59549f $ **FLOATING
C166 a_6599_9155.n107 VSS 0.21836f $ **FLOATING
C167 a_6599_9155.t24 VSS 0.59549f $ **FLOATING
C168 a_6599_9155.n108 VSS 0.21836f $ **FLOATING
C169 a_6599_9155.t27 VSS 0.59549f $ **FLOATING
C170 a_6599_9155.n109 VSS 0.19972f $ **FLOATING
C171 a_7067_9155.t11 VSS 1.17702f $ **FLOATING
C172 a_7067_9155.n0 VSS 0.44414f $ **FLOATING
C173 a_7067_9155.n1 VSS 3.97451f $ **FLOATING
C174 a_7067_9155.t1 VSS 1.69154f $ **FLOATING
C175 a_7067_9155.n2 VSS 2.24453f $ **FLOATING
C176 a_7067_9155.t7 VSS 1.69154f $ **FLOATING
C177 a_7067_9155.n3 VSS 0.61972f $ **FLOATING
C178 a_7067_9155.t6 VSS 1.69154f $ **FLOATING
C179 a_7067_9155.n4 VSS 0.61972f $ **FLOATING
C180 a_7067_9155.t8 VSS 1.69154f $ **FLOATING
C181 a_7067_9155.n5 VSS 0.61972f $ **FLOATING
C182 a_7067_9155.t0 VSS 1.69154f $ **FLOATING
C183 a_7067_9155.n6 VSS 0.61972f $ **FLOATING
C184 a_7067_9155.t2 VSS 1.69154f $ **FLOATING
C185 a_7067_9155.n7 VSS 0.61972f $ **FLOATING
C186 a_7067_9155.t9 VSS 1.69154f $ **FLOATING
C187 a_7067_9155.n8 VSS 0.61972f $ **FLOATING
C188 a_7067_9155.t3 VSS 1.69154f $ **FLOATING
C189 a_7067_9155.n9 VSS 0.61972f $ **FLOATING
C190 a_7067_9155.t4 VSS 1.69154f $ **FLOATING
C191 a_7067_9155.n10 VSS 0.9121f $ **FLOATING
C192 a_7067_9155.t5 VSS 2.026f $ **FLOATING
C193 a_7067_9155.t12 VSS 1.13175f $ **FLOATING
C194 a_7067_9155.t10 VSS 1.17701f $ **FLOATING
C195 a_7067_9155.n11 VSS 1.53934f $ **FLOATING
C196 a_7067_9155.n12 VSS 0.56441f $ **FLOATING
C197 a_7067_7119.t12 VSS 1.11458f $ **FLOATING
C198 a_7067_7119.n0 VSS 0.41879f $ **FLOATING
C199 a_7067_7119.n1 VSS 3.46429f $ **FLOATING
C200 a_7067_7119.t0 VSS 1.66598f $ **FLOATING
C201 a_7067_7119.n2 VSS 2.14485f $ **FLOATING
C202 a_7067_7119.t4 VSS 1.66598f $ **FLOATING
C203 a_7067_7119.n3 VSS 0.61036f $ **FLOATING
C204 a_7067_7119.t6 VSS 1.66598f $ **FLOATING
C205 a_7067_7119.n4 VSS 0.61036f $ **FLOATING
C206 a_7067_7119.t5 VSS 1.66598f $ **FLOATING
C207 a_7067_7119.n5 VSS 0.61036f $ **FLOATING
C208 a_7067_7119.t2 VSS 1.66598f $ **FLOATING
C209 a_7067_7119.n6 VSS 0.61036f $ **FLOATING
C210 a_7067_7119.t9 VSS 1.66598f $ **FLOATING
C211 a_7067_7119.n7 VSS 0.61036f $ **FLOATING
C212 a_7067_7119.t7 VSS 1.66598f $ **FLOATING
C213 a_7067_7119.n8 VSS 0.61036f $ **FLOATING
C214 a_7067_7119.t3 VSS 1.66598f $ **FLOATING
C215 a_7067_7119.n9 VSS 0.61036f $ **FLOATING
C216 a_7067_7119.t8 VSS 1.66598f $ **FLOATING
C217 a_7067_7119.n10 VSS 0.89832f $ **FLOATING
C218 a_7067_7119.t1 VSS 1.99538f $ **FLOATING
C219 a_7067_7119.t11 VSS 1.15938f $ **FLOATING
C220 a_7067_7119.n11 VSS 0.55574f $ **FLOATING
C221 a_7067_7119.t10 VSS 1.15922f $ **FLOATING
C222 a_7067_7119.n12 VSS 1.33194f $ **FLOATING
C223 a_7067_5083.t12 VSS 0.94004f $ **FLOATING
C224 a_7067_5083.n0 VSS 0.82059f $ **FLOATING
C225 a_7067_5083.n1 VSS 2.41249f $ **FLOATING
C226 a_7067_5083.t0 VSS 1.351f $ **FLOATING
C227 a_7067_5083.n2 VSS 1.68509f $ **FLOATING
C228 a_7067_5083.t4 VSS 1.351f $ **FLOATING
C229 a_7067_5083.n3 VSS 0.49496f $ **FLOATING
C230 a_7067_5083.t6 VSS 1.351f $ **FLOATING
C231 a_7067_5083.n4 VSS 0.49496f $ **FLOATING
C232 a_7067_5083.t5 VSS 1.351f $ **FLOATING
C233 a_7067_5083.n5 VSS 0.49496f $ **FLOATING
C234 a_7067_5083.t2 VSS 1.351f $ **FLOATING
C235 a_7067_5083.n6 VSS 0.49496f $ **FLOATING
C236 a_7067_5083.t9 VSS 1.351f $ **FLOATING
C237 a_7067_5083.n7 VSS 0.49496f $ **FLOATING
C238 a_7067_5083.t7 VSS 1.351f $ **FLOATING
C239 a_7067_5083.n8 VSS 0.49496f $ **FLOATING
C240 a_7067_5083.t3 VSS 1.351f $ **FLOATING
C241 a_7067_5083.n9 VSS 0.49496f $ **FLOATING
C242 a_7067_5083.t8 VSS 1.351f $ **FLOATING
C243 a_7067_5083.n10 VSS 0.72847f $ **FLOATING
C244 a_7067_5083.t1 VSS 1.61812f $ **FLOATING
C245 a_7067_5083.t11 VSS 0.94016f $ **FLOATING
C246 a_7067_5083.n11 VSS 0.45068f $ **FLOATING
C247 a_7067_5083.t10 VSS 0.90377f $ **FLOATING
C248 a_7067_5083.n12 VSS 0.46739f $ **FLOATING
C249 a_6599_7119.t18 VSS 0.5282f $ **FLOATING
C250 a_6599_7119.n0 VSS 0.13579f $ **FLOATING
C251 a_6599_7119.n1 VSS 0.20742f $ **FLOATING
C252 a_6599_7119.n2 VSS 0.10997f $ **FLOATING
C253 a_6599_7119.n3 VSS 0.07955f $ **FLOATING
C254 a_6599_7119.n4 VSS 0.13259f $ **FLOATING
C255 a_6599_7119.n5 VSS 0.11172f $ **FLOATING
C256 a_6599_7119.t16 VSS 2.81198f $ **FLOATING
C257 a_6599_7119.t17 VSS 2.83379f $ **FLOATING
C258 a_6599_7119.t11 VSS 2.83372f $ **FLOATING
C259 a_6599_7119.t13 VSS 2.81199f $ **FLOATING
C260 a_6599_7119.n6 VSS 0.11174f $ **FLOATING
C261 a_6599_7119.t14 VSS 2.82795f $ **FLOATING
C262 a_6599_7119.n7 VSS 0.06983f $ **FLOATING
C263 a_6599_7119.n8 VSS 0.10987f $ **FLOATING
C264 a_6599_7119.n9 VSS 0.07955f $ **FLOATING
C265 a_6599_7119.n10 VSS 0.10997f $ **FLOATING
C266 a_6599_7119.n11 VSS 0.12125f $ **FLOATING
C267 a_6599_7119.n12 VSS 0.17102f $ **FLOATING
C268 a_6599_7119.n13 VSS 0.11172f $ **FLOATING
C269 a_6599_7119.t20 VSS 2.81198f $ **FLOATING
C270 a_6599_7119.t19 VSS 2.83379f $ **FLOATING
C271 a_6599_7119.t23 VSS 2.83372f $ **FLOATING
C272 a_6599_7119.t22 VSS 2.81199f $ **FLOATING
C273 a_6599_7119.n14 VSS 0.11174f $ **FLOATING
C274 a_6599_7119.t21 VSS 2.82795f $ **FLOATING
C275 a_6599_7119.n15 VSS 0.06983f $ **FLOATING
C276 a_6599_7119.n16 VSS 0.17695f $ **FLOATING
C277 a_6599_7119.t1 VSS 0.53101f $ **FLOATING
C278 a_6599_7119.t9 VSS 0.55796f $ **FLOATING
C279 a_6599_7119.n17 VSS 0.18713f $ **FLOATING
C280 a_6599_7119.t6 VSS 0.55796f $ **FLOATING
C281 a_6599_7119.n18 VSS 0.2046f $ **FLOATING
C282 a_6599_7119.t3 VSS 0.55796f $ **FLOATING
C283 a_6599_7119.n19 VSS 0.2046f $ **FLOATING
C284 a_6599_7119.t10 VSS 0.55796f $ **FLOATING
C285 a_6599_7119.n20 VSS 0.2046f $ **FLOATING
C286 a_6599_7119.t5 VSS 0.55796f $ **FLOATING
C287 a_6599_7119.n21 VSS 0.2046f $ **FLOATING
C288 a_6599_7119.t2 VSS 0.55796f $ **FLOATING
C289 a_6599_7119.n22 VSS 0.2046f $ **FLOATING
C290 a_6599_7119.t8 VSS 0.55796f $ **FLOATING
C291 a_6599_7119.n23 VSS 0.2046f $ **FLOATING
C292 a_6599_7119.t4 VSS 0.55796f $ **FLOATING
C293 a_6599_7119.n24 VSS 0.2046f $ **FLOATING
C294 a_6599_7119.t7 VSS 0.55796f $ **FLOATING
C295 a_6599_7119.n25 VSS 0.26867f $ **FLOATING
C296 a_6599_7119.t0 VSS 0.58525f $ **FLOATING
C297 a_6599_7119.n26 VSS 0.46378f $ **FLOATING
C298 a_6599_7119.n27 VSS 0.64868f $ **FLOATING
C299 a_6599_7119.t12 VSS 0.5551f $ **FLOATING
C300 a_6599_7119.n28 VSS 0.1927f $ **FLOATING
C301 a_6599_7119.t15 VSS 0.5551f $ **FLOATING
C302 a_6599_7119.n29 VSS 0.18697f $ **FLOATING
C303 a_6684_2433.t3 VSS 1.95821f $ **FLOATING
C304 a_6684_2433.t1 VSS 0.8442f $ **FLOATING
C305 a_6684_2433.n0 VSS 0.92234f $ **FLOATING
C306 a_6684_2433.t2 VSS 0.8442f $ **FLOATING
C307 a_6684_2433.n1 VSS 0.40761f $ **FLOATING
C308 a_6684_2433.t0 VSS 0.88603f $ **FLOATING
C309 a_9470_2433.t3 VSS 1.99794f $ **FLOATING
C310 a_9470_2433.t2 VSS 0.83198f $ **FLOATING
C311 a_9470_2433.n0 VSS 0.98204f $ **FLOATING
C312 a_9470_2433.t0 VSS 0.83198f $ **FLOATING
C313 a_9470_2433.n1 VSS 0.40171f $ **FLOATING
C314 a_9470_2433.t1 VSS 0.87321f $ **FLOATING
C315 VDD.n0 VSS 0.03564f $ **FLOATING
C316 VDD.n1 VSS 0.16398f $ **FLOATING
C317 VDD.n2 VSS 0.04624f $ **FLOATING
C318 VDD.n3 VSS 0.04624f $ **FLOATING
C319 VDD.n5 VSS 0.04624f $ **FLOATING
C320 VDD.n6 VSS 0.04624f $ **FLOATING
C321 VDD.n7 VSS 0.0266f $ **FLOATING
C322 VDD.n9 VSS 0.14033f $ **FLOATING
C323 VDD.n10 VSS 0.03648f $ **FLOATING
C324 VDD.n11 VSS 0.04624f $ **FLOATING
C325 VDD.n12 VSS 0.04624f $ **FLOATING
C326 VDD.n14 VSS 0.03734f $ **FLOATING
C327 VDD.n15 VSS 0.04624f $ **FLOATING
C328 VDD.n16 VSS 0.18578f $ **FLOATING
C329 VDD.t6 VSS 0.1872f $ **FLOATING
C330 VDD.n17 VSS 0.08975f $ **FLOATING
C331 VDD.n19 VSS 0.18429f $ **FLOATING
C332 VDD.n20 VSS 0.01238f $ **FLOATING
C333 VDD.n34 VSS 0.02113f $ **FLOATING
C334 VDD.n49 VSS 0.18407f $ **FLOATING
C335 VDD.n54 VSS 0.12305f $ **FLOATING
C336 VDD.n58 VSS 0.01179f $ **FLOATING
C337 VDD.n59 VSS 0.01179f $ **FLOATING
C338 VDD.n60 VSS 0.01179f $ **FLOATING
C339 VDD.n61 VSS 0.07278f $ **FLOATING
C340 VDD.t14 VSS 0.17124f $ **FLOATING
C341 VDD.t15 VSS 0.1872f $ **FLOATING
C342 VDD.n62 VSS 0.08975f $ **FLOATING
C343 VDD.n63 VSS 0.25707f $ **FLOATING
C344 VDD.n64 VSS 0.07236f $ **FLOATING
C345 VDD.n65 VSS 0.01179f $ **FLOATING
C346 VDD.n66 VSS 0.01179f $ **FLOATING
C347 VDD.n67 VSS 0.01179f $ **FLOATING
C348 VDD.t20 VSS 0.1872f $ **FLOATING
C349 VDD.t22 VSS 0.1872f $ **FLOATING
C350 VDD.n68 VSS 0.08227f $ **FLOATING
C351 VDD.t24 VSS 0.13562f $ **FLOATING
C352 VDD.n70 VSS 0.01238f $ **FLOATING
C353 VDD.n71 VSS 0.02841f $ **FLOATING
C354 VDD.n72 VSS 0.01496f $ **FLOATING
C355 VDD.n73 VSS 0.01186f $ **FLOATING
C356 VDD.n74 VSS 0.01238f $ **FLOATING
C357 VDD.n75 VSS 0.01186f $ **FLOATING
C358 VDD.n77 VSS 0.01572f $ **FLOATING
C359 VDD.n78 VSS 0.01186f $ **FLOATING
C360 VDD.n79 VSS 0.01582f $ **FLOATING
C361 VDD.n80 VSS 0.01186f $ **FLOATING
C362 VDD.n82 VSS 0.01238f $ **FLOATING
C363 VDD.n83 VSS 0.01186f $ **FLOATING
C364 VDD.n84 VSS 0.01186f $ **FLOATING
C365 VDD.n85 VSS 0.01268f $ **FLOATING
C366 VDD.n86 VSS 0.01592f $ **FLOATING
C367 VDD.n87 VSS 0.01186f $ **FLOATING
C368 VDD.n88 VSS 0.01582f $ **FLOATING
C369 VDD.n89 VSS 0.01186f $ **FLOATING
C370 VDD.n91 VSS 0.01238f $ **FLOATING
C371 VDD.n92 VSS 0.01186f $ **FLOATING
C372 VDD.n93 VSS 0.01238f $ **FLOATING
C373 VDD.n94 VSS 0.01186f $ **FLOATING
C374 VDD.n96 VSS 0.01238f $ **FLOATING
C375 VDD.n97 VSS 0.01186f $ **FLOATING
C376 VDD.n98 VSS 0.01238f $ **FLOATING
C377 VDD.n99 VSS 0.01186f $ **FLOATING
C378 VDD.n101 VSS 0.01238f $ **FLOATING
C379 VDD.n102 VSS 0.01186f $ **FLOATING
C380 VDD.n103 VSS 0.01238f $ **FLOATING
C381 VDD.n104 VSS 0.01186f $ **FLOATING
C382 VDD.n106 VSS 0.02089f $ **FLOATING
C383 VDD.n107 VSS 0.11956f $ **FLOATING
C384 VDD.n108 VSS 0.08975f $ **FLOATING
C385 VDD.n109 VSS 0.07292f $ **FLOATING
C386 VDD.n110 VSS 0.0185f $ **FLOATING
C387 VDD.n111 VSS 0.08352f $ **FLOATING
C388 VDD.n112 VSS 0.02091f $ **FLOATING
C389 VDD.n113 VSS 0.0133f $ **FLOATING
C390 VDD.n114 VSS 0.0133f $ **FLOATING
C391 VDD.n115 VSS 0.0133f $ **FLOATING
C392 VDD.n116 VSS 0.02105f $ **FLOATING
C393 VDD.t2 VSS 0.1872f $ **FLOATING
C394 VDD.n117 VSS 0.07292f $ **FLOATING
C395 VDD.n118 VSS 0.01864f $ **FLOATING
C396 VDD.n119 VSS 0.18578f $ **FLOATING
C397 VDD.n120 VSS 0.18578f $ **FLOATING
C398 VDD.n121 VSS 0.03367f $ **FLOATING
C399 VDD.n122 VSS 0.04091f $ **FLOATING
C400 VDD.n123 VSS 0.01249f $ **FLOATING
C401 VDD.n124 VSS 0.0133f $ **FLOATING
C402 VDD.n125 VSS 0.0133f $ **FLOATING
C403 VDD.n126 VSS 0.0133f $ **FLOATING
C404 VDD.t17 VSS 0.1872f $ **FLOATING
C405 VDD.n127 VSS 0.07292f $ **FLOATING
C406 VDD.n128 VSS 0.01864f $ **FLOATING
C407 VDD.n129 VSS 0.02105f $ **FLOATING
C408 VDD.n130 VSS 0.08318f $ **FLOATING
C409 VDD.n247 VSS 0.01238f $ **FLOATING
C410 VDD.n248 VSS 0.01186f $ **FLOATING
C411 VDD.n249 VSS 0.01238f $ **FLOATING
C412 VDD.n250 VSS 0.01186f $ **FLOATING
C413 VDD.n251 VSS 0.01186f $ **FLOATING
C414 VDD.n253 VSS 0.01238f $ **FLOATING
C415 VDD.n254 VSS 0.01238f $ **FLOATING
C416 VDD.n255 VSS 0.01186f $ **FLOATING
C417 VDD.n256 VSS 0.01186f $ **FLOATING
C418 VDD.n258 VSS 0.01572f $ **FLOATING
C419 VDD.n259 VSS 0.01238f $ **FLOATING
C420 VDD.n260 VSS 0.01186f $ **FLOATING
C421 VDD.n261 VSS 0.01186f $ **FLOATING
C422 VDD.n264 VSS 0.01572f $ **FLOATING
C423 VDD.n265 VSS 0.01582f $ **FLOATING
C424 VDD.n266 VSS 0.01186f $ **FLOATING
C425 VDD.n267 VSS 0.01186f $ **FLOATING
C426 VDD.n268 VSS 0.01258f $ **FLOATING
C427 VDD.n269 VSS 0.01268f $ **FLOATING
C428 VDD.n270 VSS 0.01186f $ **FLOATING
C429 VDD.n271 VSS 0.01186f $ **FLOATING
C430 VDD.n273 VSS 0.01238f $ **FLOATING
C431 VDD.n274 VSS 0.01582f $ **FLOATING
C432 VDD.n275 VSS 0.01186f $ **FLOATING
C433 VDD.n276 VSS 0.01186f $ **FLOATING
C434 VDD.n277 VSS 0.01238f $ **FLOATING
C435 VDD.n278 VSS 0.01186f $ **FLOATING
C436 VDD.t26 VSS 0.13562f $ **FLOATING
C437 VDD.n280 VSS 0.01496f $ **FLOATING
C438 VDD.n281 VSS 0.02747f $ **FLOATING
C439 VDD.n282 VSS 0.01053f $ **FLOATING
C440 VDD.n284 VSS 0.0102f $ **FLOATING
C441 VDD.n285 VSS 0.01001f $ **FLOATING
C442 VDD.n286 VSS 0.0101f $ **FLOATING
C443 VDD.n287 VSS 0.0101f $ **FLOATING
C444 VDD.n288 VSS 0.01001f $ **FLOATING
C445 VDD.n289 VSS 0.03756f $ **FLOATING
C446 VDD.t4 VSS 19.7401f $ **FLOATING
C447 VDD.n303 VSS 0.01036f $ **FLOATING
C448 VDD.n305 VSS 0.01021f $ **FLOATING
C449 VDD.n306 VSS 0.03802f $ **FLOATING
C450 VDD.n307 VSS 0.03802f $ **FLOATING
C451 VDD.n308 VSS 0.03802f $ **FLOATING
C452 VDD.n309 VSS 0.03802f $ **FLOATING
C453 VDD.n312 VSS 0.01054f $ **FLOATING
C454 VDD.n315 VSS 1.9925f $ **FLOATING
C455 VDD.n316 VSS 1.9925f $ **FLOATING
C456 VDD.t11 VSS 1.9925f $ **FLOATING
C457 VDD.t25 VSS 1.9925f $ **FLOATING
C458 VDD.n317 VSS 1.9925f $ **FLOATING
C459 VDD.t8 VSS 1.9925f $ **FLOATING
C460 VDD.t5 VSS 1.9925f $ **FLOATING
C461 VDD.n318 VSS 1.9925f $ **FLOATING
C462 VDD.n319 VSS 1.9925f $ **FLOATING
C463 VDD.t10 VSS 1.9925f $ **FLOATING
C464 VDD.t27 VSS 1.9925f $ **FLOATING
C465 VDD.n320 VSS 1.9925f $ **FLOATING
C466 VDD.t12 VSS 1.9925f $ **FLOATING
C467 VDD.t16 VSS 1.9925f $ **FLOATING
C468 VDD.n321 VSS 1.9925f $ **FLOATING
C469 VDD.n322 VSS 1.9925f $ **FLOATING
C470 VDD.t13 VSS 1.9925f $ **FLOATING
C471 VDD.t18 VSS 1.9925f $ **FLOATING
C472 VDD.n323 VSS 1.9925f $ **FLOATING
C473 VDD.t7 VSS 1.9925f $ **FLOATING
C474 VDD.n324 VSS 1.9925f $ **FLOATING
C475 VDD.n325 VSS 1.9925f $ **FLOATING
C476 VDD.n326 VSS 1.9925f $ **FLOATING
C477 VDD.t9 VSS 1.9925f $ **FLOATING
C478 VDD.n327 VSS 2.93015f $ **FLOATING
C479 VDD.n328 VSS 1.9925f $ **FLOATING
C480 VDD.t0 VSS 2.98875f $ **FLOATING
C481 VDD.n329 VSS 1.9925f $ **FLOATING
C482 VDD.n330 VSS 1.9925f $ **FLOATING
C483 VDD.n332 VSS 0.02727f $ **FLOATING
C484 VDD.n333 VSS 0.0101f $ **FLOATING
C485 VDD.n334 VSS 0.0101f $ **FLOATING
C486 VDD.n335 VSS 0.01374f $ **FLOATING
C487 VDD.n365 VSS 0.01374f $ **FLOATING
C488 VDD.n367 VSS 0.01001f $ **FLOATING
C489 VDD.n376 VSS 0.01001f $ **FLOATING
C490 VDD.n379 VSS 0.01001f $ **FLOATING
C491 VDD.n380 VSS 0.0102f $ **FLOATING
C492 VDD.n383 VSS 0.0102f $ **FLOATING
C493 VDD.n384 VSS 0.01046f $ **FLOATING
C494 VDD.n396 VSS 0.0101f $ **FLOATING
C495 VDD.n399 VSS 0.0101f $ **FLOATING
C496 VDD.n400 VSS 0.01032f $ **FLOATING
C497 VDD.n406 VSS 0.01032f $ **FLOATING
C498 VDD.n408 VSS 0.01046f $ **FLOATING
C499 VDD.n409 VSS 0.01046f $ **FLOATING
C500 VDD.n413 VSS 0.01032f $ **FLOATING
C501 VDD.n414 VSS 0.01064f $ **FLOATING
C502 VDD.n419 VSS 0.0102f $ **FLOATING
C503 VDD.n420 VSS 0.01046f $ **FLOATING
C504 VDD.n421 VSS 0.01001f $ **FLOATING
C505 VDD.n424 VSS 0.0101f $ **FLOATING
C506 VDD.n427 VSS 0.01001f $ **FLOATING
C507 VDD.n428 VSS 0.0102f $ **FLOATING
C508 VDD.n429 VSS 0.0102f $ **FLOATING
C509 VDD.n430 VSS 0.01001f $ **FLOATING
C510 VDD.n432 VSS 0.01032f $ **FLOATING
C511 VDD.n433 VSS 0.0101f $ **FLOATING
C512 VDD.n436 VSS 0.01001f $ **FLOATING
C513 VDD.n437 VSS 0.01046f $ **FLOATING
C514 VDD.n438 VSS 0.0102f $ **FLOATING
C515 VDD.n440 VSS 0.01064f $ **FLOATING
C516 VDD.n441 VSS 0.01032f $ **FLOATING
C517 VDD.n445 VSS 0.01046f $ **FLOATING
C518 VDD.n446 VSS 0.01046f $ **FLOATING
C519 VDD.n450 VSS 0.01032f $ **FLOATING
C520 VDD.n451 VSS 0.01064f $ **FLOATING
C521 VDD.n453 VSS 0.01001f $ **FLOATING
C522 VDD.n456 VSS 0.0101f $ **FLOATING
C523 VDD.n457 VSS 0.01032f $ **FLOATING
C524 VDD.n458 VSS 0.0101f $ **FLOATING
C525 VDD.n461 VSS 0.0102f $ **FLOATING
C526 VDD.n462 VSS 0.01001f $ **FLOATING
C527 VDD.n465 VSS 0.0101f $ **FLOATING
C528 VDD.n466 VSS 0.01032f $ **FLOATING
C529 VDD.n467 VSS 0.0101f $ **FLOATING
C530 VDD.n469 VSS 0.01046f $ **FLOATING
C531 VDD.n470 VSS 0.0102f $ **FLOATING
C532 VDD.n476 VSS 0.01064f $ **FLOATING
C533 VDD.n477 VSS 0.01234f $ **FLOATING
C534 VDD.n478 VSS 0.01264f $ **FLOATING
C535 VDD.n479 VSS 0.01046f $ **FLOATING
C536 VDD.n480 VSS 0.0102f $ **FLOATING
C537 VDD.n482 VSS 0.01032f $ **FLOATING
C538 VDD.n483 VSS 0.01032f $ **FLOATING
C539 VDD.n487 VSS 0.0102f $ **FLOATING
C540 VDD.n488 VSS 0.01046f $ **FLOATING
C541 VDD.n491 VSS 0.01046f $ **FLOATING
C542 VDD.n494 VSS 0.01032f $ **FLOATING
C543 VDD.n495 VSS 0.01374f $ **FLOATING
C544 VDD.n497 VSS 0.0102f $ **FLOATING
C545 VDD.n499 VSS 0.01001f $ **FLOATING
C546 VDD.n501 VSS 0.0101f $ **FLOATING
C547 VDD.n502 VSS 0.01374f $ **FLOATING
C548 VDD.n503 VSS 0.0101f $ **FLOATING
C549 VDD.n504 VSS 0.01001f $ **FLOATING
C550 VDD.n506 VSS 0.0102f $ **FLOATING
C551 VDD.n509 VSS 0.01374f $ **FLOATING
C552 VDD.n510 VSS 0.01032f $ **FLOATING
C553 VDD.n513 VSS 0.01046f $ **FLOATING
C554 VDD.n516 VSS 0.01374f $ **FLOATING
C555 VDD.n517 VSS 0.01064f $ **FLOATING
C556 VDD.n520 VSS 0.01046f $ **FLOATING
C557 VDD.n521 VSS 0.01374f $ **FLOATING
C558 VDD.n523 VSS 0.01032f $ **FLOATING
C559 VDD.n527 VSS 0.0102f $ **FLOATING
C560 VDD.n528 VSS 0.01374f $ **FLOATING
C561 VDD.n529 VSS 0.01001f $ **FLOATING
C562 VDD.n530 VSS 0.0101f $ **FLOATING
C563 VDD.n532 VSS 0.0101f $ **FLOATING
C564 VDD.n534 VSS 0.01001f $ **FLOATING
C565 VDD.n535 VSS 0.01374f $ **FLOATING
C566 VDD.n536 VSS 0.0102f $ **FLOATING
C567 VDD.n539 VSS 0.01032f $ **FLOATING
C568 VDD.n542 VSS 0.01374f $ **FLOATING
C569 VDD.n543 VSS 0.01046f $ **FLOATING
C570 VDD.n546 VSS 0.01064f $ **FLOATING
C571 VDD.n547 VSS 0.01374f $ **FLOATING
C572 VDD.n549 VSS 0.01046f $ **FLOATING
C573 VDD.n553 VSS 0.01032f $ **FLOATING
C574 VDD.n554 VSS 0.01374f $ **FLOATING
C575 VDD.n556 VSS 0.0102f $ **FLOATING
C576 VDD.n558 VSS 0.01001f $ **FLOATING
C577 VDD.n563 VSS 0.01374f $ **FLOATING
C578 VDD.n567 VSS 0.01032f $ **FLOATING
C579 VDD.n569 VSS 0.01374f $ **FLOATING
C580 VDD.n572 VSS 0.01374f $ **FLOATING
C581 VDD.n576 VSS 0.01064f $ **FLOATING
C582 VDD.n578 VSS 0.01374f $ **FLOATING
C583 VDD.n580 VSS 0.01046f $ **FLOATING
C584 VDD.n584 VSS 0.01374f $ **FLOATING
C585 VDD.n587 VSS 0.01374f $ **FLOATING
C586 VDD.n589 VSS 0.0102f $ **FLOATING
C587 VDD.n591 VSS 0.01001f $ **FLOATING
C588 VDD.n593 VSS 0.01374f $ **FLOATING
C589 VDD.n596 VSS 0.01374f $ **FLOATING
C590 VDD.n598 VSS 0.01001f $ **FLOATING
C591 VDD.n600 VSS 0.0102f $ **FLOATING
C592 VDD.n602 VSS 0.01374f $ **FLOATING
C593 VDD.n605 VSS 0.01374f $ **FLOATING
C594 VDD.n609 VSS 0.01046f $ **FLOATING
C595 VDD.n611 VSS 0.01374f $ **FLOATING
C596 VDD.n613 VSS 0.01064f $ **FLOATING
C597 VDD.n617 VSS 0.01374f $ **FLOATING
C598 VDD.n620 VSS 0.01374f $ **FLOATING
C599 VDD.n622 VSS 0.01032f $ **FLOATING
C600 VDD.n626 VSS 0.01374f $ **FLOATING
C601 VDD.n629 VSS 0.01374f $ **FLOATING
C602 VDD.n631 VSS 0.0101f $ **FLOATING
C603 VDD.n633 VSS 0.0101f $ **FLOATING
C604 VDD.n635 VSS 0.01374f $ **FLOATING
C605 VDD.n638 VSS 0.01374f $ **FLOATING
C606 VDD.n642 VSS 0.01032f $ **FLOATING
C607 VDD.n644 VSS 0.01374f $ **FLOATING
C608 VDD.n651 VSS 0.01064f $ **FLOATING
C609 VDD.n653 VSS 0.43205f $ **FLOATING
C610 VDD.t1 VSS 66.1041f $ **FLOATING
C611 VDD.n656 VSS 0.01374f $ **FLOATING
C612 VDD.n658 VSS 0.10316f $ **FLOATING
C613 VDD.n659 VSS 2.06972f $ **FLOATING
C614 VDD.n660 VSS 2.45122f $ **FLOATING
C615 VDD.n662 VSS 0.0102f $ **FLOATING
C616 VDD.n663 VSS 0.03081f $ **FLOATING
C617 VDD.n664 VSS 0.03164f $ **FLOATING
C618 VDD.n665 VSS 0.02499f $ **FLOATING
C619 VDD.n666 VSS 0.02364f $ **FLOATING
C620 VDD.n667 VSS 0.02364f $ **FLOATING
C621 VDD.n668 VSS 0.02364f $ **FLOATING
C622 VDD.n669 VSS 0.01689f $ **FLOATING
C623 VDD.n670 VSS 0.02365f $ **FLOATING
C624 VDD.n671 VSS 0.01373f $ **FLOATING
C625 VDD.n672 VSS 2.15578f $ **FLOATING
C626 VDD.n674 VSS 0.0826f $ **FLOATING
C627 VDD.n675 VSS 0.02089f $ **FLOATING
C628 VDD.n676 VSS 0.03661f $ **FLOATING
C629 VDD.n677 VSS 0.34536f $ **FLOATING
C630 VDD.n678 VSS 0.42063f $ **FLOATING
C631 VDD.n679 VSS 0.02432f $ **FLOATING
C632 VDD.n680 VSS 0.04406f $ **FLOATING
C633 VDD.n681 VSS 0.01191f $ **FLOATING
C634 VDD.n682 VSS 0.01065f $ **FLOATING
C635 VDD.n683 VSS 0.02015f $ **FLOATING
C636 VDD.n684 VSS 0.03848f $ **FLOATING
C637 VDD.n685 VSS 0.03708f $ **FLOATING
C638 VDD.n686 VSS 1.52065f $ **FLOATING
C639 VDD.n687 VSS 1.52071f $ **FLOATING
C640 VDD.t28 VSS 1.283f $ **FLOATING
C641 VDD.n688 VSS 0.71716f $ **FLOATING
C642 VDD.n690 VSS 0.04624f $ **FLOATING
C643 VDD.n691 VSS 0.04624f $ **FLOATING
C644 VDD.n692 VSS 0.04624f $ **FLOATING
C645 VDD.n695 VSS 0.03734f $ **FLOATING
C646 VDD.n696 VSS 0.02516f $ **FLOATING
C647 VBGR.n0 VSS 0.09031f $ **FLOATING
C648 VBGR.t0 VSS 0.43653f $ **FLOATING
C649 VBGR.n2 VSS 0.01003f $ **FLOATING
C650 VBGR.n3 VSS 0.08851f $ **FLOATING
C651 UP.n0 VSS 0.28668f $ **FLOATING
C652 UP.t0 VSS 3.71016f $ **FLOATING
C653 UP.t4 VSS 3.71016f $ **FLOATING
C654 UP.n1 VSS 0.29666f $ **FLOATING
C655 UP.t3 VSS 3.67359f $ **FLOATING
C656 UP.n2 VSS 0.1873f $ **FLOATING
C657 UP.t2 VSS 3.70037f $ **FLOATING
C658 UP.n3 VSS 0.11706f $ **FLOATING
C659 UP.n4 VSS 0.18728f $ **FLOATING
C660 UP.t1 VSS 3.6736f $ **FLOATING
C661 UP.n5 VSS 0.18418f $ **FLOATING
C662 UP.n6 VSS 0.25356f $ **FLOATING
C663 VCP.t10 VSS 1.32974f $ **FLOATING
C664 VCP.t7 VSS 1.32974f $ **FLOATING
C665 VCP.t4 VSS 1.32974f $ **FLOATING
C666 VCP.t11 VSS 1.32974f $ **FLOATING
C667 VCP.t6 VSS 1.32974f $ **FLOATING
C668 VCP.t3 VSS 1.32974f $ **FLOATING
C669 VCP.t9 VSS 1.32974f $ **FLOATING
C670 VCP.t5 VSS 1.32974f $ **FLOATING
C671 VCP.t8 VSS 1.32974f $ **FLOATING
C672 VCP.t0 VSS 1.3948f $ **FLOATING
C673 VCP.n0 VSS 0.64032f $ **FLOATING
C674 VCP.n1 VSS 0.4876f $ **FLOATING
C675 VCP.n2 VSS 0.4876f $ **FLOATING
C676 VCP.n3 VSS 0.4876f $ **FLOATING
C677 VCP.n4 VSS 0.4876f $ **FLOATING
C678 VCP.n5 VSS 0.4876f $ **FLOATING
C679 VCP.n6 VSS 0.4876f $ **FLOATING
C680 VCP.n7 VSS 0.4876f $ **FLOATING
C681 VCP.n8 VSS 0.44599f $ **FLOATING
C682 VCP.t2 VSS 1.26552f $ **FLOATING
C683 VCP.n9 VSS 0.90305f $ **FLOATING
C684 VCP.t13 VSS 1.25929f $ **FLOATING
C685 VCP.t12 VSS 1.32295f $ **FLOATING
C686 VCP.t1 VSS 1.5856f $ **FLOATING
C687 VCP.n10 VSS 0.67574f $ **FLOATING
C688 VCP.n11 VSS 1.1414f $ **FLOATING
C689 VCP.n12 VSS 4.94023f $ **FLOATING
C690 DN.t0 VSS 0.61935f $ **FLOATING
.ends
