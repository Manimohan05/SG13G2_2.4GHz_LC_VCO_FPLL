* NGSPICE file created from BANDGAP_REF.ext - technology: ihp-sg13g2

.subckt BANDGAP_REF_PEX VDD GND VBGR
X0 VDD.t26 VDD.t25 a_3630_15211# VDD.t17 sg13_lv_pmos ad=1.2376p pd=7.96u as=1.2376p ps=7.96u w=3.64u l=3.7u
X1 a_n7059_10169.t6 a_3822_10479# VDD.t63 VDD.t49 sg13_lv_pmos ad=1.78125p pd=9.755u as=1.78125p ps=9.755u w=9.375u l=2.08u
X2 VDD.t68 GND.t8 cap_cmim l=5u w=5u
X3 a_981_18638# a_n6059_11418# GND.t41 GND.t40 sg13_lv_nmos ad=0.1005p pd=1.34u as=0.1005p ps=1.34u w=0.15u l=10u
X4 VDD.t2 a_n7059_10169.t12 VBGR VDD.t0 sg13_lv_pmos ad=0.38p pd=2.38u as=0.38p ps=2.38u w=2u l=5u
X5 a_n7288_18340# GND.t22 GND.t21 rppd l=38.65u w=0.71u
X6 GND.t37 a_5580_15247# a_n7059_10169.t2 GND.t36 sg13_lv_nmos ad=2.448p pd=15.08u as=1.368p ps=7.58u w=7.2u l=9.75u
X7 a_n6059_10861# a_n7059_10169.t9 VDD.t7 VDD.t0 sg13_lv_pmos ad=0.35625p pd=2.255u as=0.35625p ps=2.255u w=1.875u l=5u
X8 a_n7059_10169.t4 a_3822_10479# VDD.t60 VDD.t49 sg13_lv_pmos ad=1.78125p pd=9.755u as=3.1875p ps=19.43u w=9.375u l=2.08u
X9 a_4707_16560# VDD.t27 VDD.t28 VDD.t17 sg13_lv_pmos ad=1.2376p pd=7.96u as=1.2376p ps=7.96u w=3.64u l=3.7u
X10 VDD.t63 a_3822_10479# a_n7059_10169.t5 VDD.t49 sg13_lv_pmos ad=1.78125p pd=9.755u as=1.78125p ps=9.755u w=9.375u l=2.08u
X11 VDD.t14 a_n7059_10169.t14 VBGR VDD.t0 sg13_lv_pmos ad=0.38p pd=2.38u as=0.38p ps=2.38u w=2u l=5u
X12 VDD.t68 GND.t2 cap_cmim l=5u w=5u
X13 a_3822_10479# a_3822_10479# VDD.t51 VDD.t49 sg13_lv_pmos ad=1.78125p pd=9.755u as=1.78125p ps=9.755u w=9.375u l=2.08u
X14 a_5580_15247# a_3630_15211# GND.t56 GND.t55 sg13_lv_nmos ad=0.2448p pd=2.12u as=0.2448p ps=2.12u w=0.72u l=9.75u
X15 VDD.t68 GND.t4 cap_cmim l=5u w=5u
X16 VDD.t63 a_3822_10479# a_n7059_10169.t6 VDD.t49 sg13_lv_pmos ad=1.78125p pd=9.755u as=1.78125p ps=9.755u w=9.375u l=2.08u
X17 VDD.t59 a_3822_10479# a_4707_16560# VDD.t58 sg13_lv_pmos ad=1.802p pd=11.28u as=1.802p ps=11.28u w=5.3u l=1.95u
X18 GND.t25 a_n6059_10861# a_n6059_11418# GND.t26 sg13_lv_nmos ad=0.33915p pd=2.165u as=0.33915p ps=2.165u w=1.785u l=5u
X19 a_n7289_16017# a_527_16281# GND.t29 rppd l=38.65u w=0.5u
X20 a_3822_10479# a_3822_10479# VDD.t50 VDD.t49 sg13_lv_pmos ad=1.78125p pd=9.755u as=3.1875p ps=19.43u w=9.375u l=2.08u
X21 a_4707_16560# VDD.t21 VDD.t22 VDD.t17 sg13_lv_pmos ad=1.2376p pd=7.96u as=1.2376p ps=7.96u w=3.64u l=3.7u
X22 VDD.t61 a_3822_10479# a_n7059_10169.t4 VDD.t49 sg13_lv_pmos ad=1.78125p pd=9.755u as=1.78125p ps=9.755u w=9.375u l=2.08u
X23 VDD.t51 a_3822_10479# a_3822_10479# VDD.t49 sg13_lv_pmos ad=1.78125p pd=9.755u as=1.78125p ps=9.755u w=9.375u l=2.08u
X24 VDD.t55 a_3822_10479# a_3822_10479# VDD.t49 sg13_lv_pmos ad=1.78125p pd=9.755u as=1.78125p ps=9.755u w=9.375u l=2.08u
X25 a_n6059_11418# a_n7059_10169.t9 VDD.t9 VDD.t0 sg13_lv_pmos ad=0.35625p pd=2.255u as=0.35625p ps=2.255u w=1.875u l=5u
X26 a_n7288_17727# a_528_18033# GND.t21 rppd l=38.65u w=0.71u
X27 a_n6059_10861# a_n7059_10169.t11 VDD.t1 VDD.t0 sg13_lv_pmos ad=0.35625p pd=2.255u as=0.35625p ps=2.255u w=1.875u l=5u
X28 GND.t54 a_n7289_16545# a_n7289_16545# GND.t53 sg13_lv_nmos ad=0.8925p pd=5.93u as=0.49875p ps=3.005u w=2.625u l=5u
X29 a_n7288_17115# a_528_16809# GND.t21 rppd l=38.65u w=0.71u
X30 VDD.t68 GND.t6 cap_cmim l=5u w=5u
X31 a_n7289_16545# a_n7289_16545# GND.t48 GND.t49 sg13_lv_nmos ad=0.49875p pd=3.005u as=0.49875p ps=3.005u w=2.625u l=5u
X32 VDD.t51 a_3822_10479# a_3822_10479# VDD.t49 sg13_lv_pmos ad=1.78125p pd=9.755u as=1.78125p ps=9.755u w=9.375u l=2.08u
X33 a_n7289_15489# a_527_15753# GND.t29 rppd l=38.65u w=0.5u
X34 VDD.t68 GND.t8 cap_cmim l=5u w=5u
X35 a_n7289_16545# a_n7289_16545# GND.t45 GND.t46 sg13_lv_nmos ad=0.49875p pd=3.005u as=0.49875p ps=3.005u w=2.625u l=5u
X36 VDD.t43 a_n7059_10169.t8 a_n6059_10861# VDD.t0 sg13_lv_pmos ad=0.6375p pd=4.43u as=0.35625p ps=2.255u w=1.875u l=5u
X37 a_3630_15211# a_n6059_11418# a_4707_16560# VDD.t17 sg13_lv_pmos ad=1.2376p pd=7.96u as=1.2376p ps=7.96u w=3.64u l=3.7u
X38 a_n7289_15489# a_n6059_10861# GND.t29 rppd l=38.65u w=0.5u
X39 VDD.t68 GND.t0 cap_cmim l=5u w=5u
X40 a_n7059_10169.t7 a_3822_10479# VDD.t63 VDD.t49 sg13_lv_pmos ad=1.78125p pd=9.755u as=1.78125p ps=9.755u w=9.375u l=2.08u
X41 a_n6059_11418# a_n6059_10861# GND.t25 GND.t23 sg13_lv_nmos ad=0.33915p pd=2.165u as=0.33915p ps=2.165u w=1.785u l=5u
X42 a_n7289_16545# a_n7289_16545# GND.t43 GND.t42 sg13_lv_nmos ad=0.49875p pd=3.005u as=0.8925p ps=5.93u w=2.625u l=5u
X43 VDD.t68 GND.t2 cap_cmim l=5u w=5u
X44 a_n6059_11418# a_n7059_10169.t11 VDD.t3 VDD.t0 sg13_lv_pmos ad=0.35625p pd=2.255u as=0.35625p ps=2.255u w=1.875u l=5u
X45 VBGR a_n7059_10169.t9 VDD.t8 VDD.t0 sg13_lv_pmos ad=0.38p pd=2.38u as=0.38p ps=2.38u w=2u l=5u
X46 a_5580_15247# a_n6059_10861# a_4707_16560# VDD.t17 sg13_lv_pmos ad=1.2376p pd=7.96u as=1.2376p ps=7.96u w=3.64u l=3.7u
X47 a_1804_15931# a_981_18638# VDD.t37 VDD.t33 sg13_lv_pmos ad=0.17p pd=1.68u as=0.17p ps=1.68u w=0.5u l=1u
X48 GND.t59 a_527_13669# GND.t29 rppd l=38.65u w=3u
X49 a_n7059_10169.t5 a_3822_10479# VDD.t61 VDD.t49 sg13_lv_pmos ad=1.78125p pd=9.755u as=1.78125p ps=9.755u w=9.375u l=2.08u
X50 a_3822_10479# a_3822_10479# VDD.t55 VDD.t49 sg13_lv_pmos ad=1.78125p pd=9.755u as=1.78125p ps=9.755u w=9.375u l=2.08u
X51 VDD.t67 a_3822_10479# a_n7059_10169.t7 VDD.t49 sg13_lv_pmos ad=3.1875p pd=19.43u as=1.78125p ps=9.755u w=9.375u l=2.08u
X52 VDD.t44 a_n7059_10169.t8 a_n6059_11418# VDD.t0 sg13_lv_pmos ad=0.6375p pd=4.43u as=0.35625p ps=2.255u w=1.875u l=5u
X53 a_981_18638# a_981_18638# VDD.t35 VDD.t33 sg13_lv_pmos ad=0.17p pd=1.68u as=0.17p ps=1.68u w=0.5u l=1u
X54 a_n7289_14961# a_n6059_10861# GND.t29 rppd l=38.65u w=0.5u
X55 GND.t51 a_n7289_16545# a_n7289_16545# GND.t50 sg13_lv_nmos ad=0.49875p pd=3.005u as=0.49875p ps=3.005u w=2.625u l=5u
X56 a_3822_10479# a_3822_10479# VDD.t51 VDD.t49 sg13_lv_pmos ad=1.78125p pd=9.755u as=1.78125p ps=9.755u w=9.375u l=2.08u
X57 VDD.t68 GND.t6 cap_cmim l=5u w=5u
X58 VDD.t57 a_3822_10479# a_3822_10479# VDD.t49 sg13_lv_pmos ad=3.1875p pd=19.43u as=1.78125p ps=9.755u w=9.375u l=2.08u
X59 VBGR a_n7059_10169.t11 VDD.t2 VDD.t0 sg13_lv_pmos ad=0.38p pd=2.38u as=0.38p ps=2.38u w=2u l=5u
X60 VDD.t68 GND.t4 cap_cmim l=5u w=5u
X61 VDD.t45 a_n7059_10169.t8 VBGR VDD.t0 sg13_lv_pmos ad=0.68p pd=4.68u as=0.38p ps=2.38u w=2u l=5u
X62 a_n6059_11418# a_n6059_10861# GND.t28 GND.t27 sg13_lv_nmos ad=0.33915p pd=2.165u as=0.6069p ps=4.25u w=1.785u l=5u
X63 GND.t35 a_5580_15247# a_n7059_10169.t3 GND.t34 sg13_lv_nmos ad=1.368p pd=7.58u as=1.368p ps=7.58u w=7.2u l=9.75u
X64 a_n6059_10861# a_n7059_10169.t15 VDD.t40 VDD.t0 sg13_lv_pmos ad=0.35625p pd=2.255u as=0.6375p ps=4.43u w=1.875u l=5u
X65 a_4707_16560# VDD.t31 VDD.t32 VDD.t17 sg13_lv_pmos ad=1.2376p pd=7.96u as=1.2376p ps=7.96u w=3.64u l=3.7u
X66 a_n6059_10861# a_n7059_10169.t13 VDD.t13 VDD.t0 sg13_lv_pmos ad=0.35625p pd=2.255u as=0.35625p ps=2.255u w=1.875u l=5u
X67 a_4707_16560# VDD.t23 VDD.t24 VDD.t17 sg13_lv_pmos ad=1.2376p pd=7.96u as=1.2376p ps=7.96u w=3.64u l=3.7u
X68 a_n7288_17115# a_528_17421# GND.t21 rppd l=38.65u w=0.71u
X69 VDD.t68 GND.t8 cap_cmim l=5u w=5u
X70 a_n7059_10169.t2 a_5580_15247# GND.t35 GND.t34 sg13_lv_nmos ad=1.368p pd=7.58u as=1.368p ps=7.58u w=7.2u l=9.75u
X71 VDD.t7 a_n7059_10169.t10 a_n6059_10861# VDD.t0 sg13_lv_pmos ad=0.35625p pd=2.255u as=0.35625p ps=2.255u w=1.875u l=5u
X72 a_n6059_11418# a_n7059_10169.t15 VDD.t42 VDD.t0 sg13_lv_pmos ad=0.35625p pd=2.255u as=0.6375p ps=4.43u w=1.875u l=5u
X73 VDD.t39 a_1804_15931# a_n6059_11418# VDD.t38 sg13_lv_pmos ad=0.104p pd=1.34u as=0.104p ps=1.34u w=0.2u l=4u
X74 a_n7289_14961# a_527_14697# GND.t29 rppd l=38.65u w=0.5u
X75 a_5580_15247# a_n7059_10169.t0 cap_cmim l=22.29u w=22.29u
X76 VDD.t34 a_981_18638# a_981_18638# VDD.t33 sg13_lv_pmos ad=0.17p pd=1.68u as=0.17p ps=1.68u w=0.5u l=1u
X77 VDD.t68 GND.t2 cap_cmim l=5u w=5u
X78 VDD.t68 GND.t0 cap_cmim l=5u w=5u
X79 a_3822_10479# GND.t31 GND.t30 rppd l=15u w=0.5u
X80 a_n6059_11418# a_n7059_10169.t13 VDD.t15 VDD.t0 sg13_lv_pmos ad=0.35625p pd=2.255u as=0.35625p ps=2.255u w=1.875u l=5u
X81 a_n7289_14433# a_527_14697# GND.t29 rppd l=38.65u w=0.5u
X82 a_5580_15247# a_n6059_10861# a_4707_16560# VDD.t17 sg13_lv_pmos ad=1.2376p pd=7.96u as=1.2376p ps=7.96u w=3.64u l=3.7u
X83 VDD.t36 a_981_18638# a_1804_15931# VDD.t33 sg13_lv_pmos ad=0.17p pd=1.68u as=0.17p ps=1.68u w=0.5u l=1u
X84 VDD.t68 GND.t4 cap_cmim l=5u w=5u
X85 GND.t45 a_n7289_16545# a_n7289_16545# GND.t44 sg13_lv_nmos ad=0.49875p pd=3.005u as=0.49875p ps=3.005u w=2.625u l=5u
X86 a_n7288_17727# a_528_17421# GND.t21 rppd l=38.65u w=0.71u
X87 a_n7289_16545# a_n7289_16545# GND.t51 GND.t52 sg13_lv_nmos ad=0.49875p pd=3.005u as=0.49875p ps=3.005u w=2.625u l=5u
X88 VDD.t9 a_n7059_10169.t10 a_n6059_11418# VDD.t0 sg13_lv_pmos ad=0.35625p pd=2.255u as=0.35625p ps=2.255u w=1.875u l=5u
X89 VBGR a_528_16809# GND.t21 rppd l=38.65u w=0.71u
X90 VDD.t1 a_n7059_10169.t12 a_n6059_10861# VDD.t0 sg13_lv_pmos ad=0.35625p pd=2.255u as=0.35625p ps=2.255u w=1.875u l=5u
X91 VDD.t29 VDD.t29 a_3630_15211# VDD.t17 sg13_lv_pmos ad=1.2376p pd=7.96u as=1.2376p ps=7.96u w=3.64u l=3.7u
X92 GND.t48 a_n7289_16545# a_n7289_16545# GND.t47 sg13_lv_nmos ad=0.49875p pd=3.005u as=0.49875p ps=3.005u w=2.625u l=5u
X93 a_3630_15211# a_n6059_11418# a_4707_16560# VDD.t17 sg13_lv_pmos ad=1.2376p pd=7.96u as=1.2376p ps=7.96u w=3.64u l=3.7u
X94 a_n7289_16545# a_527_16281# GND.t29 rppd l=38.65u w=0.5u
X95 VBGR a_n7059_10169.t15 VDD.t41 VDD.t0 sg13_lv_pmos ad=0.38p pd=2.38u as=0.68p ps=4.68u w=2u l=5u
X96 a_n7289_14433# a_527_13669# GND.t29 rppd l=38.65u w=0.5u
X97 VDD.t68 GND.t6 cap_cmim l=5u w=5u
X98 VDD.t13 a_n7059_10169.t14 a_n6059_10861# VDD.t0 sg13_lv_pmos ad=0.35625p pd=2.255u as=0.35625p ps=2.255u w=1.875u l=5u
X99 VDD.t18 VDD.t16 a_5580_15247# VDD.t17 sg13_lv_pmos ad=1.2376p pd=7.96u as=1.2376p ps=7.96u w=3.64u l=3.7u
X100 VBGR a_n7059_10169.t13 VDD.t14 VDD.t0 sg13_lv_pmos ad=0.38p pd=2.38u as=0.38p ps=2.38u w=2u l=5u
X101 a_n7059_10169.t3 a_5580_15247# GND.t39 GND.t34 sg13_lv_nmos ad=1.368p pd=7.58u as=2.448p ps=15.08u w=7.2u l=9.75u
X102 VDD.t3 a_n7059_10169.t12 a_n6059_11418# VDD.t0 sg13_lv_pmos ad=0.35625p pd=2.255u as=0.35625p ps=2.255u w=1.875u l=5u
X103 a_1804_15931# GND.t32 cap_cmim l=18.2u w=18.2u
X104 VDD.t20 VDD.t19 a_5580_15247# VDD.t17 sg13_lv_pmos ad=1.2376p pd=7.96u as=1.2376p ps=7.96u w=3.64u l=3.7u
X105 VDD.t68 GND.t15 cap_cmim l=5u w=5u
X106 VDD.t8 a_n7059_10169.t10 VBGR VDD.t0 sg13_lv_pmos ad=0.38p pd=2.38u as=0.38p ps=2.38u w=2u l=5u
X107 GND.t24 a_n6059_10861# a_n6059_11418# GND.t23 sg13_lv_nmos ad=0.6069p pd=4.25u as=0.33915p ps=2.165u w=1.785u l=5u
X108 a_3630_15211# a_3630_15211# GND.t58 GND.t57 sg13_lv_nmos ad=0.2448p pd=2.12u as=0.2448p ps=2.12u w=0.72u l=9.75u
X109 VDD.t15 a_n7059_10169.t14 a_n6059_11418# VDD.t0 sg13_lv_pmos ad=0.35625p pd=2.255u as=0.35625p ps=2.255u w=1.875u l=5u
X110 a_n7289_16017# a_527_15753# GND.t29 rppd l=38.65u w=0.5u
X111 a_n7288_18340# a_528_18033# GND.t21 rppd l=38.65u w=0.71u
C0 a_n6059_10861# a_5580_15247# 1.39141f
C1 a_3630_15211# w_3320_16060# 0.08623f
C2 a_528_16809# a_n7202_16809# 0.02797f
C3 VDD a_3630_15211# 5.53382f
C4 VBGR a_n7289_14961# 0.02835f
C5 a_4707_16560# a_3630_15211# 2.26037f
C6 a_n7288_17115# a_n7202_17421# 0.02797f
C7 a_n7288_17727# a_n7202_17727# 0.02797f
C8 a_n7289_14433# a_n7203_14697# 0.01946f
C9 a_n6059_10861# w_3320_10081# 0.03529f
C10 a_n7203_14961# a_n7289_14961# 0.01946f
C11 w_n7489_9836# VBGR 0.03187f
C12 VDD a_n7202_17421# 0.01249f
C13 a_n7203_14961# a_n7203_14697# 0.28316f
C14 a_5580_15247# w_3320_10081# 0.01939f
C15 a_n6059_11418# a_981_18638# 0.32331f
C16 a_1804_15931# m3_1900_17599# 0.18012f
C17 a_981_18638# w_1450_16710# 0.01837f
C18 VDD m3_1900_17599# 0.11496f
C19 a_n7203_14961# a_527_14697# 0.01946f
C20 a_528_18033# a_n7202_18033# 0.02797f
C21 a_11712_10489# a_5580_15247# 0.02077f
C22 a_1804_15931# a_n6059_10861# 0.56499f
C23 a_n7288_18340# a_n7202_18340# 0.02797f
C24 a_n7202_18646# a_981_18638# 0.01155f
C25 a_n6059_10861# w_3320_16060# 0.06145f
C26 a_1804_15931# a_n7289_16545# 0.06623f
C27 a_n6059_10861# VDD 7.7968f
C28 VDD a_n7289_16545# 0.44548f
C29 a_1804_15931# a_5580_15247# 0.52839f
C30 a_n6059_11418# a_3630_15211# 2.44101f
C31 a_n6059_10861# a_4707_16560# 0.77777f
C32 a_5580_15247# w_3320_16060# 0.12191f
C33 a_n7202_17115# a_n7202_16809# 0.28316f
C34 VDD a_5580_15247# 9.63855f
C35 a_4707_16560# a_5580_15247# 1.94868f
C36 VBGR a_n7289_14433# 0.02826f
C37 a_528_17421# a_n7202_17421# 0.02797f
C38 a_n7288_17727# a_n7202_18033# 0.02797f
C39 a_n7289_16545# a_n7203_15753# 0.3003f
C40 a_n6059_11418# a_n7202_17421# 0.01101f
C41 VDD w_3320_10081# 0.29949f
C42 a_5580_15247# w_8745_13831# 0.01565f
C43 a_n7203_16281# a_n7203_16017# 0.28316f
C44 a_n6059_11418# m3_1900_17599# 0.13887f
C45 VDD a_11712_10489# 0.04832f
C46 a_n7202_18340# a_n7202_18033# 0.2814f
C47 a_n6059_11418# a_n6059_10861# 5.19243f
C48 a_3822_10479# a_3630_15211# 0.2287f
C49 a_n6059_10861# w_1450_16710# 0.01046f
C50 a_n6059_11418# a_n7289_16545# 0.54762f
C51 a_1804_15931# VDD 3.87414f
C52 VDD w_3320_16060# 0.97624f
C53 a_n6059_11418# a_5580_15247# 0.6691f
C54 a_4707_16560# w_3320_16060# 0.05243f
C55 a_n7202_17115# a_528_16809# 0.02797f
C56 VDD a_4707_16560# 4.11718f
C57 a_n7289_16545# a_n7289_15489# 0.01143f
C58 a_n7289_16545# a_n7203_13669# 2.06054f
C59 a_n7203_16545# a_n7202_16809# 0.28312f
C60 a_n6059_10861# a_n7203_15225# 0.03934f
C61 a_n6059_10861# w_1389_15644# 0.0227f
C62 a_n7289_16545# a_n7203_15225# 0.26585f
C63 a_n7202_18340# a_528_18033# 0.02797f
C64 VDD w_8745_13831# 0.12231f
C65 a_n7289_16545# a_n7203_14433# 0.28328f
C66 a_4707_16560# w_8745_13831# 0.01857f
C67 a_n7202_17421# a_n7202_17727# 0.28316f
C68 a_n7289_16017# a_n7203_16017# 0.01946f
C69 VBGR a_n7289_16017# 0.02643f
C70 a_3822_10479# a_n6059_10861# 0.12554f
C71 a_n6059_11418# a_1804_15931# 0.8956f
C72 a_3822_10479# a_5580_15247# 0.99474f
C73 a_1804_15931# w_1450_16710# 0.02901f
C74 a_n6059_11418# w_3320_16060# 0.02743f
C75 a_n6059_11418# VDD 6.60712f
C76 VDD w_1450_16710# 0.14006f
C77 a_n6059_11418# a_4707_16560# 1.14873f
C78 a_n7289_16545# a_n7202_17727# 0.04493f
C79 a_n7202_18646# VDD 0.19813f
C80 a_n7203_16281# a_527_16281# 0.01946f
C81 a_n6059_10861# a_527_15753# 0.01872f
C82 a_n7289_16545# a_527_15753# 0.01192f
C83 a_n7289_16545# a_527_13669# 0.03816f
C84 a_3822_10479# w_3320_10081# 0.06148f
C85 a_n7289_16545# a_n7202_16809# 0.31907f
C86 VDD a_n7203_13669# 0.04526f
C87 a_1804_15931# w_1389_15644# 0.04315f
C88 a_n7289_16545# a_n7289_14961# 0.01076f
C89 VDD w_1389_15644# 0.08151f
C90 a_n7289_16545# a_n7203_14697# 0.27223f
C91 a_n7289_16017# a_n7203_16281# 0.01946f
C92 a_3822_10479# a_11712_10489# 0.0484f
C93 a_n7289_15489# a_n7203_15753# 0.01947f
C94 a_527_14697# a_n6059_10861# 0.01925f
C95 a_527_14697# a_n7289_16545# 0.01226f
C96 a_3822_10479# VDD 53.687f
C97 a_n6059_11418# w_1450_16710# 0.02162f
C98 a_3822_10479# a_4707_16560# 1.38266f
C99 a_n7289_16545# a_n7202_18033# 0.02918f
C100 w_n7489_9836# a_n6059_10861# 0.01864f
C101 VDD a_n7202_17727# 0.0906f
C102 w_n7489_9836# a_n7289_16545# 0.04233f
C103 a_n7288_18340# VDD 0.01496f
C104 a_n7203_16281# a_n7203_16545# 0.28316f
C105 a_n7203_16017# a_n7289_16545# 0.34937f
C106 a_n6059_10861# VBGR 0.77384f
C107 VBGR a_n7289_16545# 0.44625f
C108 a_n6059_11418# a_n7203_13669# 0.02588f
C109 a_3822_10479# w_8745_13831# 0.04046f
C110 VDD a_n7202_16809# 0.01247f
C111 a_n6059_10861# a_n7203_15489# 0.03922f
C112 a_n6059_11418# w_1389_15644# 0.01462f
C113 a_n7289_16545# a_n7203_15489# 0.27748f
C114 a_981_18638# a_n7202_18340# 0.0122f
C115 a_n7289_16545# a_n7289_14433# 0.01035f
C116 a_528_17421# a_n7202_17727# 0.02797f
C117 a_527_15753# a_n7203_15753# 0.01946f
C118 a_n7203_14961# a_n7289_16545# 0.25927f
C119 a_n7203_16545# a_527_16281# 0.01946f
C120 VBGR a_n7288_17115# 0.02034f
C121 w_n7489_9836# a_1804_15931# 0.01614f
C122 VDD a_n7202_18033# 0.10885f
C123 a_n7202_17115# a_n7202_17421# 0.28316f
C124 w_n7489_9836# VDD 0.44118f
C125 a_n7203_13669# a_n7203_14433# 0.28316f
C126 a_n7288_18340# a_n7202_18646# 0.02797f
C127 a_n7203_16281# a_n7289_16545# 0.46335f
C128 a_n6059_11418# a_527_15753# 0.01738f
C129 a_1804_15931# VBGR 0.01015f
C130 VDD VBGR 7.06928f
C131 a_n6059_11418# a_527_13669# 0.01087f
C132 a_n6059_11418# a_n7202_16809# 0.03367f
C133 a_n7289_16545# a_n7202_17115# 0.14683f
C134 a_n7203_16017# a_n7203_15753# 0.28316f
C135 a_n7289_16545# a_527_16281# 0.03573f
C136 a_n7203_15489# a_n7203_15753# 0.28316f
C137 a_527_13669# a_n7203_13669# 0.12082f
C138 w_n7489_9836# a_n6059_11418# 0.04437f
C139 VDD a_n7288_17727# 0.01227f
C140 a_n7202_17115# a_n7288_17115# 0.02797f
C141 a_527_13669# a_n7203_14433# 0.01946f
C142 a_n7289_14961# a_n7203_15225# 0.01946f
C143 a_n6059_11418# a_n7203_16017# 0.01623f
C144 a_n7203_14697# a_n7203_14433# 0.28316f
C145 a_n7289_16017# a_n7289_16545# 0.02695f
C146 a_n6059_11418# a_528_16809# 0.01526f
C147 VDD a_n7202_17115# 0.01249f
C148 a_981_18638# m3_1900_17599# 0.07046f
C149 a_n6059_10861# a_981_18638# 0.01705f
C150 a_n7202_18340# VDD 0.1303f
C151 VBGR a_n7289_15489# 0.02616f
C152 VBGR a_n7203_13669# 0.04028f
C153 a_n7289_16545# a_n7203_16545# 0.57323f
C154 a_n6059_10861# a_3630_15211# 1.55585f
C155 a_n7203_15489# a_n7289_15489# 0.01947f
C156 a_5580_15247# a_3630_15211# 1.81989f
C157 a_n7202_18033# a_n7202_17727# 0.28316f
C158 a_n7203_15489# a_n7203_15225# 0.28316f
C159 a_n7289_14433# a_n7203_14433# 0.01946f
C160 a_n7203_14961# a_n7203_15225# 0.28316f
C161 a_n7289_16545# a_n7202_17421# 0.07627f
C162 a_527_14697# a_n7203_14697# 0.01946f
C163 a_3630_15211# w_3320_10081# 0.01456f
C164 a_n7203_16017# a_527_15753# 0.01946f
C165 a_1804_15931# a_981_18638# 0.85191f
C166 a_981_18638# VDD 2.29154f
C167 a_n7202_18646# a_n7202_18340# 0.28316f
C168 a_n6059_10861# a_n7289_16545# 0.08942f
C169 VBGR a_n7202_16809# 0.06913f
R0 VDD.n280 VDD.n72 18.6717
R1 VDD.n43 VDD.n107 18.6678
R2 VDD.n324 VDD.n283 18.6678
R3 VDD.n6 VDD.n4 0.0835752
R4 VDD.n36 VDD.n99 18.6737
R5 VDD.n20 VDD.n37 18.6698
R6 VDD.n35 VDD.n100 18.6678
R7 VDD.n340 VDD.n59 18.6678
R8 VDD.n118 VDD.n101 18.6678
R9 VDD.n337 VDD.n102 18.6678
R10 VDD.n31 VDD.n34 18.6678
R11 VDD.n335 VDD.n103 18.6678
R12 VDD.n333 VDD.n104 18.6678
R13 VDD.n122 VDD.n105 18.6678
R14 VDD.n331 VDD.n56 18.6678
R15 VDD.n329 VDD.n106 18.6678
R16 VDD.n28 VDD.n27 18.6678
R17 VDD.n326 VDD.n45 18.6678
R18 VDD.n5 VDD.n4 0.109778
R19 VDD.n72 VDD.n97 18.6678
R20 VDD.n72 VDD.n98 18.6678
R21 VDD.t17 VDD.n4 1.87091
R22 VDD.t17 VDD.n7 0.682884
R23 VDD.t17 VDD.n50 8.49814
R24 VDD.t17 VDD.n223 17.0005
R25 VDD.t17 VDD.n222 17.0005
R26 VDD.t17 VDD.n221 17.0005
R27 VDD.t17 VDD.n220 17.0005
R28 VDD.t17 VDD.n24 8.49606
R29 VDD.t59 VDD.n245 17.0005
R30 VDD.n259 VDD.t59 17.0005
R31 VDD.t59 VDD.n252 17.0005
R32 VDD.t59 VDD.n251 17.0005
R33 VDD.t59 VDD.n253 17.0005
R34 VDD.t59 VDD.n250 17.0005
R35 VDD.t59 VDD.n254 17.0005
R36 VDD.t59 VDD.n249 17.0005
R37 VDD.t59 VDD.n255 17.0005
R38 VDD.t59 VDD.n248 17.0005
R39 VDD.t59 VDD.n256 17.0005
R40 VDD.t59 VDD.n247 17.0005
R41 VDD.t59 VDD.n257 17.0005
R42 VDD.t59 VDD.n246 17.0005
R43 VDD.t59 VDD.n258 17.0005
R44 VDD.n11 VDD.n9 0.0770581
R45 VDD.t17 VDD.n11 2.09318
R46 VDD.t17 VDD.n22 3.35015
R47 VDD.t17 VDD.n153 17.0005
R48 VDD.t17 VDD.n151 17.0005
R49 VDD.t17 VDD.n150 17.0005
R50 VDD.t17 VDD.n149 17.0005
R51 VDD.t17 VDD.n147 17.0005
R52 VDD.t17 VDD.n146 17.0005
R53 VDD.t17 VDD.n55 8.49722
R54 VDD.t17 VDD.n138 17.0005
R55 VDD.t17 VDD.n139 17.0005
R56 VDD.t17 VDD.n140 17.0005
R57 VDD.t17 VDD.n29 8.49537
R58 VDD.n29 VDD.n28 0.0122706
R59 VDD.t17 VDD.n44 3.3571
R60 VDD.t17 VDD.n137 17.0005
R61 VDD.t17 VDD.n120 17.0005
R62 VDD.t17 VDD.n124 17.0005
R63 VDD.t17 VDD.n125 17.0005
R64 VDD.t17 VDD.n126 17.0005
R65 VDD.t17 VDD.n30 8.49822
R66 VDD.t17 VDD.n127 17.0005
R67 VDD.t17 VDD.n128 17.0005
R68 VDD.t17 VDD.n129 17.0005
R69 VDD.t17 VDD.n111 17.0005
R70 VDD.t17 VDD.n19 4.24587
R71 VDD.t17 VDD.n112 17.0005
R72 VDD.t17 VDD.n113 17.0005
R73 VDD.t17 VDD.n60 8.49675
R74 VDD.t17 VDD.t24 17.0005
R75 VDD.n184 VDD.t57 17.0005
R76 VDD.n210 VDD.t57 17.0005
R77 VDD.n208 VDD.t57 17.0005
R78 VDD.n206 VDD.t57 17.0005
R79 VDD.n204 VDD.t57 17.0005
R80 VDD.n202 VDD.t57 17.0005
R81 VDD.n200 VDD.t57 17.0005
R82 VDD.n198 VDD.t57 17.0005
R83 VDD.n196 VDD.t57 17.0005
R84 VDD.n194 VDD.t57 17.0005
R85 VDD.n192 VDD.t57 17.0005
R86 VDD.n190 VDD.t57 17.0005
R87 VDD.n188 VDD.t57 17.0005
R88 VDD.n186 VDD.t57 17.0005
R89 VDD.n13 VDD.n14 0.0539725
R90 VDD.n39 VDD.n14 0.0674653
R91 VDD.t67 VDD.n0 0.587752
R92 VDD.t60 VDD.n42 3.38336
R93 VDD.n40 VDD.n42 0.0254521
R94 VDD.n15 VDD.t50 0.879354
R95 VDD.n168 VDD.t50 17.0005
R96 VDD.n172 VDD.t50 17.0005
R97 VDD.n170 VDD.t50 17.0005
R98 VDD.n1 VDD.t44 3.39672
R99 VDD.t43 VDD.n88 17.0005
R100 VDD.n95 VDD.t43 17.0005
R101 VDD.t43 VDD.n91 17.0005
R102 VDD.t43 VDD.n89 17.0005
R103 VDD.t43 VDD.n94 17.0005
R104 VDD.n38 VDD.t41 2.83285
R105 VDD.t40 VDD.n84 17.0005
R106 VDD.n86 VDD.t40 17.0005
R107 VDD.t40 VDD.n82 17.0005
R108 VDD.t40 VDD.n83 17.0005
R109 VDD.t40 VDD.n85 17.0005
R110 VDD.n6 VDD.t25 1.45366
R111 VDD.t19 VDD.n52 7.49552
R112 VDD.n51 VDD.n52 0.0119611
R113 VDD.t19 VDD.n272 15.0005
R114 VDD.t19 VDD.n266 15.0005
R115 VDD.t19 VDD.n271 15.0005
R116 VDD.t19 VDD.n267 15.0005
R117 VDD.t19 VDD.n26 7.49575
R118 VDD.n26 VDD.n25 0.0114983
R119 VDD.n161 VDD.t27 15.0005
R120 VDD.t27 VDD.n154 15.0005
R121 VDD.t27 VDD.n160 15.0005
R122 VDD.t27 VDD.n155 15.0005
R123 VDD.t27 VDD.n159 15.0005
R124 VDD.t27 VDD.n156 15.0005
R125 VDD.t27 VDD.n158 15.0005
R126 VDD.t27 VDD.n157 15.0005
R127 VDD.n33 VDD.n45 0.0362393
R128 VDD.t21 VDD.n33 4.98746
R129 VDD.t21 VDD.n144 15.0005
R130 VDD.t21 VDD.n142 15.0005
R131 VDD.t21 VDD.n143 15.0005
R132 VDD.n57 VDD.n56 0.0114983
R133 VDD.t21 VDD.n57 7.49575
R134 VDD.n136 VDD.t16 15.0005
R135 VDD.t16 VDD.n130 15.0005
R136 VDD.t16 VDD.n135 15.0005
R137 VDD.t16 VDD.n131 15.0005
R138 VDD.n32 VDD.n31 0.0114983
R139 VDD.t16 VDD.n32 7.49575
R140 VDD.t16 VDD.n134 15.0005
R141 VDD.t16 VDD.n132 15.0005
R142 VDD.t16 VDD.n133 15.0005
R143 VDD.t16 VDD.t18 15.0005
R144 VDD.t23 VDD.n116 15.0005
R145 VDD.t23 VDD.n21 3.73766
R146 VDD.n21 VDD.n20 0.0155146
R147 VDD.t23 VDD.n114 15.0005
R148 VDD.t23 VDD.n115 15.0005
R149 VDD.t23 VDD.n61 7.4956
R150 VDD.n61 VDD.n59 0.0118068
R151 VDD.n117 VDD.t23 15.0005
R152 VDD.t31 VDD.n10 2.49247
R153 VDD.t31 VDD.n23 7.49374
R154 VDD.t32 VDD.n23 0.0155261
R155 VDD.n295 VDD.n74 9.63299
R156 VDD.n321 VDD.n285 9.63299
R157 VDD.t36 VDD.n286 9.63227
R158 VDD.t63 VDD.t49 1.47574
R159 VDD.t61 VDD.n41 1.78958
R160 VDD.n41 VDD.n46 0.136606
R161 VDD.n175 VDD.t61 9.0005
R162 VDD.t58 VDD.n276 8.5089
R163 VDD.t33 VDD.n302 8.5089
R164 VDD.t58 VDD.n239 8.50095
R165 VDD.t49 VDD.n62 8.50093
R166 VDD.t49 VDD.n40 1.68958
R167 VDD.t49 VDD.n46 0.364325
R168 VDD.n0 VDD.t49 0.0723755
R169 VDD.n39 VDD.t49 1.39697
R170 VDD.n209 VDD.t49 8.50093
R171 VDD.n207 VDD.t49 8.50093
R172 VDD.n205 VDD.t49 8.50093
R173 VDD.n203 VDD.t49 8.50093
R174 VDD.n201 VDD.t49 8.50093
R175 VDD.n199 VDD.t49 8.50093
R176 VDD.n197 VDD.t49 8.50093
R177 VDD.n195 VDD.t49 8.50093
R178 VDD.n193 VDD.t49 8.50093
R179 VDD.n191 VDD.t49 8.50093
R180 VDD.n189 VDD.t49 8.50093
R181 VDD.n187 VDD.t49 8.50093
R182 VDD.n185 VDD.t49 8.50093
R183 VDD.n46 VDD.t60 0.981138
R184 VDD.t58 VDD.n244 8.50089
R185 VDD.t58 VDD.n243 8.50089
R186 VDD.t58 VDD.n242 8.50089
R187 VDD.t58 VDD.n241 8.50089
R188 VDD.t58 VDD.n240 8.50089
R189 VDD.t58 VDD.n229 8.50062
R190 VDD.t58 VDD.n238 8.5005
R191 VDD.t58 VDD.n237 8.5005
R192 VDD.t58 VDD.n236 8.5005
R193 VDD.t58 VDD.n235 8.5005
R194 VDD.t58 VDD.n234 8.5005
R195 VDD.t58 VDD.n233 8.5005
R196 VDD.t58 VDD.n232 8.5005
R197 VDD.t58 VDD.n231 8.5005
R198 VDD.n54 VDD.t49 2.09124
R199 VDD.n58 VDD.t49 2.09124
R200 VDD.n13 VDD.n0 0.316669
R201 VDD.n182 VDD.t49 8.5005
R202 VDD.t49 VDD.n173 8.5005
R203 VDD.t49 VDD.n171 8.5005
R204 VDD.t49 VDD.n169 8.5005
R205 VDD.t49 VDD.n15 0.318451
R206 VDD.n317 VDD.t33 8.5005
R207 VDD.t33 VDD.n289 8.5005
R208 VDD.t33 VDD.n300 8.5005
R209 VDD.t38 VDD.n305 8.5005
R210 VDD.n8 VDD.t0 0.323134
R211 VDD.n87 VDD.t0 8.5005
R212 VDD.n90 VDD.t0 8.5005
R213 VDD.n93 VDD.t0 8.5005
R214 VDD.n92 VDD.t0 8.5005
R215 VDD.t0 VDD.n3 0.335182
R216 VDD.t0 VDD.n81 8.5005
R217 VDD.t0 VDD.n80 8.5005
R218 VDD.t0 VDD.n79 8.5005
R219 VDD.t0 VDD.n78 8.5005
R220 VDD.t0 VDD.n38 0.324802
R221 VDD.t33 VDD.n297 8.50005
R222 VDD.t33 VDD.n316 8.49985
R223 VDD.t33 VDD.n292 8.49985
R224 VDD.t33 VDD.n313 8.49985
R225 VDD.n14 VDD.t57 1.2919
R226 VDD.t17 VDD.n47 8.49537
R227 VDD.t17 VDD.n152 8.49531
R228 VDD.t17 VDD.n148 8.49531
R229 VDD.t17 VDD.n165 8.48461
R230 VDD.t17 VDD.n121 8.48078
R231 VDD.t19 VDD.n268 7.49575
R232 VDD.t21 VDD.n141 7.49575
R233 VDD.n319 VDD.n318 7.07444
R234 VDD.n323 VDD.n284 7.0721
R235 VDD.t17 VDD.n164 5.61923
R236 VDD.t17 VDD.n109 5.61856
R237 VDD.t17 VDD.n110 5.61856
R238 VDD.t17 VDD.n12 5.61856
R239 VDD.n282 VDD.t17 5.61856
R240 VDD.n318 VDD.n317 4.53951
R241 VDD.n289 VDD.n284 4.53875
R242 VDD.n293 VDD.n284 4.53035
R243 VDD.n318 VDD.n287 4.53035
R244 VDD.n310 VDD.t38 4.23715
R245 VDD.t49 VDD.n63 2.8095
R246 VDD.n16 VDD.t49 0.486989
R247 VDD.t38 VDD.n303 4.23691
R248 VDD.t58 VDD.n274 4.23642
R249 VDD.t58 VDD.n261 4.23628
R250 VDD.t33 VDD.t34 4.23614
R251 VDD.t33 VDD.n294 4.23595
R252 VDD.t33 VDD.n301 4.23582
R253 VDD.t17 VDD.n225 4.22512
R254 VDD.t17 VDD.n119 4.20261
R255 VDD.t17 VDD.n166 4.19628
R256 VDD.t17 VDD.t29 4.18309
R257 VDD.t20 VDD.t26 3.60559
R258 VDD.n176 VDD.t60 3.46429
R259 VDD.n174 VDD.t50 3.44446
R260 VDD.n53 VDD.t49 0.737734
R261 VDD.t17 VDD.n224 3.31404
R262 VDD.n68 VDD.n96 3.38736
R263 VDD.n88 VDD.n1 0.119453
R264 VDD.n212 VDD.t49 2.80949
R265 VDD.n277 VDD.t58 2.80871
R266 VDD.t58 VDD.n262 2.8082
R267 VDD.n17 VDD.n18 0.0464703
R268 VDD.t58 VDD.n226 2.09752
R269 VDD.n96 VDD.t0 0.262993
R270 VDD.n216 VDD.t49 2.09118
R271 VDD.n214 VDD.t49 2.09105
R272 VDD.t13 VDD.t14 1.91575
R273 VDD.t8 VDD.t7 1.91575
R274 VDD.t1 VDD.t2 1.91575
R275 VDD.t15 VDD.t13 1.87739
R276 VDD.t7 VDD.t9 1.87739
R277 VDD.t3 VDD.t1 1.87739
R278 VDD.t28 VDD.t22 1.84308
R279 VDD.n215 VDD.n167 1.80015
R280 VDD.n218 VDD.n217 1.80015
R281 VDD.n181 VDD.n177 1.77474
R282 VDD.n213 VDD.n9 1.77474
R283 VDD.n211 VDD.n9 1.77474
R284 VDD.n179 VDD.n178 1.7541
R285 VDD.n16 VDD.n163 1.77675
R286 VDD.n180 VDD.t32 1.7541
R287 VDD.t49 VDD.n64 1.66951
R288 VDD.t58 VDD.n230 1.65516
R289 VDD.t51 VDD.n183 1.43298
R290 VDD.n13 VDD.t55 1.43298
R291 VDD.t14 VDD.t0 1.69646
R292 VDD.n96 VDD.t2 1.42349
R293 VDD.n306 VDD.t35 1.40606
R294 VDD.n307 VDD.t37 1.40606
R295 VDD.t39 VDD.n300 1.38105
R296 VDD.n312 VDD.n311 1.36807
R297 VDD.n304 VDD.n302 1.36807
R298 VDD.t17 VDD.n219 1.36589
R299 VDD.t33 VDD.n296 1.36083
R300 VDD.n281 VDD.n279 1.2602
R301 VDD.t26 VDD.n4 1.23481
R302 VDD.n145 VDD.n108 1.22535
R303 VDD.n281 VDD.n280 1.22418
R304 VDD.n48 VDD.t20 1.22106
R305 VDD.n283 VDD.n108 1.19297
R306 VDD.t9 VDD.t0 1.37715
R307 VDD.n2 VDD.t3 1.35168
R308 VDD.n341 VDD.n36 1.1005
R309 VDD.n339 VDD.n36 1.1005
R310 VDD.n36 VDD.n338 1.1005
R311 VDD.n36 VDD.n67 0.34883
R312 VDD.n36 VDD.n336 1.1005
R313 VDD.n334 VDD.n36 1.1005
R314 VDD.n77 VDD.n36 0.147883
R315 VDD.n36 VDD.n332 1.1005
R316 VDD.n330 VDD.n36 1.1005
R317 VDD.n328 VDD.n36 1.1005
R318 VDD.n36 VDD.n327 1.1005
R319 VDD.n76 VDD.n36 0.54009
R320 VDD.n36 VDD.n325 1.1005
R321 VDD.n75 VDD.n36 0.189528
R322 VDD.n36 VDD.n65 0.54009
R323 VDD.n36 VDD.n322 1.1005
R324 VDD.n73 VDD.n36 0.54009
R325 VDD.n36 VDD.n320 1.1005
R326 VDD.n69 VDD.n36 1.1005
R327 VDD.t17 VDD.n123 0.990548
R328 VDD.n162 VDD.n161 0.889051
R329 VDD.n163 VDD.n162 0.87634
R330 VDD.t68 VDD.n36 0.858361
R331 VDD.n7 VDD.n6 0.732055
R332 VDD.t38 VDD.n308 0.764382
R333 VDD.t33 VDD.n298 0.758921
R334 VDD.n7 VDD.n99 0.820549
R335 VDD.n123 VDD.n104 0.710877
R336 VDD.n123 VDD.n122 0.690888
R337 VDD.n265 VDD.n264 0.6605
R338 VDD.n49 VDD.n48 0.0044511
R339 VDD.n145 VDD.t28 0.650654
R340 VDD.n275 VDD.n260 0.649324
R341 VDD.t22 VDD.n45 0.641213
R342 VDD.n260 VDD.n259 0.632208
R343 VDD.n2 VDD.t0 0.157917
R344 VDD.t61 VDD.t63 0.578744
R345 VDD.n276 VDD.n25 0.576245
R346 VDD.n270 VDD.n269 0.576245
R347 VDD.n309 VDD.n304 0.57569
R348 VDD.n264 VDD.n49 0.306523
R349 VDD.t17 VDD.n162 0.571898
R350 VDD.n273 VDD.n51 0.570184
R351 VDD.n219 VDD.n218 0.567404
R352 VDD.n309 VDD.t39 0.562667
R353 VDD.n315 VDD.n314 0.537161
R354 VDD.n315 VDD.n288 0.534164
R355 VDD.n291 VDD.n290 0.532492
R356 VDD.n299 VDD.n290 0.53143
R357 VDD.n279 VDD.n278 0.505544
R358 VDD.n264 VDD.n263 0.501611
R359 VDD.n228 VDD.n227 0.50119
R360 VDD.n268 VDD.n219 0.49714
R361 VDD.n71 VDD.n70 0.00644547
R362 VDD.n298 VDD.t35 0.311543
R363 VDD.n308 VDD.n306 0.296797
R364 VDD.t55 VDD.t51 0.294032
R365 VDD.n308 VDD.n307 0.273309
R366 VDD.n227 VDD.n224 0.263806
R367 VDD.n298 VDD.t37 0.263688
R368 VDD.n163 VDD.t29 0.261477
R369 VDD.n283 VDD.n282 0.223995
R370 VDD.n49 VDD.n224 0.223351
R371 VDD.t33 VDD.n290 0.201382
R372 VDD.t33 VDD.n315 0.19989
R373 VDD.n177 VDD.n164 0.19957
R374 VDD.n178 VDD.n164 0.19312
R375 VDD.t18 VDD.n102 0.189157
R376 VDD.n109 VDD.n97 0.188517
R377 VDD.n177 VDD.t29 0.186616
R378 VDD.n12 VDD.n98 0.181217
R379 VDD.t17 VDD.n281 0.177495
R380 VDD.n178 VDD.n22 0.19467
R381 VDD.n167 VDD.n166 0.170595
R382 VDD.n44 VDD.n43 0.21279
R383 VDD.n282 VDD.n43 0.164073
R384 VDD.n230 VDD.n228 0.161135
R385 VDD.t36 VDD.n296 0.157694
R386 VDD.n296 VDD.n285 0.157594
R387 VDD.n110 VDD.n98 0.155245
R388 VDD.n70 VDD.n69 0.329723
R389 VDD.n72 VDD.n66 0.0575264
R390 VDD.n263 VDD.n230 0.151694
R391 VDD.n110 VDD.n97 0.147267
R392 VDD.n119 VDD.n118 0.141081
R393 VDD.n217 VDD.n64 0.129429
R394 VDD.n184 VDD.n64 0.126963
R395 VDD.n5 VDD.n12 0.24543
R396 VDD.n216 VDD.n215 0.121581
R397 VDD.n122 VDD.n121 0.120877
R398 VDD.n16 VDD.n181 0.200598
R399 VDD.n280 VDD.n109 0.112467
R400 VDD.t32 VDD.n22 0.0903097
R401 VDD.n45 VDD.n44 0.0677853
R402 VDD.n218 VDD.n166 0.112125
R403 VDD.n215 VDD.n214 0.107703
R404 VDD.n214 VDD.n213 0.105411
R405 VDD.n245 VDD.n226 0.104451
R406 VDD.t38 VDD.n309 0.100926
R407 VDD.t17 VDD.n108 0.0958832
R408 VDD.n212 VDD.n211 0.0954058
R409 VDD.n213 VDD.n212 0.0952249
R410 VDD.n217 VDD.n216 0.0907649
R411 VDD.n119 VDD.n102 0.0885765
R412 VDD.n54 VDD.n180 0.0897974
R413 VDD.n278 VDD.n226 0.0842405
R414 VDD.n273 VDD.n262 0.0835606
R415 VDD.t8 VDD.t0 1.80624
R416 VDD.n294 VDD.n293 0.082931
R417 VDD.t34 VDD.n285 0.082802
R418 VDD.n269 VDD.n261 0.0827445
R419 VDD.n274 VDD.n265 0.0752984
R420 VDD.n277 VDD.n228 0.0738532
R421 VDD.n63 VDD.n179 0.100598
R422 VDD.n278 VDD.n277 0.071901
R423 VDD.t34 VDD.n295 0.0707091
R424 VDD.n118 VDD.t24 0.069971
R425 VDD.n10 VDD.n165 0.0895626
R426 VDD.n269 VDD.n262 0.066755
R427 VDD.n274 VDD.n273 0.0660008
R428 VDD.n53 VDD.n174 0.125262
R429 VDD.n275 VDD.n261 0.0600797
R430 VDD.n311 VDD.n310 0.0578697
R431 VDD.n311 VDD.n303 0.0574341
R432 VDD.n137 VDD.n104 0.0570278
R433 VDD.n227 VDD.n225 0.055276
R434 VDD.n312 VDD.n301 0.0547924
R435 VDD.n279 VDD.n225 0.0535001
R436 VDD.n297 VDD.n287 0.0533262
R437 VDD.t58 VDD.n260 0.0532184
R438 VDD.n63 VDD.n180 0.11019
R439 VDD.n297 VDD.t36 0.0525623
R440 VDD.n295 VDD.n294 0.0514823
R441 VDD.n57 VDD.n121 0.0613916
R442 VDD.n137 VDD.n136 0.0464363
R443 VDD.t45 VDD.n8 2.83297
R444 VDD.n65 VDD.n74 0.0332965
R445 VDD.n324 VDD.n75 0.0897235
R446 VDD.n76 VDD.n107 0.0395822
R447 VDD.n333 VDD.n77 0.130436
R448 VDD.n67 VDD.n34 0.0456604
R449 VDD.n68 VDD.t68 0.0103693
R450 VDD.n336 VDD.n34 0.0434524
R451 VDD.n75 VDD.n323 0.124468
R452 VDD.n84 VDD.n38 0.120214
R453 VDD.t39 VDD.n305 0.0394583
R454 VDD.n320 VDD.n319 0.0392619
R455 VDD.n325 VDD.n324 0.0392619
R456 VDD.n8 VDD.n95 0.119715
R457 VDD.n3 VDD.n86 0.120037
R458 VDD.t35 VDD.n301 0.0383695
R459 VDD.n327 VDD.n326 0.0382143
R460 VDD.n313 VDD.n312 0.0369025
R461 VDD.n335 VDD.n334 0.0361191
R462 VDD.n73 VDD.n286 0.0576536
R463 VDD.n322 VDD.n74 0.0345476
R464 VDD.n167 VDD.n165 0.0337839
R465 VDD.n306 VDD.n303 0.0337536
R466 VDD.n332 VDD.n105 0.0332381
R467 VDD.n338 VDD.n337 0.0327143
R468 VDD.n53 VDD.n176 0.109458
R469 VDD.n35 VDD.n341 0.0321905
R470 VDD.n328 VDD.n27 0.0314048
R471 VDD.n316 VDD.n288 0.0307914
R472 VDD.n292 VDD.n291 0.0307914
R473 VDD.n314 VDD.n313 0.0307914
R474 VDD.n310 VDD.n304 0.0297354
R475 VDD.n325 VDD.n107 0.0282619
R476 VDD.n321 VDD.n73 0.0503203
R477 VDD.n317 VDD.n288 0.028
R478 VDD.n291 VDD.n289 0.028
R479 VDD.n299 VDD.n300 0.028
R480 VDD.n307 VDD.n305 0.0272361
R481 VDD.n339 VDD.n101 0.0272143
R482 VDD.n331 VDD.n330 0.0266905
R483 VDD.n330 VDD.n329 0.0261667
R484 VDD.t37 VDD.n299 0.0257083
R485 VDD.n340 VDD.n339 0.025381
R486 VDD.n263 VDD.n229 0.0246805
R487 VDD.n95 VDD.n87 0.0237628
R488 VDD.n52 VDD.n47 0.0348553
R489 VDD.n84 VDD.n78 0.0228333
R490 VDD.n160 VDD.n151 0.0223103
R491 VDD.n91 VDD.n90 0.0214366
R492 VDD.n85 VDD.n79 0.0205
R493 VDD.n156 VDD.n149 0.0204138
R494 VDD.n25 VDD.n24 0.0108819
R495 VDD.n144 VDD.n140 0.0202753
R496 VDD.n341 VDD.n340 0.0201429
R497 VDD.n158 VDD.n147 0.0197816
R498 VDD.n33 VDD.n28 0.0281796
R499 VDD.n276 VDD.n275 0.0195972
R500 VDD.n211 VDD.n54 0.104814
R501 VDD.n314 VDD.n302 0.0195972
R502 VDD.n329 VDD.n328 0.0193571
R503 VDD.t24 VDD.n117 0.0193483
R504 VDD.n93 VDD.n89 0.0191103
R505 VDD.n332 VDD.n331 0.0188333
R506 VDD.n23 VDD.n11 0.099034
R507 VDD.n41 VDD.n40 0.0297103
R508 VDD.n338 VDD.n101 0.0183095
R509 VDD.n83 VDD.n80 0.0181667
R510 VDD.n154 VDD.n153 0.0178851
R511 VDD.n267 VDD.n220 0.0178034
R512 VDD.n154 VDD.n152 0.0177453
R513 VDD.n322 VDD.n321 0.0175238
R514 VDD.n60 VDD.n59 0.00949295
R515 VDD.n21 VDD.n111 0.0615761
R516 VDD.n143 VDD.n138 0.0171854
R517 VDD.n94 VDD.n92 0.016784
R518 VDD.n18 VDD.n68 0.367849
R519 VDD.n70 VDD.n18 0.39101
R520 VDD.n71 VDD.n36 0.17561
R521 VDD.n71 VDD.n17 0.124801
R522 VDD.n17 VDD.t68 0.124246
R523 VDD.n5 VDD.n66 3.75643
R524 VDD.n271 VDD.n221 0.0165674
R525 VDD.n133 VDD.n120 0.0165674
R526 VDD.n39 VDD.n210 0.0739615
R527 VDD.n155 VDD.n150 0.0159885
R528 VDD.n334 VDD.n333 0.0159524
R529 VDD.n186 VDD.n185 0.0159129
R530 VDD.n170 VDD.n169 0.0159054
R531 VDD.n158 VDD.n148 0.0158487
R532 VDD.n82 VDD.n81 0.0158333
R533 VDD.n56 VDD.n55 0.00856685
R534 VDD.n130 VDD.n129 0.0156404
R535 VDD.n209 VDD.n208 0.0156393
R536 VDD.n266 VDD.n222 0.0153315
R537 VDD.n132 VDD.n124 0.0153315
R538 VDD.n156 VDD.n148 0.0152165
R539 VDD.n172 VDD.n171 0.0150946
R540 VDD.n188 VDD.n187 0.015092
R541 VDD.n207 VDD.n206 0.0148184
R542 VDD.n173 VDD.n168 0.0145541
R543 VDD.n115 VDD.n113 0.0144045
R544 VDD.n190 VDD.n189 0.0142711
R545 VDD.n58 VDD.n179 0.0994672
R546 VDD.n327 VDD.n27 0.014119
R547 VDD.n272 VDD.n223 0.0140955
R548 VDD.n134 VDD.n125 0.0140955
R549 VDD.n116 VDD.n99 0.0140955
R550 VDD.n146 VDD.n145 0.014092
R551 VDD.n159 VDD.n150 0.014092
R552 VDD.n183 VDD.n182 0.0140135
R553 VDD.n265 VDD.n229 0.0139861
R554 VDD.n205 VDD.n204 0.0137239
R555 VDD.n157 VDD.n146 0.0134598
R556 VDD.n192 VDD.n191 0.0134502
R557 VDD.n37 VDD.n35 0.0498132
R558 VDD.n160 VDD.n152 0.01332
R559 VDD.n203 VDD.n202 0.012903
R560 VDD.n131 VDD.n127 0.0128596
R561 VDD.n32 VDD.n126 0.0238578
R562 VDD.n337 VDD.n67 0.0567665
R563 VDD.n268 VDD.n24 0.0231161
R564 VDD.n141 VDD.n140 0.0127342
R565 VDD.n181 VDD.n58 0.0982002
R566 VDD.n194 VDD.n193 0.0126294
R567 VDD.n36 VDD.n66 0.161815
R568 VDD.n105 VDD.n77 0.11115
R569 VDD.n48 VDD.n47 0.0122706
R570 VDD.n161 VDD.n153 0.0121954
R571 VDD.n201 VDD.n200 0.0120821
R572 VDD.n252 VDD.n244 0.0120638
R573 VDD.n51 VDD.n50 0.00671437
R574 VDD.n141 VDD.n29 0.0235779
R575 VDD.n31 VDD.n30 0.00655998
R576 VDD.n258 VDD.n231 0.0115638
R577 VDD.n196 VDD.n195 0.0115348
R578 VDD.n251 VDD.n243 0.0114255
R579 VDD.n142 VDD.n106 0.0113146
R580 VDD.n114 VDD.n19 0.0260047
R581 VDD.n199 VDD.n198 0.0112612
R582 VDD.n86 VDD.n81 0.0111667
R583 VDD.n253 VDD.n242 0.011
R584 VDD.n246 VDD.n232 0.0109255
R585 VDD.n198 VDD.n197 0.0107139
R586 VDD.n20 VDD.n19 0.00572767
R587 VDD.n257 VDD.n233 0.0105
R588 VDD.n197 VDD.n196 0.0104403
R589 VDD.n135 VDD.n103 0.0103876
R590 VDD.n131 VDD.n30 0.0164476
R591 VDD.n250 VDD.n241 0.0103617
R592 VDD.n157 VDD.n147 0.0102989
R593 VDD.n320 VDD.n286 0.0101905
R594 VDD.n92 VDD.n88 0.0101375
R595 VDD.n254 VDD.n240 0.00993617
R596 VDD.n200 VDD.n199 0.00989303
R597 VDD.n247 VDD.n234 0.0098617
R598 VDD.n159 VDD.n149 0.00966667
R599 VDD.n115 VDD.n112 0.00946067
R600 VDD.n256 VDD.n235 0.00943617
R601 VDD.n336 VDD.n335 0.00940476
R602 VDD.n10 VDD.n9 0.00490215
R603 VDD.n195 VDD.n194 0.00934577
R604 VDD.n249 VDD.n239 0.00919149
R605 VDD.n82 VDD.n80 0.00916667
R606 VDD.n272 VDD.n50 0.0153661
R607 VDD.n135 VDD.n127 0.00915169
R608 VDD.n134 VDD.n126 0.00915169
R609 VDD.n112 VDD.n100 0.00915169
R610 VDD.n202 VDD.n201 0.00907214
R611 VDD.n248 VDD.n236 0.00879787
R612 VDD.n293 VDD.n292 0.00863858
R613 VDD.n193 VDD.n192 0.00852488
R614 VDD.n204 VDD.n203 0.00825124
R615 VDD.n176 VDD.n175 0.00818675
R616 VDD.n249 VDD.n238 0.00815957
R617 VDD.n255 VDD.n238 0.00815957
R618 VDD.n255 VDD.n237 0.00815957
R619 VDD.n94 VDD.n93 0.0081435
R620 VDD.n174 VDD.n169 0.00796104
R621 VDD.n248 VDD.n237 0.00794681
R622 VDD.n266 VDD.n223 0.00791573
R623 VDD.n139 VDD.n106 0.00791573
R624 VDD.n130 VDD.n128 0.00791573
R625 VDD.n132 VDD.n125 0.00791573
R626 VDD.n254 VDD.n239 0.00791489
R627 VDD.n316 VDD.n287 0.00787469
R628 VDD.n155 VDD.n151 0.00777011
R629 VDD.n191 VDD.n190 0.00770398
R630 VDD.n61 VDD.n113 0.0189136
R631 VDD.n250 VDD.n240 0.00738298
R632 VDD.n326 VDD.n76 0.0296298
R633 VDD.n256 VDD.n236 0.00730851
R634 VDD.n206 VDD.n205 0.00715672
R635 VDD.n175 VDD.n62 0.00696385
R636 VDD.n189 VDD.n188 0.00688308
R637 VDD.n247 VDD.n235 0.00688298
R638 VDD.n83 VDD.n79 0.00683333
R639 VDD.n253 VDD.n241 0.00674468
R640 VDD.n133 VDD.n124 0.00667978
R641 VDD.n183 VDD.n15 0.128297
R642 VDD.n143 VDD.n55 0.0144376
R643 VDD.n136 VDD.n129 0.00637079
R644 VDD.n208 VDD.n207 0.00633582
R645 VDD.n251 VDD.n242 0.00631915
R646 VDD.n319 VDD.n69 0.0062619
R647 VDD.n37 VDD.n36 0.043971
R648 VDD.n257 VDD.n234 0.00624468
R649 VDD.n187 VDD.n186 0.00606219
R650 VDD.n182 VDD.n168 0.00590541
R651 VDD.n246 VDD.n233 0.00581915
R652 VDD.n90 VDD.n89 0.00581722
R653 VDD.n252 VDD.n243 0.00568085
R654 VDD.n210 VDD.n209 0.00551492
R655 VDD.n267 VDD.n221 0.00544382
R656 VDD.t18 VDD.n120 0.00544382
R657 VDD.n173 VDD.n172 0.00536486
R658 VDD.n258 VDD.n232 0.00518085
R659 VDD.n259 VDD.n244 0.00504255
R660 VDD.n185 VDD.n184 0.00496766
R661 VDD.t42 VDD.n3 3.39762
R662 VDD.n142 VDD.n138 0.00482584
R663 VDD.n245 VDD.n231 0.00475532
R664 VDD.n171 VDD.n170 0.00455405
R665 VDD.n116 VDD.n111 0.00451685
R666 VDD.n85 VDD.n78 0.0045
R667 VDD.n26 VDD.n220 0.0152061
R668 VDD.n128 VDD.n103 0.00420787
R669 VDD.n271 VDD.n270 0.00389888
R670 VDD.n117 VDD.n60 0.0128918
R671 VDD.n114 VDD.n100 0.00389888
R672 VDD.t0 VDD.n1 0.338828
R673 VDD.n91 VDD.n87 0.00349094
R674 VDD.n270 VDD.n222 0.0032809
R675 VDD.n144 VDD.n139 0.0032809
R676 VDD.n42 VDD.n62 0.0505925
R677 VDD.n323 VDD.n65 0.0254394
R678 VDD.t15 VDD.n2 1.52906
R679 VDD VDD.t49 0.0005
R680 GND.n252 GND.n1156 42224.4
R681 GND.n1156 GND.n259 9488.45
R682 GND.n259 GND.n242 4891.08
R683 GND.n1156 GND.n245 2622.92
R684 GND.n245 GND.n714 1878.12
R685 GND.n250 GND.n248 6919.81
R686 GND.t26 GND.n92 15.0048
R687 GND.n92 GND.n714 88.3926
R688 GND.t27 GND.n92 34.3918
R689 GND.n1211 GND.t8 54.5772
R690 GND.n92 GND.t23 15.6876
R691 GND.n248 GND.t30 15.4347
R692 GND.n248 GND.t36 16.4394
R693 GND.n242 GND.n246 1.22096
R694 GND.t57 GND.n242 7.25361
R695 GND.n248 GND.n259 215.685
R696 GND.n188 GND.n185 0.773811
R697 GND.n242 GND.n245 22.0629
R698 GND.t47 GND.n251 4.34084
R699 GND.n240 GND.t21 22.4898
R700 GND.n189 GND.t41 17.4841
R701 GND.t28 GND.n98 8.49297
R702 GND.n98 GND.n97 0.0178949
R703 GND.t28 GND.n1159 17.0005
R704 GND.t28 GND.n95 8.49312
R705 GND.n94 GND.n95 0.0167631
R706 GND.n248 GND.n668 17.0005
R707 GND.n248 GND.n669 17.0005
R708 GND.n248 GND.n670 17.0005
R709 GND.n248 GND.n671 17.0005
R710 GND.n248 GND.n672 17.0005
R711 GND.n248 GND.n673 17.0005
R712 GND.n248 GND.n674 17.0005
R713 GND.n248 GND.n675 17.0005
R714 GND.n248 GND.n65 1.23219
R715 GND.n248 GND.n261 17.0005
R716 GND.n242 GND.n243 0.491039
R717 GND.n248 GND.n694 17.0005
R718 GND.n248 GND.n693 17.0005
R719 GND.n248 GND.n692 17.0005
R720 GND.n248 GND.n691 17.0005
R721 GND.n248 GND.n690 17.0005
R722 GND.n248 GND.n689 17.0005
R723 GND.n248 GND.n688 17.0005
R724 GND.n248 GND.n687 17.0005
R725 GND.n248 GND.n686 17.0005
R726 GND.n248 GND.n685 17.0005
R727 GND.n248 GND.n684 17.0005
R728 GND.n248 GND.n683 17.0005
R729 GND.n248 GND.n682 17.0005
R730 GND.n248 GND.n681 17.0005
R731 GND.n248 GND.n680 17.0005
R732 GND.n248 GND.n679 17.0005
R733 GND.n248 GND.n678 17.0005
R734 GND.n248 GND.n677 17.0005
R735 GND.n248 GND.n676 17.0005
R736 GND.t37 GND.n260 17.0005
R737 GND.t37 GND.n695 17.0005
R738 GND.t37 GND.n696 17.0005
R739 GND.t37 GND.n697 17.0005
R740 GND.t37 GND.n698 17.0005
R741 GND.t37 GND.n699 17.0005
R742 GND.t37 GND.n700 17.0005
R743 GND.t37 GND.n701 17.0005
R744 GND.t37 GND.n702 17.0005
R745 GND.t37 GND.n703 17.0005
R746 GND.t37 GND.n705 17.0005
R747 GND.t37 GND.n706 17.0005
R748 GND.t37 GND.n707 17.0005
R749 GND.t37 GND.n708 17.0005
R750 GND.t37 GND.n709 17.0005
R751 GND.t37 GND.n710 17.0005
R752 GND.t37 GND.n711 17.0005
R753 GND.t37 GND.n712 17.0005
R754 GND.n713 GND.t37 17.0005
R755 GND.t39 GND.n839 17.0005
R756 GND.t39 GND.n840 17.0005
R757 GND.t39 GND.n841 17.0005
R758 GND.t39 GND.n842 17.0005
R759 GND.t39 GND.n843 17.0005
R760 GND.t39 GND.n844 17.0005
R761 GND.t39 GND.n845 17.0005
R762 GND.t39 GND.n846 17.0005
R763 GND.t39 GND.n66 1.25679
R764 GND.n240 GND.t54 2.67346
R765 GND.t43 GND.n79 4.23034
R766 GND.t43 GND.n164 17.0005
R767 GND.t43 GND.n733 17.0005
R768 GND.n79 GND.n78 0.0232801
R769 GND.n734 GND.t43 17.0005
R770 GND.n240 GND.t44 4.43471
R771 GND.n251 GND.n240 0.400267
R772 GND.n248 GND.t34 8.59664
R773 GND.n187 GND.n254 13.0963
R774 GND.n186 GND.n255 12.5784
R775 GND.n1033 GND.t22 9.3925
R776 GND.n265 GND.n182 0.132831
R777 GND.n182 GND.n181 1.09765
R778 GND.n266 GND.n180 2.23712
R779 GND.n267 GND.n179 2.23712
R780 GND.n268 GND.n178 2.23712
R781 GND.n269 GND.n177 2.23712
R782 GND.n270 GND.n176 2.23712
R783 GND.n271 GND.n175 2.23712
R784 GND.n272 GND.n174 2.23712
R785 GND.n273 GND.n173 2.23712
R786 GND.n274 GND.n172 2.23712
R787 GND.n275 GND.n171 2.23712
R788 GND.n168 GND.n167 0.859335
R789 GND.n277 GND.n276 2.23712
R790 GND.n279 GND.n278 2.23712
R791 GND.n281 GND.n280 2.23712
R792 GND.n283 GND.n282 2.23712
R793 GND.n285 GND.n284 2.23712
R794 GND.n287 GND.n286 2.23712
R795 GND.n289 GND.n288 2.23712
R796 GND.n291 GND.n290 2.23712
R797 GND.n293 GND.n292 2.23712
R798 GND.n295 GND.n294 2.23712
R799 GND.n297 GND.n296 2.23712
R800 GND.n299 GND.n298 2.23712
R801 GND.n301 GND.n300 2.23712
R802 GND.n303 GND.n302 2.23712
R803 GND.n305 GND.n304 2.23712
R804 GND.n307 GND.n306 2.23712
R805 GND.n309 GND.n308 2.23712
R806 GND.n312 GND.n311 0.221874
R807 GND.n7 GND.n313 0.493109
R808 GND.n170 GND.n234 0.857366
R809 GND.n169 GND.n233 1.09157
R810 GND.n231 GND.n232 1.09157
R811 GND.n229 GND.n230 1.09157
R812 GND.n227 GND.n228 1.09157
R813 GND.n225 GND.n226 1.09157
R814 GND.n223 GND.n224 1.09157
R815 GND.n221 GND.n222 1.09157
R816 GND.n219 GND.n220 1.09157
R817 GND.n217 GND.n218 1.09157
R818 GND.n215 GND.n216 1.09157
R819 GND.n213 GND.n214 1.09157
R820 GND.n211 GND.n212 1.09157
R821 GND.n209 GND.n210 1.09157
R822 GND.n207 GND.n208 1.09157
R823 GND.n205 GND.n206 1.09157
R824 GND.n203 GND.n204 1.09157
R825 GND.n201 GND.n202 1.09157
R826 GND.n199 GND.n200 1.09157
R827 GND.n197 GND.n198 1.09157
R828 GND.n195 GND.n196 1.09157
R829 GND.n193 GND.n194 1.09157
R830 GND.n191 GND.n192 0.260175
R831 GND.n237 GND.n238 0.100154
R832 GND.n238 GND.n868 0.477577
R833 GND.n1167 GND.n666 9.0005
R834 GND.n1172 GND.n1167 9.0005
R835 GND.n1172 GND.n1166 9.0005
R836 GND.n1172 GND.n1171 9.0005
R837 GND.n1154 GND.n717 9.0005
R838 GND.n333 GND.n1305 2.25851
R839 GND.n318 GND.t2 1.3026
R840 GND.t2 GND.n461 2.22244
R841 GND.n69 GND.n1274 2.25851
R842 GND.n63 GND.t4 1.13737
R843 GND.t6 GND.n331 1.3026
R844 GND.n320 GND.t6 1.3026
R845 GND.n190 GND.n1158 0.680805
R846 GND.n1154 GND.n242 8.51119
R847 GND.n1157 GND.n92 3.40102
R848 GND.t56 GND.n242 8.501
R849 GND.n97 GND.n92 0.541885
R850 GND.n1160 GND.n92 8.5009
R851 GND.n240 GND.n77 1.68581
R852 GND.n240 GND.n722 8.50088
R853 GND.n240 GND.n163 4.23937
R854 GND.n188 GND.n775 8.50081
R855 GND.n728 GND.n240 8.50081
R856 GND.n93 GND.n92 0.0773154
R857 GND.n240 GND.n718 8.50062
R858 GND.n1153 GND.n242 8.50062
R859 GND.n92 GND.t24 3.39911
R860 GND.n188 GND.n262 8.5005
R861 GND.n240 GND.n1148 8.5005
R862 GND.n250 GND.n240 41.3481
R863 GND.t42 GND.n240 4.22588
R864 GND.t29 GND.n251 7.53674
R865 GND.t49 GND.n240 5.72235
R866 GND.n1149 GND.n240 8.5005
R867 GND.n240 GND.n185 1.87922
R868 GND.n240 GND.t52 6.96506
R869 GND.n240 GND.n252 0.134913
R870 GND.n246 GND.t55 10.2463
R871 GND.n188 GND.n782 8.50043
R872 GND.n188 GND.n780 8.50024
R873 GND.n188 GND.n774 8.49966
R874 GND.n188 GND.n776 8.49966
R875 GND.t37 GND.n704 8.49218
R876 GND.n249 GND.n248 0.00127252
R877 GND.n249 GND.n260 1.4386
R878 GND.n248 GND.n667 8.4689
R879 GND.n254 GND.n240 3.70839
R880 GND.n255 GND.n240 3.63949
R881 GND.n256 GND.n240 3.57311
R882 GND.n257 GND.n240 3.5091
R883 GND.n258 GND.n240 3.44734
R884 GND.t53 GND.n185 10.0625
R885 GND.n777 GND.n256 8.85388
R886 GND.n714 GND.n246 159.98
R887 GND.n1151 GND.n1150 4.55958
R888 GND.n1147 GND.n729 4.55917
R889 GND.n1150 GND.n1149 4.50967
R890 GND.n1148 GND.n1147 4.50967
R891 GND.n1036 GND.n1035 4.5005
R892 GND.n1037 GND.n765 4.5005
R893 GND.n1039 GND.n1038 4.5005
R894 GND.n1040 GND.n764 4.5005
R895 GND.n1042 GND.n1041 4.5005
R896 GND.n1043 GND.n763 4.5005
R897 GND.n1045 GND.n1044 4.5005
R898 GND.n1046 GND.n762 4.5005
R899 GND.n1048 GND.n1047 4.5005
R900 GND.n1049 GND.n761 4.5005
R901 GND.n1051 GND.n1050 4.5005
R902 GND.n1052 GND.n760 4.5005
R903 GND.n1054 GND.n1053 4.5005
R904 GND.n1055 GND.n759 4.5005
R905 GND.n1057 GND.n1056 4.5005
R906 GND.n1058 GND.n758 4.5005
R907 GND.n1060 GND.n1059 4.5005
R908 GND.n1061 GND.n757 4.5005
R909 GND.n1063 GND.n1062 4.5005
R910 GND.n1064 GND.n756 4.5005
R911 GND.n1066 GND.n1065 4.5005
R912 GND.n1067 GND.n755 4.5005
R913 GND.n1069 GND.n1068 4.5005
R914 GND.n1070 GND.n754 4.5005
R915 GND.n1072 GND.n1071 4.5005
R916 GND.n1073 GND.n753 4.5005
R917 GND.n1075 GND.n1074 4.5005
R918 GND.n1076 GND.n752 4.5005
R919 GND.n1078 GND.n1077 4.5005
R920 GND.n1079 GND.n751 4.5005
R921 GND.n1081 GND.n1080 4.5005
R922 GND.n1082 GND.n750 4.5005
R923 GND.n1084 GND.n1083 4.5005
R924 GND.n1085 GND.n749 4.5005
R925 GND.n1087 GND.n1086 4.5005
R926 GND.n1088 GND.n748 4.5005
R927 GND.n1090 GND.n1089 4.5005
R928 GND.n1091 GND.n747 4.5005
R929 GND.n1093 GND.n1092 4.5005
R930 GND.n1094 GND.n746 4.5005
R931 GND.n1096 GND.n1095 4.5005
R932 GND.n1097 GND.n745 4.5005
R933 GND.n1099 GND.n1098 4.5005
R934 GND.n1100 GND.n744 4.5005
R935 GND.n1102 GND.n1101 4.5005
R936 GND.n1103 GND.n743 4.5005
R937 GND.n1105 GND.n1104 4.5005
R938 GND.n1106 GND.n742 4.5005
R939 GND.n1108 GND.n1107 4.5005
R940 GND.n1109 GND.n741 4.5005
R941 GND.n1111 GND.n1110 4.5005
R942 GND.n1112 GND.n740 4.5005
R943 GND.n1114 GND.n1113 4.5005
R944 GND.n1115 GND.n739 4.5005
R945 GND.n1117 GND.n1116 4.5005
R946 GND.n1118 GND.n738 4.5005
R947 GND.n1120 GND.n1119 4.5005
R948 GND.n1121 GND.n737 4.5005
R949 GND.n1123 GND.n1122 4.5005
R950 GND.n1124 GND.n736 4.5005
R951 GND.n1126 GND.n1125 4.5005
R952 GND.n1128 GND.n732 4.5005
R953 GND.n1130 GND.n1129 4.5005
R954 GND.n1132 GND.n1131 4.5005
R955 GND.n1133 GND.n730 4.5005
R956 GND.n1136 GND.n1135 4.5005
R957 GND.n1137 GND.n158 4.5005
R958 GND.n159 GND.n1146 4.5005
R959 GND.n1145 GND.n157 4.5005
R960 GND.n1144 GND.n1143 4.5005
R961 GND.n1142 GND.n1138 4.5005
R962 GND.n1141 GND.n1140 4.5005
R963 GND.n1139 GND.n265 4.5005
R964 GND.n869 GND.n236 4.5005
R965 GND.n871 GND.n870 4.5005
R966 GND.n872 GND.n831 4.5005
R967 GND.n874 GND.n873 4.5005
R968 GND.n875 GND.n830 4.5005
R969 GND.n877 GND.n876 4.5005
R970 GND.n878 GND.n829 4.5005
R971 GND.n880 GND.n879 4.5005
R972 GND.n881 GND.n828 4.5005
R973 GND.n883 GND.n882 4.5005
R974 GND.n884 GND.n827 4.5005
R975 GND.n886 GND.n885 4.5005
R976 GND.n887 GND.n826 4.5005
R977 GND.n889 GND.n888 4.5005
R978 GND.n890 GND.n825 4.5005
R979 GND.n892 GND.n891 4.5005
R980 GND.n893 GND.n824 4.5005
R981 GND.n895 GND.n894 4.5005
R982 GND.n896 GND.n823 4.5005
R983 GND.n898 GND.n897 4.5005
R984 GND.n899 GND.n822 4.5005
R985 GND.n901 GND.n900 4.5005
R986 GND.n902 GND.n821 4.5005
R987 GND.n904 GND.n903 4.5005
R988 GND.n905 GND.n820 4.5005
R989 GND.n907 GND.n906 4.5005
R990 GND.n908 GND.n819 4.5005
R991 GND.n910 GND.n909 4.5005
R992 GND.n911 GND.n818 4.5005
R993 GND.n913 GND.n912 4.5005
R994 GND.n914 GND.n817 4.5005
R995 GND.n916 GND.n915 4.5005
R996 GND.n917 GND.n816 4.5005
R997 GND.n919 GND.n918 4.5005
R998 GND.n920 GND.n815 4.5005
R999 GND.n922 GND.n921 4.5005
R1000 GND.n923 GND.n814 4.5005
R1001 GND.n925 GND.n924 4.5005
R1002 GND.n926 GND.n813 4.5005
R1003 GND.n928 GND.n927 4.5005
R1004 GND.n929 GND.n812 4.5005
R1005 GND.n931 GND.n930 4.5005
R1006 GND.n932 GND.n811 4.5005
R1007 GND.n934 GND.n933 4.5005
R1008 GND.n935 GND.n810 4.5005
R1009 GND.n937 GND.n936 4.5005
R1010 GND.n938 GND.n809 4.5005
R1011 GND.n940 GND.n939 4.5005
R1012 GND.n941 GND.n808 4.5005
R1013 GND.n943 GND.n942 4.5005
R1014 GND.n944 GND.n807 4.5005
R1015 GND.n946 GND.n945 4.5005
R1016 GND.n947 GND.n806 4.5005
R1017 GND.n949 GND.n948 4.5005
R1018 GND.n950 GND.n805 4.5005
R1019 GND.n952 GND.n951 4.5005
R1020 GND.n953 GND.n804 4.5005
R1021 GND.n955 GND.n954 4.5005
R1022 GND.n956 GND.n803 4.5005
R1023 GND.n958 GND.n957 4.5005
R1024 GND.n959 GND.n802 4.5005
R1025 GND.n961 GND.n960 4.5005
R1026 GND.n962 GND.n801 4.5005
R1027 GND.n964 GND.n963 4.5005
R1028 GND.n965 GND.n800 4.5005
R1029 GND.n967 GND.n966 4.5005
R1030 GND.n968 GND.n799 4.5005
R1031 GND.n970 GND.n969 4.5005
R1032 GND.n971 GND.n798 4.5005
R1033 GND.n973 GND.n972 4.5005
R1034 GND.n974 GND.n797 4.5005
R1035 GND.n976 GND.n975 4.5005
R1036 GND.n977 GND.n796 4.5005
R1037 GND.n979 GND.n978 4.5005
R1038 GND.n980 GND.n795 4.5005
R1039 GND.n982 GND.n981 4.5005
R1040 GND.n983 GND.n794 4.5005
R1041 GND.n985 GND.n984 4.5005
R1042 GND.n986 GND.n793 4.5005
R1043 GND.n988 GND.n987 4.5005
R1044 GND.n989 GND.n792 4.5005
R1045 GND.n991 GND.n990 4.5005
R1046 GND.n992 GND.n791 4.5005
R1047 GND.n994 GND.n993 4.5005
R1048 GND.n995 GND.n790 4.5005
R1049 GND.n997 GND.n996 4.5005
R1050 GND.n998 GND.n789 4.5005
R1051 GND.n1000 GND.n999 4.5005
R1052 GND.n1001 GND.n788 4.5005
R1053 GND.n1003 GND.n1002 4.5005
R1054 GND.n1004 GND.n787 4.5005
R1055 GND.n1006 GND.n1005 4.5005
R1056 GND.n1007 GND.n786 4.5005
R1057 GND.n1009 GND.n1008 4.5005
R1058 GND.n1010 GND.n785 4.5005
R1059 GND.n1012 GND.n1011 4.5005
R1060 GND.n1013 GND.n784 4.5005
R1061 GND.n1015 GND.n1014 4.5005
R1062 GND.n1016 GND.n783 4.5005
R1063 GND.n1018 GND.n1017 4.5005
R1064 GND.n1019 GND.n773 4.5005
R1065 GND.n1022 GND.n1021 4.5005
R1066 GND.n1024 GND.n1023 4.5005
R1067 GND.n1027 GND.n768 4.5005
R1068 GND.n1030 GND.n1029 4.5005
R1069 GND.n1032 GND.n1031 4.5005
R1070 GND.n162 GND.n160 4.5005
R1071 GND.n170 GND.n1034 4.5005
R1072 GND.n852 GND.n837 4.5005
R1073 GND.n854 GND.n853 4.5005
R1074 GND.n855 GND.n836 4.5005
R1075 GND.n857 GND.n856 4.5005
R1076 GND.n858 GND.n835 4.5005
R1077 GND.n860 GND.n859 4.5005
R1078 GND.n861 GND.n834 4.5005
R1079 GND.n863 GND.n862 4.5005
R1080 GND.n864 GND.n833 4.5005
R1081 GND.n866 GND.n865 4.5005
R1082 GND.n867 GND.n832 4.5005
R1083 GND.n235 GND.n868 4.5005
R1084 GND.n1166 GND.n1164 4.5005
R1085 GND.n1167 GND.n1165 4.5005
R1086 GND.n1175 GND.n1174 4.5005
R1087 GND.n1171 GND.n1170 4.5005
R1088 GND.n1164 GND.n1162 4.5005
R1089 GND.n1165 GND.n1163 4.5005
R1090 GND.n1176 GND.n1175 4.5005
R1091 GND.n1170 GND.n1169 4.5005
R1092 GND.n1162 GND.n1161 4.5005
R1093 GND.n1177 GND.n1176 4.5005
R1094 GND.n1163 GND.n94 4.5005
R1095 GND.t2 GND.n319 1.79831
R1096 GND.t2 GND.n334 1.79831
R1097 GND.t6 GND.n473 4.49686
R1098 GND.t6 GND.n370 1.12175
R1099 GND.n1174 GND.n1173 4.49509
R1100 GND.n1168 GND.n666 4.48628
R1101 GND.n240 GND.t50 7.06285
R1102 GND.n94 GND.n93 0.529093
R1103 GND.n240 GND.n721 4.23682
R1104 GND.t40 GND.n257 5.64502
R1105 GND.n188 GND.n778 4.11744
R1106 GND.n188 GND.n777 3.93187
R1107 GND.n188 GND.n779 3.93183
R1108 GND.n258 GND.t53 15.6114
R1109 GND.n779 GND.n257 23.0243
R1110 GND.n726 GND.t45 3.1972
R1111 GND.n724 GND.t48 3.1972
R1112 GND.n241 GND.t51 3.47635
R1113 GND.n1157 GND.n717 3.16936
R1114 GND.n778 GND.n256 20.1019
R1115 GND.n1186 GND.n1183 3.01808
R1116 GND.n1200 GND.n1199 3.0093
R1117 GND.n586 GND.n585 3.00929
R1118 GND.n566 GND.n526 3.00929
R1119 GND.n608 GND.n607 3.00929
R1120 GND.n588 GND.n513 3.00929
R1121 GND.n630 GND.n629 3.00929
R1122 GND.n610 GND.n499 3.00929
R1123 GND.n567 GND.n566 3.0005
R1124 GND.n568 GND.n528 3.0005
R1125 GND.n570 GND.n569 3.0005
R1126 GND.n525 GND.n524 3.0005
R1127 GND.n574 GND.n573 3.0005
R1128 GND.n575 GND.n523 3.0005
R1129 GND.n522 GND.n521 3.0005
R1130 GND.n580 GND.n579 3.0005
R1131 GND.n581 GND.n520 3.0005
R1132 GND.n583 GND.n582 3.0005
R1133 GND.n517 GND.n516 3.0005
R1134 GND.n589 GND.n588 3.0005
R1135 GND.n590 GND.n515 3.0005
R1136 GND.n592 GND.n591 3.0005
R1137 GND.n512 GND.n511 3.0005
R1138 GND.n596 GND.n595 3.0005
R1139 GND.n597 GND.n510 3.0005
R1140 GND.n508 GND.n507 3.0005
R1141 GND.n602 GND.n601 3.0005
R1142 GND.n603 GND.n506 3.0005
R1143 GND.n605 GND.n604 3.0005
R1144 GND.n503 GND.n502 3.0005
R1145 GND.n611 GND.n610 3.0005
R1146 GND.n612 GND.n501 3.0005
R1147 GND.n614 GND.n613 3.0005
R1148 GND.n498 GND.n497 3.0005
R1149 GND.n618 GND.n617 3.0005
R1150 GND.n619 GND.n496 3.0005
R1151 GND.n495 GND.n494 3.0005
R1152 GND.n624 GND.n623 3.0005
R1153 GND.n625 GND.n493 3.0005
R1154 GND.n627 GND.n626 3.0005
R1155 GND.n490 GND.n489 3.0005
R1156 GND.n1201 GND.n1200 3.0005
R1157 GND.n1202 GND.n488 3.0005
R1158 GND.n1204 GND.n1203 3.0005
R1159 GND.n1205 GND.n484 3.0005
R1160 GND.n1207 GND.n1206 3.0005
R1161 GND.n1208 GND.n482 3.0005
R1162 GND.n483 GND.n481 3.0005
R1163 GND.n1193 GND.n1192 3.0005
R1164 GND.n1191 GND.n1182 3.0005
R1165 GND.n1190 GND.n1189 3.0005
R1166 GND.n587 GND.n586 3.0005
R1167 GND.n609 GND.n608 3.0005
R1168 GND.n631 GND.n630 3.0005
R1169 GND.n632 GND.n488 3.0005
R1170 GND.n1204 GND.n487 3.0005
R1171 GND.n1205 GND.n486 3.0005
R1172 GND.n1206 GND.n485 3.0005
R1173 GND.n482 GND.n480 3.0005
R1174 GND.n481 GND.n151 3.0005
R1175 GND.n1194 GND.n1193 3.0005
R1176 GND.n1182 GND.n1181 3.0005
R1177 GND.n1189 GND.n1188 3.0005
R1178 GND.n1185 GND.n1184 3.0005
R1179 GND.n1198 GND.n487 3.0005
R1180 GND.n1197 GND.n486 3.0005
R1181 GND.n1196 GND.n485 3.0005
R1182 GND.n1195 GND.n480 3.0005
R1183 GND.t8 GND.n123 0.562241
R1184 GND.n125 GND.n1194 3.0005
R1185 GND.n1181 GND.n1180 3.0005
R1186 GND.n1188 GND.n1187 3.0005
R1187 GND.n1284 GND.n319 0.00450749
R1188 GND.t2 GND.n325 1.12175
R1189 GND.n382 GND.t2 1.12175
R1190 GND.n1279 GND.n382 0.010059
R1191 GND.t2 GND.n369 1.12175
R1192 GND.n1299 GND.n369 0.010059
R1193 GND.n1300 GND.n334 0.00450749
R1194 GND.t2 GND.n317 1.49687
R1195 GND.n317 GND.n323 0.00925955
R1196 GND.n572 GND.n326 0.00925955
R1197 GND.t2 GND.n326 1.49687
R1198 GND.n315 GND.n380 0.0151318
R1199 GND.n578 GND.n367 0.00925955
R1200 GND.n367 GND.t2 1.49687
R1201 GND.t2 GND.n584 3.0005
R1202 GND.n528 GND.n527 3.0005
R1203 GND.n571 GND.n570 3.0005
R1204 GND.n323 GND.n525 3.0005
R1205 GND.n573 GND.n572 3.0005
R1206 GND.n523 GND.n329 3.0005
R1207 GND.n380 GND.n522 3.0005
R1208 GND.n579 GND.n578 3.0005
R1209 GND.n520 GND.n519 3.0005
R1210 GND.n584 GND.n583 3.0005
R1211 GND.n518 GND.n517 3.0005
R1212 GND.n64 GND.t4 1.12175
R1213 GND.t4 GND.n80 1.12175
R1214 GND.n1260 GND.n80 0.0104363
R1215 GND.n76 GND.n466 0.00956254
R1216 GND.n71 GND.t4 1.12175
R1217 GND.n70 GND.t4 1.79831
R1218 GND.t4 GND.n1 1.49687
R1219 GND.n1 GND.n2 0.00925955
R1220 GND.n594 GND.n3 0.00925955
R1221 GND.n3 GND.t4 1.49687
R1222 GND.n600 GND.n4 0.00925955
R1223 GND.n4 GND.t4 1.49687
R1224 GND.t4 GND.n606 3.0005
R1225 GND.n515 GND.n514 3.0005
R1226 GND.n593 GND.n592 3.0005
R1227 GND.n2 GND.n512 3.0005
R1228 GND.n595 GND.n594 3.0005
R1229 GND.n510 GND.n509 3.0005
R1230 GND.n5 GND.n508 3.0005
R1231 GND.n601 GND.n600 3.0005
R1232 GND.n506 GND.n505 3.0005
R1233 GND.n606 GND.n605 3.0005
R1234 GND.n504 GND.n503 3.0005
R1235 GND.n321 GND.t6 1.27347
R1236 GND.n321 GND.n471 0.00802601
R1237 GND.n324 GND.n1228 0.010059
R1238 GND.n324 GND.t6 1.12175
R1239 GND.n383 GND.t6 1.12175
R1240 GND.n1237 GND.n370 0.010059
R1241 GND.n330 GND.t6 1.79831
R1242 GND.t6 GND.n316 1.49687
R1243 GND.n316 GND.n322 0.00925955
R1244 GND.n616 GND.n327 0.00925955
R1245 GND.t6 GND.n327 1.49687
R1246 GND.n314 GND.n381 0.0151318
R1247 GND.n622 GND.n368 0.00925955
R1248 GND.n368 GND.t6 1.49687
R1249 GND.t6 GND.n628 3.0005
R1250 GND.n501 GND.n500 3.0005
R1251 GND.n615 GND.n614 3.0005
R1252 GND.n322 GND.n498 3.0005
R1253 GND.n617 GND.n616 3.0005
R1254 GND.n496 GND.n328 3.0005
R1255 GND.n381 GND.n495 3.0005
R1256 GND.n623 GND.n622 3.0005
R1257 GND.n493 GND.n492 3.0005
R1258 GND.n628 GND.n627 3.0005
R1259 GND.n491 GND.n490 3.0005
R1260 GND.n239 GND.t59 2.88567
R1261 GND.n162 GND.n262 2.87922
R1262 GND.n1026 GND.n770 2.86394
R1263 GND.n56 GND.n850 2.83988
R1264 GND.n1134 GND.n731 2.83257
R1265 GND.n78 GND.n96 2.83157
R1266 GND.n1127 GND.n735 2.83157
R1267 GND.n56 GND.n851 2.81238
R1268 GND.n56 GND.n849 2.81238
R1269 GND.n56 GND.n847 2.81238
R1270 GND.n67 GND.n846 0.147167
R1271 GND.n56 GND.n67 0.334388
R1272 GND.n67 GND.n66 0.127956
R1273 GND.n56 GND.n838 2.81238
R1274 GND.n1020 GND.n184 2.81771
R1275 GND.n56 GND.n1179 2.78217
R1276 GND.n161 GND.n766 2.77717
R1277 GND.n781 GND.n767 2.77717
R1278 GND.n1028 GND.n769 2.77717
R1279 GND.n1025 GND.n771 2.77717
R1280 GND.n183 GND.n772 2.77717
R1281 GND.n777 GND.n255 17.0961
R1282 GND.n56 GND.n848 2.72717
R1283 GND.n186 GND.n254 13.022
R1284 GND.n643 GND.n642 2.26806
R1285 GND.n1212 GND.n1211 2.2505
R1286 GND.n479 GND.n478 2.2505
R1287 GND.n656 GND.n655 2.2505
R1288 GND.n657 GND.n652 2.2505
R1289 GND.n659 GND.n658 2.2505
R1290 GND.n634 GND.t8 2.2505
R1291 GND.n143 GND.n665 0.00925198
R1292 GND.n143 GND.t8 1.12187
R1293 GND.n646 GND.n645 2.2505
R1294 GND.n644 GND.n639 2.2505
R1295 GND.n1213 GND.n1212 2.2505
R1296 GND.n478 GND.n477 2.2505
R1297 GND.n655 GND.n654 2.2505
R1298 GND.n652 GND.n651 2.2505
R1299 GND.n660 GND.n659 2.2505
R1300 GND.n636 GND.n634 2.2505
R1301 GND.n665 GND.n664 2.2505
R1302 GND.n635 GND.n633 2.2505
R1303 GND.n647 GND.n646 2.2505
R1304 GND.n639 GND.n638 2.2505
R1305 GND.n641 GND.n640 2.2505
R1306 GND.n638 GND.n637 2.2505
R1307 GND.n648 GND.n647 2.2505
R1308 GND.n649 GND.n635 2.2505
R1309 GND.n664 GND.n663 2.2505
R1310 GND.n662 GND.n636 2.2505
R1311 GND.n661 GND.n660 2.2505
R1312 GND.n651 GND.n650 2.2505
R1313 GND.n654 GND.n653 2.2505
R1314 GND.n477 GND.n476 2.2505
R1315 GND.n1214 GND.n1213 2.2505
R1316 GND.n1243 GND.n1242 2.2505
R1317 GND.n1241 GND.n475 2.2505
R1318 GND.n1240 GND.n1239 2.2505
R1319 GND.n1216 GND.n1215 2.2505
R1320 GND.n1235 GND.n1234 2.2505
R1321 GND.n1233 GND.n1218 2.2505
R1322 GND.n1232 GND.n1231 2.2505
R1323 GND.n1220 GND.n1219 2.2505
R1324 GND.n1227 GND.n1226 2.2505
R1325 GND.n1225 GND.n1221 2.2505
R1326 GND.n1224 GND.n1223 2.2505
R1327 GND.n470 GND.n469 2.2505
R1328 GND.n1274 GND.n1273 2.2505
R1329 GND.n1272 GND.n468 2.2505
R1330 GND.n1271 GND.n1270 2.2505
R1331 GND.n1247 GND.n1246 2.2505
R1332 GND.n1266 GND.n1265 2.2505
R1333 GND.n1264 GND.n1248 2.2505
R1334 GND.n1263 GND.n1262 2.2505
R1335 GND.n1250 GND.n1249 2.2505
R1336 GND.n1258 GND.n1257 2.2505
R1337 GND.n1256 GND.n1252 2.2505
R1338 GND.n1255 GND.n1254 2.2505
R1339 GND.n465 GND.n464 2.2505
R1340 GND.n1305 GND.n1304 2.2505
R1341 GND.n1303 GND.n463 2.2505
R1342 GND.n1302 GND.n1301 2.2505
R1343 GND.n1278 GND.n1277 2.2505
R1344 GND.n1297 GND.n1296 2.2505
R1345 GND.n1295 GND.n1280 2.2505
R1346 GND.n1294 GND.n1293 2.2505
R1347 GND.n1282 GND.n1281 2.2505
R1348 GND.n1289 GND.n1288 2.2505
R1349 GND.n1287 GND.n1283 2.2505
R1350 GND.n1286 GND.n1285 2.2505
R1351 GND.n460 GND.n459 2.2505
R1352 GND.n1245 GND.n1244 2.2505
R1353 GND.n1276 GND.n1275 2.2505
R1354 GND.n1307 GND.n1306 2.2505
R1355 GND.n462 GND.n460 2.2505
R1356 GND.n1285 GND.n1284 2.2505
R1357 GND.n1283 GND.n461 2.2505
R1358 GND.n1290 GND.n1289 2.2505
R1359 GND.n1291 GND.n1282 2.2505
R1360 GND.n1293 GND.n1292 2.2505
R1361 GND.n1280 GND.n1279 2.2505
R1362 GND.n1298 GND.n1297 2.2505
R1363 GND.n1299 GND.n1278 2.2505
R1364 GND.n1301 GND.n1300 2.2505
R1365 GND.n463 GND.n332 2.2505
R1366 GND.n467 GND.n465 2.2505
R1367 GND.n1254 GND.n1253 2.2505
R1368 GND.n1252 GND.n1251 2.2505
R1369 GND.n1259 GND.n1258 2.2505
R1370 GND.n1260 GND.n1250 2.2505
R1371 GND.n1262 GND.n1261 2.2505
R1372 GND.n1248 GND.n466 2.2505
R1373 GND.n1267 GND.n1266 2.2505
R1374 GND.n1268 GND.n1247 2.2505
R1375 GND.n1270 GND.n1269 2.2505
R1376 GND.n468 GND.n68 2.2505
R1377 GND.n472 GND.n470 2.2505
R1378 GND.n1223 GND.n1222 2.2505
R1379 GND.n1221 GND.n471 2.2505
R1380 GND.n1228 GND.n1227 2.2505
R1381 GND.n1229 GND.n1220 2.2505
R1382 GND.n1231 GND.n1230 2.2505
R1383 GND.n1218 GND.n1217 2.2505
R1384 GND.n1236 GND.n1235 2.2505
R1385 GND.n1237 GND.n1216 2.2505
R1386 GND.n1239 GND.n1238 2.2505
R1387 GND.n475 GND.n474 2.2505
R1388 GND.n76 GND.t4 1.12188
R1389 GND.t32 GND.n56 2.13021
R1390 GND.n124 GND.n60 2.11381
R1391 GND.n187 GND.n252 16.3451
R1392 GND.n92 GND.n250 252.895
R1393 GND.n1199 GND.n1198 1.52923
R1394 GND.n1187 GND.n1186 1.52923
R1395 GND.t2 GND.n333 1.3026
R1396 GND.t4 GND.n69 1.3026
R1397 GND.t2 GND.n526 1.52352
R1398 GND.n585 GND.t2 1.52352
R1399 GND.t4 GND.n513 1.52352
R1400 GND.n607 GND.t4 1.52352
R1401 GND.t6 GND.n499 1.52352
R1402 GND.n629 GND.t6 1.52352
R1403 GND.n1190 GND.n1183 1.51756
R1404 GND.n1337 GND.n1336 1.50925
R1405 GND.n449 GND.n456 1.50925
R1406 GND.n564 GND.n563 1.50925
R1407 GND.n548 GND.n452 1.50925
R1408 GND.n548 GND.n310 1.5005
R1409 GND.n549 GND.n545 1.5005
R1410 GND.n551 GND.n550 1.5005
R1411 GND.n552 GND.n544 1.5005
R1412 GND.n554 GND.n553 1.5005
R1413 GND.n555 GND.n539 1.5005
R1414 GND.n557 GND.n556 1.5005
R1415 GND.n558 GND.n535 1.5005
R1416 GND.n560 GND.n559 1.5005
R1417 GND.n538 GND.n534 1.5005
R1418 GND.n537 GND.n536 1.5005
R1419 GND.n530 GND.n529 1.5005
R1420 GND.n565 GND.n564 1.5005
R1421 GND.n263 GND.n1337 1.5005
R1422 GND.n443 GND.n442 1.5005
R1423 GND.n1320 GND.n1319 1.5005
R1424 GND.n1322 GND.n1321 1.5005
R1425 GND.n1323 GND.n1313 1.5005
R1426 GND.n1325 GND.n1324 1.5005
R1427 GND.n1326 GND.n1312 1.5005
R1428 GND.n1328 GND.n1327 1.5005
R1429 GND.n1329 GND.n1309 1.5005
R1430 GND.n1331 GND.n1330 1.5005
R1431 GND.n1332 GND.n458 1.5005
R1432 GND.n1334 GND.n1333 1.5005
R1433 GND.n1308 GND.n456 1.5005
R1434 GND.n444 GND.n443 1.5005
R1435 GND.n1319 GND.n1318 1.5005
R1436 GND.n1322 GND.n1317 1.5005
R1437 GND.n1323 GND.n1316 1.5005
R1438 GND.n1324 GND.n1315 1.5005
R1439 GND.n1314 GND.n1312 1.5005
R1440 GND.n1328 GND.n1311 1.5005
R1441 GND.n1329 GND.n455 1.5005
R1442 GND.n1330 GND.n1310 1.5005
R1443 GND.n458 GND.n457 1.5005
R1444 GND.n1335 GND.n1334 1.5005
R1445 GND.t0 GND.n455 1.5005
R1446 GND.t15 GND.n532 1.5005
R1447 GND.n549 GND.n547 1.5005
R1448 GND.n550 GND.n546 1.5005
R1449 GND.n544 GND.n543 1.5005
R1450 GND.n554 GND.n532 1.5005
R1451 GND.n555 GND.n542 1.5005
R1452 GND.n556 GND.n541 1.5005
R1453 GND.n540 GND.n535 1.5005
R1454 GND.n561 GND.n560 1.5005
R1455 GND.n562 GND.n534 1.5005
R1456 GND.n536 GND.n533 1.5005
R1457 GND.n531 GND.n530 1.5005
R1458 GND.n240 GND.t46 5.12392
R1459 GND.n247 GND.t35 1.45967
R1460 GND.n1178 GND.t35 1.4251
R1461 GND.n247 GND.n713 1.40774
R1462 GND.n1179 GND.n1178 1.40575
R1463 GND.t25 GND.n190 1.54212
R1464 GND.n642 GND.n637 1.14256
R1465 GND.n779 GND.n258 2.70865
R1466 GND.n644 GND.n643 1.13618
R1467 GND.n715 GND.t25 0.882463
R1468 GND.n240 GND.n239 0.796451
R1469 GND.n1336 GND.t0 0.746874
R1470 GND.t0 GND.n445 0.746874
R1471 GND.t0 GND.n446 0.746874
R1472 GND.t0 GND.n447 0.746874
R1473 GND.t0 GND.n448 0.746874
R1474 GND.t0 GND.n449 0.746874
R1475 GND.t15 GND.n452 0.746874
R1476 GND.t15 GND.n451 0.746874
R1477 GND.t15 GND.n450 0.746874
R1478 GND.t15 GND.n453 0.746874
R1479 GND.t15 GND.n454 0.746874
R1480 GND.n563 GND.t15 0.746874
R1481 GND.n1210 GND.n1209 0.692808
R1482 GND.n152 GND.n1210 0.692808
R1483 GND.n123 GND.n152 0.00254947
R1484 GND.n188 GND.n184 0.583757
R1485 GND.n189 GND.n188 0.0820277
R1486 GND.n729 GND.n727 0.620868
R1487 GND.n716 GND.n715 0.616878
R1488 GND.n1158 GND.n716 0.614902
R1489 GND.n724 GND.n241 0.653307
R1490 GND.n726 GND.n725 0.594491
R1491 GND.n727 GND.n726 0.581202
R1492 GND.n1150 GND.n719 0.570962
R1493 GND.n725 GND.n724 0.567136
R1494 GND.n1147 GND.n159 0.567
R1495 GND.n577 GND.n576 0.5005
R1496 GND.n599 GND.n598 0.5005
R1497 GND.n621 GND.n620 0.5005
R1498 GND.n389 GND.n577 0.5005
R1499 GND.n6 GND.n599 0.5005
R1500 GND.n388 GND.n621 0.5005
R1501 GND.n0 GND.n6 0.00335499
R1502 GND.n188 GND.n187 0.486214
R1503 GND.n188 GND.n186 0.382922
R1504 GND.t21 GND.t29 0.365641
R1505 GND.t0 GND.t15 0.3151
R1506 GND.n850 GND.n249 1.46903
R1507 GND.t32 GND.n666 0.209531
R1508 GND.n365 GND.n60 0.0942177
R1509 GND.n336 GND.n372 0.00206464
R1510 GND.n60 GND.n336 0.0942177
R1511 GND.n1368 GND.n337 0.00206464
R1512 GND.n60 GND.n337 0.0942177
R1513 GND.n375 GND.n1367 0.00206464
R1514 GND.n375 GND.n60 0.0942177
R1515 GND.n339 GND.n376 0.00206464
R1516 GND.n60 GND.n339 0.0942177
R1517 GND.n1365 GND.n340 0.00206464
R1518 GND.n60 GND.n340 0.0942177
R1519 GND.n379 GND.n1364 0.00206464
R1520 GND.n379 GND.n60 0.0942177
R1521 GND.n60 GND.n341 0.0942177
R1522 GND.n341 GND.n385 0.00206464
R1523 GND.n1362 GND.n342 0.00206464
R1524 GND.n60 GND.n342 0.0942177
R1525 GND.n387 GND.n1361 0.00206464
R1526 GND.n387 GND.n60 0.0942177
R1527 GND.n58 GND.n60 0.0307853
R1528 GND.n60 GND.n338 0.0942177
R1529 GND.n60 GND.n335 0.0942177
R1530 GND.n60 GND.n359 0.0942177
R1531 GND.n60 GND.n153 0.0942177
R1532 GND.n1358 GND.n153 0.00206464
R1533 GND.n60 GND.n360 0.188
R1534 GND.n390 GND.n438 0.00206464
R1535 GND.n390 GND.n60 0.0942177
R1536 GND.n361 GND.n391 0.00206464
R1537 GND.n60 GND.n361 0.0942177
R1538 GND.n1356 GND.n362 0.00206464
R1539 GND.n60 GND.n362 0.0942177
R1540 GND.n393 GND.n436 0.00206464
R1541 GND.n393 GND.n60 0.0942177
R1542 GND.n364 GND.n394 0.00206464
R1543 GND.n60 GND.n364 0.0942177
R1544 GND.n1354 GND.n363 0.00206464
R1545 GND.n60 GND.n363 0.0942177
R1546 GND.n396 GND.n434 0.00206464
R1547 GND.n396 GND.n60 0.0942177
R1548 GND.n357 GND.n397 0.00206464
R1549 GND.n60 GND.n357 0.0942177
R1550 GND.n1352 GND.n358 0.00206464
R1551 GND.n60 GND.n358 0.0942177
R1552 GND.n399 GND.n432 0.00206464
R1553 GND.n399 GND.n60 0.0942177
R1554 GND.n356 GND.n400 0.00206464
R1555 GND.n60 GND.n356 0.0942177
R1556 GND.n1350 GND.n353 0.00206464
R1557 GND.n60 GND.n353 0.0942177
R1558 GND.n402 GND.n430 0.00206464
R1559 GND.n402 GND.n60 0.0942177
R1560 GND.n354 GND.n403 0.00206464
R1561 GND.n60 GND.n354 0.0942177
R1562 GND.n1348 GND.n355 0.00206464
R1563 GND.n60 GND.n355 0.0942177
R1564 GND.n405 GND.n428 0.00206464
R1565 GND.n405 GND.n60 0.0942177
R1566 GND.n347 GND.n406 0.00206464
R1567 GND.n60 GND.n347 0.0942177
R1568 GND.n1346 GND.n346 0.00206464
R1569 GND.n60 GND.n346 0.0942177
R1570 GND.n408 GND.n426 0.00206464
R1571 GND.n408 GND.n60 0.0942177
R1572 GND.n344 GND.n409 0.00206464
R1573 GND.n60 GND.n344 0.0942177
R1574 GND.n1344 GND.n343 0.00206464
R1575 GND.n60 GND.n343 0.0942177
R1576 GND.n411 GND.n424 0.00206464
R1577 GND.n411 GND.n60 0.0942177
R1578 GND.n345 GND.n412 0.00206464
R1579 GND.n60 GND.n345 0.0942177
R1580 GND.n1342 GND.n348 0.00206464
R1581 GND.n60 GND.n348 0.0942177
R1582 GND.n414 GND.n422 0.00206464
R1583 GND.n414 GND.n60 0.0942177
R1584 GND.n349 GND.n415 0.00206464
R1585 GND.n60 GND.n349 0.0942177
R1586 GND.n1340 GND.n350 0.00206464
R1587 GND.n60 GND.n350 0.0942177
R1588 GND.n417 GND.n420 0.00206464
R1589 GND.n417 GND.n60 0.0942177
R1590 GND.n352 GND.n418 0.00206464
R1591 GND.n60 GND.n352 0.0942177
R1592 GND.n1338 GND.n351 0.00206464
R1593 GND.n60 GND.n351 0.0942177
R1594 GND.n1338 GND.n441 0.188
R1595 GND.n419 GND.n149 0.188
R1596 GND.n150 GND.n418 0.188
R1597 GND.n1339 GND.n82 0.188
R1598 GND.n420 GND.n81 0.188
R1599 GND.n147 GND.n416 0.188
R1600 GND.n1340 GND.n144 0.188
R1601 GND.n421 GND.n13 0.188
R1602 GND.n84 GND.n415 0.188
R1603 GND.n1341 GND.n83 0.188
R1604 GND.n422 GND.n138 0.188
R1605 GND.n139 GND.n413 0.188
R1606 GND.n1342 GND.n16 0.188
R1607 GND.n423 GND.n128 0.188
R1608 GND.n129 GND.n412 0.188
R1609 GND.n1343 GND.n135 0.188
R1610 GND.n424 GND.n130 0.188
R1611 GND.n19 GND.n410 0.188
R1612 GND.n1344 GND.n122 0.188
R1613 GND.n425 GND.n111 0.188
R1614 GND.n120 GND.n409 0.188
R1615 GND.n1345 GND.n119 0.188
R1616 GND.n426 GND.n29 0.188
R1617 GND.n110 GND.n407 0.188
R1618 GND.n1346 GND.n102 0.188
R1619 GND.n427 GND.n103 0.188
R1620 GND.n104 GND.n406 0.188
R1621 GND.n1347 GND.n22 0.188
R1622 GND.n428 GND.n88 0.188
R1623 GND.n89 GND.n404 0.188
R1624 GND.n1348 GND.n91 0.188
R1625 GND.n429 GND.n90 0.188
R1626 GND.n86 GND.n403 0.188
R1627 GND.n1349 GND.n85 0.188
R1628 GND.n430 GND.n105 0.188
R1629 GND.n108 GND.n401 0.188
R1630 GND.n1350 GND.n101 0.188
R1631 GND.n431 GND.n100 0.188
R1632 GND.n35 GND.n400 0.188
R1633 GND.n1351 GND.n118 0.188
R1634 GND.n432 GND.n117 0.188
R1635 GND.n113 GND.n398 0.188
R1636 GND.n1352 GND.n112 0.188
R1637 GND.n433 GND.n38 0.188
R1638 GND.n132 GND.n397 0.188
R1639 GND.n1353 GND.n131 0.188
R1640 GND.n434 GND.n127 0.188
R1641 GND.n137 GND.n395 0.188
R1642 GND.n1354 GND.n10 0.188
R1643 GND.n435 GND.n140 0.188
R1644 GND.n142 GND.n394 0.188
R1645 GND.n1355 GND.n75 0.188
R1646 GND.n436 GND.n74 0.188
R1647 GND.n8 GND.n392 0.188
R1648 GND.n1356 GND.n146 0.188
R1649 GND.n437 GND.n145 0.188
R1650 GND.n73 GND.n391 0.188
R1651 GND.n1357 GND.n72 0.188
R1652 GND.n438 GND.n148 0.188
R1653 GND.n155 GND.n360 0.188
R1654 GND.n1358 GND.n154 0.188
R1655 GND.n165 GND.n441 0.00206023
R1656 GND.n56 GND.n12 0.0942177
R1657 GND.n12 GND.n150 0.00206464
R1658 GND.n14 GND.n82 0.00206464
R1659 GND.n56 GND.n14 0.0942177
R1660 GND.n56 GND.n15 0.0942177
R1661 GND.n15 GND.n144 0.00206464
R1662 GND.n56 GND.n13 0.188
R1663 GND.n17 GND.n84 0.00206464
R1664 GND.n56 GND.n17 0.0942177
R1665 GND.n56 GND.n18 0.0942177
R1666 GND.n18 GND.n139 0.00206464
R1667 GND.n56 GND.n16 0.188
R1668 GND.n56 GND.n20 0.0942177
R1669 GND.n20 GND.n129 0.00206464
R1670 GND.n56 GND.n21 0.0942177
R1671 GND.n21 GND.n130 0.00206464
R1672 GND.n56 GND.n19 0.188
R1673 GND.n56 GND.n28 0.0942177
R1674 GND.n28 GND.n111 0.00206464
R1675 GND.n56 GND.n27 0.0942177
R1676 GND.n27 GND.n119 0.00206464
R1677 GND.n56 GND.n29 0.188
R1678 GND.n56 GND.n23 0.0942177
R1679 GND.n23 GND.n102 0.00206464
R1680 GND.n56 GND.n24 0.0942177
R1681 GND.n24 GND.n104 0.00206464
R1682 GND.n56 GND.n22 0.188
R1683 GND.n25 GND.n88 0.00206464
R1684 GND.n56 GND.n25 0.0942177
R1685 GND.n56 GND.n26 0.0942177
R1686 GND.n26 GND.n90 0.00206464
R1687 GND.n56 GND.n30 0.0942177
R1688 GND.n30 GND.n85 0.00206464
R1689 GND.n31 GND.n105 0.00206464
R1690 GND.n56 GND.n31 0.0942177
R1691 GND.n32 GND.n101 0.00206464
R1692 GND.n56 GND.n32 0.0942177
R1693 GND.n56 GND.n35 0.188
R1694 GND.n33 GND.n118 0.00206464
R1695 GND.n56 GND.n33 0.0942177
R1696 GND.n34 GND.n113 0.00206464
R1697 GND.n56 GND.n34 0.0942177
R1698 GND.n56 GND.n38 0.188
R1699 GND.n36 GND.n132 0.00206464
R1700 GND.n56 GND.n36 0.0942177
R1701 GND.n37 GND.n127 0.00206464
R1702 GND.n56 GND.n37 0.0942177
R1703 GND.n56 GND.n10 0.188
R1704 GND.n11 GND.n140 0.00206464
R1705 GND.n56 GND.n11 0.0942177
R1706 GND.n39 GND.n75 0.00206464
R1707 GND.n56 GND.n39 0.0942177
R1708 GND.n56 GND.n8 0.188
R1709 GND.n9 GND.n146 0.00206464
R1710 GND.n56 GND.n9 0.0942177
R1711 GND.n42 GND.n73 0.00206464
R1712 GND.n56 GND.n42 0.0942177
R1713 GND.n40 GND.n148 0.00206464
R1714 GND.n56 GND.n40 0.0942177
R1715 GND.n41 GND.n154 0.00206023
R1716 GND.n1359 GND.n440 0.188
R1717 GND.n156 GND.n371 0.188
R1718 GND.n61 GND.n56 0.0943511
R1719 GND.n62 GND.n338 0.00362497
R1720 GND.n1360 GND.n141 0.188
R1721 GND.n1361 GND.n44 0.188
R1722 GND.n136 GND.n386 0.188
R1723 GND.n1362 GND.n126 0.188
R1724 GND.n385 GND.n133 0.188
R1725 GND.n134 GND.n384 0.188
R1726 GND.n1363 GND.n46 0.188
R1727 GND.n1364 GND.n114 0.188
R1728 GND.n115 GND.n378 0.188
R1729 GND.n1365 GND.n121 0.188
R1730 GND.n377 GND.n116 0.188
R1731 GND.n49 GND.n376 0.188
R1732 GND.n1366 GND.n109 0.188
R1733 GND.n1367 GND.n99 0.188
R1734 GND.n107 GND.n374 0.188
R1735 GND.n1368 GND.n106 0.188
R1736 GND.n373 GND.n52 0.188
R1737 GND.n372 GND.n439 0.188
R1738 GND.n87 GND.n1369 0.188
R1739 GND.n166 GND.n440 0.00206023
R1740 GND.n56 GND.n43 0.0289307
R1741 GND.n56 GND.n45 0.0942177
R1742 GND.n45 GND.n141 0.00206464
R1743 GND.n56 GND.n44 0.188
R1744 GND.n56 GND.n47 0.0942177
R1745 GND.n47 GND.n126 0.00206464
R1746 GND.n56 GND.n48 0.0942177
R1747 GND.n48 GND.n134 0.00206464
R1748 GND.n56 GND.n46 0.188
R1749 GND.n56 GND.n50 0.0942177
R1750 GND.n50 GND.n115 0.00206464
R1751 GND.n56 GND.n51 0.0942177
R1752 GND.n51 GND.n116 0.00206464
R1753 GND.n56 GND.n49 0.188
R1754 GND.n56 GND.n53 0.0942177
R1755 GND.n53 GND.n99 0.00206464
R1756 GND.n56 GND.n54 0.0942177
R1757 GND.n54 GND.n106 0.00206464
R1758 GND.n56 GND.n52 0.188
R1759 GND.n439 GND.n55 0.00206464
R1760 GND.n56 GND.n55 0.0942177
R1761 GND.n57 GND.n56 0.0105473
R1762 GND.t40 GND.n778 0.178312
R1763 GND.n851 GND.n667 0.17521
R1764 GND.n311 GND.n310 0.146822
R1765 GND.n264 GND.n263 0.146822
R1766 GND.n244 GND.n242 0.654435
R1767 GND.n241 GND.n240 0.0643404
R1768 GND.n725 GND.n240 0.127913
R1769 GND.n715 GND.n93 0.640574
R1770 GND.n165 GND.n56 0.0963489
R1771 GND.n56 GND.n41 0.0963489
R1772 GND.n166 GND.n56 0.0963489
R1773 GND.n716 GND.n92 0.0902214
R1774 GND.n838 GND.n261 0.083
R1775 GND.n1179 GND.n261 0.0726875
R1776 GND.n734 GND.n721 0.0695681
R1777 GND.n124 GND.t32 0.0691032
R1778 GND.n850 GND.n667 0.0652097
R1779 GND.n721 GND.n720 0.0610974
R1780 GND.n1174 GND.n1167 0.0595769
R1781 GND.n1174 GND.n1166 0.0595769
R1782 GND.n1175 GND.n1165 0.0595769
R1783 GND.n1175 GND.n1164 0.0595769
R1784 GND.n1170 GND.n1164 0.0595769
R1785 GND.n1176 GND.n1163 0.0595769
R1786 GND.n1176 GND.n1162 0.0595769
R1787 GND.n1169 GND.n1162 0.0595769
R1788 GND.n66 GND.n65 0.015808
R1789 GND.n1014 GND.n783 0.0560729
R1790 GND.n1014 GND.n1013 0.0560729
R1791 GND.n1013 GND.n1012 0.0560729
R1792 GND.n1012 GND.n785 0.0560729
R1793 GND.n1008 GND.n785 0.0560729
R1794 GND.n1008 GND.n1007 0.0560729
R1795 GND.n1007 GND.n1006 0.0560729
R1796 GND.n1006 GND.n787 0.0560729
R1797 GND.n1002 GND.n787 0.0560729
R1798 GND.n1002 GND.n1001 0.0560729
R1799 GND.n1001 GND.n1000 0.0560729
R1800 GND.n1000 GND.n789 0.0560729
R1801 GND.n996 GND.n789 0.0560729
R1802 GND.n996 GND.n995 0.0560729
R1803 GND.n995 GND.n994 0.0560729
R1804 GND.n994 GND.n791 0.0560729
R1805 GND.n990 GND.n791 0.0560729
R1806 GND.n990 GND.n989 0.0560729
R1807 GND.n989 GND.n988 0.0560729
R1808 GND.n988 GND.n793 0.0560729
R1809 GND.n984 GND.n793 0.0560729
R1810 GND.n984 GND.n983 0.0560729
R1811 GND.n983 GND.n982 0.0560729
R1812 GND.n982 GND.n795 0.0560729
R1813 GND.n978 GND.n795 0.0560729
R1814 GND.n978 GND.n977 0.0560729
R1815 GND.n977 GND.n976 0.0560729
R1816 GND.n976 GND.n797 0.0560729
R1817 GND.n972 GND.n797 0.0560729
R1818 GND.n972 GND.n971 0.0560729
R1819 GND.n971 GND.n970 0.0560729
R1820 GND.n970 GND.n799 0.0560729
R1821 GND.n966 GND.n799 0.0560729
R1822 GND.n966 GND.n965 0.0560729
R1823 GND.n965 GND.n964 0.0560729
R1824 GND.n964 GND.n801 0.0560729
R1825 GND.n960 GND.n801 0.0560729
R1826 GND.n960 GND.n959 0.0560729
R1827 GND.n959 GND.n958 0.0560729
R1828 GND.n958 GND.n803 0.0560729
R1829 GND.n954 GND.n803 0.0560729
R1830 GND.n954 GND.n953 0.0560729
R1831 GND.n953 GND.n952 0.0560729
R1832 GND.n952 GND.n805 0.0560729
R1833 GND.n948 GND.n805 0.0560729
R1834 GND.n948 GND.n947 0.0560729
R1835 GND.n947 GND.n946 0.0560729
R1836 GND.n946 GND.n807 0.0560729
R1837 GND.n942 GND.n807 0.0560729
R1838 GND.n942 GND.n941 0.0560729
R1839 GND.n941 GND.n940 0.0560729
R1840 GND.n940 GND.n809 0.0560729
R1841 GND.n936 GND.n809 0.0560729
R1842 GND.n936 GND.n935 0.0560729
R1843 GND.n935 GND.n934 0.0560729
R1844 GND.n934 GND.n811 0.0560729
R1845 GND.n930 GND.n811 0.0560729
R1846 GND.n930 GND.n929 0.0560729
R1847 GND.n929 GND.n928 0.0560729
R1848 GND.n928 GND.n813 0.0560729
R1849 GND.n924 GND.n813 0.0560729
R1850 GND.n924 GND.n923 0.0560729
R1851 GND.n923 GND.n922 0.0560729
R1852 GND.n922 GND.n815 0.0560729
R1853 GND.n918 GND.n815 0.0560729
R1854 GND.n918 GND.n917 0.0560729
R1855 GND.n917 GND.n916 0.0560729
R1856 GND.n916 GND.n817 0.0560729
R1857 GND.n912 GND.n817 0.0560729
R1858 GND.n912 GND.n911 0.0560729
R1859 GND.n911 GND.n910 0.0560729
R1860 GND.n910 GND.n819 0.0560729
R1861 GND.n906 GND.n819 0.0560729
R1862 GND.n906 GND.n905 0.0560729
R1863 GND.n905 GND.n904 0.0560729
R1864 GND.n904 GND.n821 0.0560729
R1865 GND.n900 GND.n821 0.0560729
R1866 GND.n900 GND.n899 0.0560729
R1867 GND.n899 GND.n898 0.0560729
R1868 GND.n898 GND.n823 0.0560729
R1869 GND.n894 GND.n823 0.0560729
R1870 GND.n894 GND.n893 0.0560729
R1871 GND.n893 GND.n892 0.0560729
R1872 GND.n892 GND.n825 0.0560729
R1873 GND.n888 GND.n825 0.0560729
R1874 GND.n888 GND.n887 0.0560729
R1875 GND.n887 GND.n886 0.0560729
R1876 GND.n886 GND.n827 0.0560729
R1877 GND.n882 GND.n827 0.0560729
R1878 GND.n882 GND.n881 0.0560729
R1879 GND.n881 GND.n880 0.0560729
R1880 GND.n880 GND.n829 0.0560729
R1881 GND.n876 GND.n829 0.0560729
R1882 GND.n313 GND.n312 0.416139
R1883 GND.n312 GND.n309 0.392235
R1884 GND.n309 GND.n307 0.114292
R1885 GND.n307 GND.n305 0.114292
R1886 GND.n305 GND.n303 0.114292
R1887 GND.n303 GND.n301 0.114292
R1888 GND.n301 GND.n299 0.114292
R1889 GND.n299 GND.n297 0.114292
R1890 GND.n297 GND.n295 0.114292
R1891 GND.n295 GND.n293 0.114292
R1892 GND.n293 GND.n291 0.114292
R1893 GND.n291 GND.n289 0.114292
R1894 GND.n289 GND.n287 0.114292
R1895 GND.n287 GND.n285 0.114292
R1896 GND.n285 GND.n283 0.114292
R1897 GND.n283 GND.n281 0.114292
R1898 GND.n281 GND.n279 0.114292
R1899 GND.n279 GND.n277 0.114292
R1900 GND.n171 GND.n167 0.142719
R1901 GND.n172 GND.n171 0.114292
R1902 GND.n173 GND.n172 0.114292
R1903 GND.n174 GND.n173 0.114292
R1904 GND.n175 GND.n174 0.114292
R1905 GND.n176 GND.n175 0.114292
R1906 GND.n177 GND.n176 0.114292
R1907 GND.n178 GND.n177 0.114292
R1908 GND.n179 GND.n178 0.114292
R1909 GND.n180 GND.n179 0.114292
R1910 GND.n181 GND.n180 0.114292
R1911 GND.n1140 GND.n1139 0.0555
R1912 GND.n1140 GND.n1138 0.0555
R1913 GND.n1144 GND.n1138 0.0555
R1914 GND.n1145 GND.n1144 0.0555
R1915 GND.n1146 GND.n1145 0.0555
R1916 GND.n1146 GND.n1137 0.0555
R1917 GND.n1137 GND.n1136 0.0555
R1918 GND.n1136 GND.n730 0.0555
R1919 GND.n1131 GND.n730 0.0555
R1920 GND.n1131 GND.n1130 0.0555
R1921 GND.n1130 GND.n732 0.0555
R1922 GND.n1125 GND.n732 0.0555
R1923 GND.n1125 GND.n1124 0.0555
R1924 GND.n1124 GND.n1123 0.0555
R1925 GND.n1123 GND.n737 0.0555
R1926 GND.n1119 GND.n737 0.0555
R1927 GND.n1119 GND.n1118 0.0555
R1928 GND.n1118 GND.n1117 0.0555
R1929 GND.n1117 GND.n739 0.0555
R1930 GND.n1113 GND.n739 0.0555
R1931 GND.n1113 GND.n1112 0.0555
R1932 GND.n1112 GND.n1111 0.0555
R1933 GND.n1111 GND.n741 0.0555
R1934 GND.n1107 GND.n741 0.0555
R1935 GND.n1107 GND.n1106 0.0555
R1936 GND.n1106 GND.n1105 0.0555
R1937 GND.n1105 GND.n743 0.0555
R1938 GND.n1101 GND.n743 0.0555
R1939 GND.n1101 GND.n1100 0.0555
R1940 GND.n1100 GND.n1099 0.0555
R1941 GND.n1099 GND.n745 0.0555
R1942 GND.n1095 GND.n745 0.0555
R1943 GND.n1095 GND.n1094 0.0555
R1944 GND.n1094 GND.n1093 0.0555
R1945 GND.n1093 GND.n747 0.0555
R1946 GND.n1089 GND.n747 0.0555
R1947 GND.n1089 GND.n1088 0.0555
R1948 GND.n1088 GND.n1087 0.0555
R1949 GND.n1087 GND.n749 0.0555
R1950 GND.n1083 GND.n749 0.0555
R1951 GND.n1083 GND.n1082 0.0555
R1952 GND.n1082 GND.n1081 0.0555
R1953 GND.n1081 GND.n751 0.0555
R1954 GND.n1077 GND.n751 0.0555
R1955 GND.n1077 GND.n1076 0.0555
R1956 GND.n1076 GND.n1075 0.0555
R1957 GND.n1075 GND.n753 0.0555
R1958 GND.n1071 GND.n753 0.0555
R1959 GND.n1071 GND.n1070 0.0555
R1960 GND.n1070 GND.n1069 0.0555
R1961 GND.n1069 GND.n755 0.0555
R1962 GND.n1065 GND.n755 0.0555
R1963 GND.n1065 GND.n1064 0.0555
R1964 GND.n1064 GND.n1063 0.0555
R1965 GND.n1063 GND.n757 0.0555
R1966 GND.n1059 GND.n757 0.0555
R1967 GND.n1059 GND.n1058 0.0555
R1968 GND.n1058 GND.n1057 0.0555
R1969 GND.n1057 GND.n759 0.0555
R1970 GND.n1053 GND.n759 0.0555
R1971 GND.n1053 GND.n1052 0.0555
R1972 GND.n1052 GND.n1051 0.0555
R1973 GND.n1051 GND.n761 0.0555
R1974 GND.n1047 GND.n761 0.0555
R1975 GND.n1047 GND.n1046 0.0555
R1976 GND.n1046 GND.n1045 0.0555
R1977 GND.n1045 GND.n763 0.0555
R1978 GND.n1041 GND.n763 0.0555
R1979 GND.n1041 GND.n1040 0.0555
R1980 GND.n1040 GND.n1039 0.0555
R1981 GND.n1039 GND.n765 0.0555
R1982 GND.n1035 GND.n765 0.0555
R1983 GND.n192 GND.n1035 0.327108
R1984 GND.n194 GND.n192 0.405755
R1985 GND.n196 GND.n194 0.226262
R1986 GND.n198 GND.n196 0.226262
R1987 GND.n200 GND.n198 0.226262
R1988 GND.n202 GND.n200 0.226262
R1989 GND.n204 GND.n202 0.226262
R1990 GND.n206 GND.n204 0.226262
R1991 GND.n208 GND.n206 0.226262
R1992 GND.n210 GND.n208 0.226262
R1993 GND.n212 GND.n210 0.226262
R1994 GND.n214 GND.n212 0.226262
R1995 GND.n216 GND.n214 0.226262
R1996 GND.n218 GND.n216 0.226262
R1997 GND.n220 GND.n218 0.226262
R1998 GND.n222 GND.n220 0.226262
R1999 GND.n224 GND.n222 0.226262
R2000 GND.n226 GND.n224 0.226262
R2001 GND.n228 GND.n226 0.226262
R2002 GND.n230 GND.n228 0.226262
R2003 GND.n232 GND.n230 0.226262
R2004 GND.n233 GND.n232 0.226262
R2005 GND.n234 GND.n233 0.253296
R2006 GND.n1033 GND.n234 0.127255
R2007 GND.n1034 GND.n162 0.0555
R2008 GND.n1019 GND.n1018 0.0555
R2009 GND.n1018 GND.n783 0.0555
R2010 GND.n876 GND.n875 0.0555
R2011 GND.n875 GND.n874 0.0555
R2012 GND.n874 GND.n831 0.0555
R2013 GND.n870 GND.n831 0.0555
R2014 GND.n870 GND.n869 0.0555
R2015 GND.n869 GND.n238 1.54223
R2016 GND.t31 GND.n366 0.346571
R2017 GND.n854 GND.n837 0.0555
R2018 GND.n855 GND.n854 0.0555
R2019 GND.n856 GND.n855 0.0555
R2020 GND.n856 GND.n835 0.0555
R2021 GND.n860 GND.n835 0.0555
R2022 GND.n861 GND.n860 0.0555
R2023 GND.n862 GND.n861 0.0555
R2024 GND.n862 GND.n833 0.0555
R2025 GND.n866 GND.n833 0.0555
R2026 GND.n867 GND.n866 0.0555
R2027 GND.n868 GND.n867 0.0555
R2028 GND.t31 GND.n837 0.0555
R2029 GND.n567 GND.n565 0.0539902
R2030 GND.n1308 GND.n1307 0.0539902
R2031 GND.n839 GND.n668 0.0535903
R2032 GND.n1201 GND.n631 0.0529549
R2033 GND.n1242 GND.n1214 0.0529549
R2034 GND.n164 GND.n163 0.0245125
R2035 GND.n838 GND.n65 0.23309
R2036 GND.n1016 GND.n1015 0.0449583
R2037 GND.n1015 GND.n784 0.0449583
R2038 GND.n1011 GND.n784 0.0449583
R2039 GND.n1011 GND.n1010 0.0449583
R2040 GND.n1010 GND.n1009 0.0449583
R2041 GND.n1009 GND.n786 0.0449583
R2042 GND.n1005 GND.n786 0.0449583
R2043 GND.n1005 GND.n1004 0.0449583
R2044 GND.n1004 GND.n1003 0.0449583
R2045 GND.n1003 GND.n788 0.0449583
R2046 GND.n999 GND.n788 0.0449583
R2047 GND.n999 GND.n998 0.0449583
R2048 GND.n998 GND.n997 0.0449583
R2049 GND.n997 GND.n790 0.0449583
R2050 GND.n993 GND.n790 0.0449583
R2051 GND.n993 GND.n992 0.0449583
R2052 GND.n992 GND.n991 0.0449583
R2053 GND.n991 GND.n792 0.0449583
R2054 GND.n987 GND.n792 0.0449583
R2055 GND.n987 GND.n986 0.0449583
R2056 GND.n986 GND.n985 0.0449583
R2057 GND.n985 GND.n794 0.0449583
R2058 GND.n981 GND.n794 0.0449583
R2059 GND.n981 GND.n980 0.0449583
R2060 GND.n980 GND.n979 0.0449583
R2061 GND.n979 GND.n796 0.0449583
R2062 GND.n975 GND.n796 0.0449583
R2063 GND.n975 GND.n974 0.0449583
R2064 GND.n974 GND.n973 0.0449583
R2065 GND.n973 GND.n798 0.0449583
R2066 GND.n969 GND.n798 0.0449583
R2067 GND.n969 GND.n968 0.0449583
R2068 GND.n968 GND.n967 0.0449583
R2069 GND.n967 GND.n800 0.0449583
R2070 GND.n963 GND.n800 0.0449583
R2071 GND.n963 GND.n962 0.0449583
R2072 GND.n962 GND.n961 0.0449583
R2073 GND.n961 GND.n802 0.0449583
R2074 GND.n957 GND.n802 0.0449583
R2075 GND.n957 GND.n956 0.0449583
R2076 GND.n956 GND.n955 0.0449583
R2077 GND.n955 GND.n804 0.0449583
R2078 GND.n951 GND.n804 0.0449583
R2079 GND.n951 GND.n950 0.0449583
R2080 GND.n950 GND.n949 0.0449583
R2081 GND.n949 GND.n806 0.0449583
R2082 GND.n945 GND.n806 0.0449583
R2083 GND.n945 GND.n944 0.0449583
R2084 GND.n944 GND.n943 0.0449583
R2085 GND.n943 GND.n808 0.0449583
R2086 GND.n939 GND.n808 0.0449583
R2087 GND.n939 GND.n938 0.0449583
R2088 GND.n938 GND.n937 0.0449583
R2089 GND.n937 GND.n810 0.0449583
R2090 GND.n933 GND.n810 0.0449583
R2091 GND.n933 GND.n932 0.0449583
R2092 GND.n932 GND.n931 0.0449583
R2093 GND.n931 GND.n812 0.0449583
R2094 GND.n927 GND.n812 0.0449583
R2095 GND.n927 GND.n926 0.0449583
R2096 GND.n926 GND.n925 0.0449583
R2097 GND.n925 GND.n814 0.0449583
R2098 GND.n921 GND.n814 0.0449583
R2099 GND.n921 GND.n920 0.0449583
R2100 GND.n920 GND.n919 0.0449583
R2101 GND.n919 GND.n816 0.0449583
R2102 GND.n915 GND.n816 0.0449583
R2103 GND.n915 GND.n914 0.0449583
R2104 GND.n914 GND.n913 0.0449583
R2105 GND.n913 GND.n818 0.0449583
R2106 GND.n909 GND.n818 0.0449583
R2107 GND.n909 GND.n908 0.0449583
R2108 GND.n908 GND.n907 0.0449583
R2109 GND.n907 GND.n820 0.0449583
R2110 GND.n903 GND.n820 0.0449583
R2111 GND.n903 GND.n902 0.0449583
R2112 GND.n902 GND.n901 0.0449583
R2113 GND.n901 GND.n822 0.0449583
R2114 GND.n897 GND.n822 0.0449583
R2115 GND.n897 GND.n896 0.0449583
R2116 GND.n896 GND.n895 0.0449583
R2117 GND.n895 GND.n824 0.0449583
R2118 GND.n891 GND.n824 0.0449583
R2119 GND.n891 GND.n890 0.0449583
R2120 GND.n890 GND.n889 0.0449583
R2121 GND.n889 GND.n826 0.0449583
R2122 GND.n885 GND.n826 0.0449583
R2123 GND.n885 GND.n884 0.0449583
R2124 GND.n884 GND.n883 0.0449583
R2125 GND.n883 GND.n828 0.0449583
R2126 GND.n879 GND.n828 0.0449583
R2127 GND.n879 GND.n878 0.0449583
R2128 GND.n878 GND.n877 0.0449583
R2129 GND.n366 GND.n56 1.55728
R2130 GND.n852 GND.n366 0.32211
R2131 GND.n853 GND.n852 0.0445
R2132 GND.n853 GND.n836 0.0445
R2133 GND.n857 GND.n836 0.0445
R2134 GND.n858 GND.n857 0.0445
R2135 GND.n859 GND.n858 0.0445
R2136 GND.n859 GND.n834 0.0445
R2137 GND.n863 GND.n834 0.0445
R2138 GND.n864 GND.n863 0.0445
R2139 GND.n865 GND.n864 0.0445
R2140 GND.n865 GND.n832 0.0445
R2141 GND.n235 GND.n832 0.0445
R2142 GND.n56 GND.n7 0.0710103
R2143 GND.n1141 GND.n265 0.0445
R2144 GND.n1142 GND.n1141 0.0445
R2145 GND.n1143 GND.n1142 0.0445
R2146 GND.n1143 GND.n157 0.0445
R2147 GND.n159 GND.n157 0.0445
R2148 GND.n1135 GND.n158 0.0445
R2149 GND.n1133 GND.n1132 0.0445
R2150 GND.n1129 GND.n1128 0.0445
R2151 GND.n1126 GND.n736 0.0445
R2152 GND.n1122 GND.n1121 0.0445
R2153 GND.n1121 GND.n1120 0.0445
R2154 GND.n1120 GND.n738 0.0445
R2155 GND.n1116 GND.n738 0.0445
R2156 GND.n1116 GND.n1115 0.0445
R2157 GND.n1115 GND.n1114 0.0445
R2158 GND.n1114 GND.n740 0.0445
R2159 GND.n1110 GND.n740 0.0445
R2160 GND.n1110 GND.n1109 0.0445
R2161 GND.n1109 GND.n1108 0.0445
R2162 GND.n1108 GND.n742 0.0445
R2163 GND.n1104 GND.n742 0.0445
R2164 GND.n1104 GND.n1103 0.0445
R2165 GND.n1103 GND.n1102 0.0445
R2166 GND.n1102 GND.n744 0.0445
R2167 GND.n1098 GND.n744 0.0445
R2168 GND.n1098 GND.n1097 0.0445
R2169 GND.n1097 GND.n1096 0.0445
R2170 GND.n1096 GND.n746 0.0445
R2171 GND.n1092 GND.n746 0.0445
R2172 GND.n1092 GND.n1091 0.0445
R2173 GND.n1091 GND.n1090 0.0445
R2174 GND.n1090 GND.n748 0.0445
R2175 GND.n1086 GND.n748 0.0445
R2176 GND.n1086 GND.n1085 0.0445
R2177 GND.n1085 GND.n1084 0.0445
R2178 GND.n1084 GND.n750 0.0445
R2179 GND.n1080 GND.n750 0.0445
R2180 GND.n1080 GND.n1079 0.0445
R2181 GND.n1079 GND.n1078 0.0445
R2182 GND.n1078 GND.n752 0.0445
R2183 GND.n1074 GND.n752 0.0445
R2184 GND.n1074 GND.n1073 0.0445
R2185 GND.n1073 GND.n1072 0.0445
R2186 GND.n1072 GND.n754 0.0445
R2187 GND.n1068 GND.n754 0.0445
R2188 GND.n1068 GND.n1067 0.0445
R2189 GND.n1067 GND.n1066 0.0445
R2190 GND.n1066 GND.n756 0.0445
R2191 GND.n1062 GND.n756 0.0445
R2192 GND.n1062 GND.n1061 0.0445
R2193 GND.n1061 GND.n1060 0.0445
R2194 GND.n1060 GND.n758 0.0445
R2195 GND.n1056 GND.n758 0.0445
R2196 GND.n1056 GND.n1055 0.0445
R2197 GND.n1055 GND.n1054 0.0445
R2198 GND.n1054 GND.n760 0.0445
R2199 GND.n1050 GND.n760 0.0445
R2200 GND.n1050 GND.n1049 0.0445
R2201 GND.n1049 GND.n1048 0.0445
R2202 GND.n1048 GND.n762 0.0445
R2203 GND.n1044 GND.n762 0.0445
R2204 GND.n1044 GND.n1043 0.0445
R2205 GND.n1043 GND.n1042 0.0445
R2206 GND.n1042 GND.n764 0.0445
R2207 GND.n1038 GND.n764 0.0445
R2208 GND.n1038 GND.n1037 0.0445
R2209 GND.n1037 GND.n1036 0.0445
R2210 GND.n1031 GND.n160 0.0445
R2211 GND.n1031 GND.n1030 0.0445
R2212 GND.n1030 GND.n768 0.0445
R2213 GND.n1023 GND.n768 0.0445
R2214 GND.n1023 GND.n1022 0.0445
R2215 GND.n1022 GND.n773 0.0445
R2216 GND.n1017 GND.n773 0.0445
R2217 GND.n1017 GND.n1016 0.0445
R2218 GND.n877 GND.n830 0.0445
R2219 GND.n873 GND.n830 0.0445
R2220 GND.n873 GND.n872 0.0445
R2221 GND.n872 GND.n871 0.0445
R2222 GND.n871 GND.n236 0.0445
R2223 GND.n1028 GND.n1027 0.0440417
R2224 GND.n1034 GND.n1033 0.0411771
R2225 GND.n1026 GND.n1025 0.0400312
R2226 GND.n1134 GND.n1133 0.0394583
R2227 GND.n1129 GND.n96 0.0380833
R2228 GND.n1127 GND.n1126 0.0380833
R2229 GND.n775 GND.n769 0.0380486
R2230 GND.n1122 GND.n719 0.0367083
R2231 GND.n589 GND.n587 0.0365627
R2232 GND.n1304 GND.n1276 0.0365627
R2233 GND.n775 GND.n770 0.0365208
R2234 GND.n1024 GND.n772 0.0360208
R2235 GND.n776 GND.n771 0.0357565
R2236 GND.n1153 GND.n1152 0.035375
R2237 GND.n705 GND.n684 0.0352907
R2238 GND.n611 GND.n609 0.0351824
R2239 GND.n1273 GND.n1245 0.0351824
R2240 GND.n1020 GND.n1019 0.034875
R2241 GND.n781 GND.n774 0.0342287
R2242 GND.n703 GND.n685 0.0337558
R2243 GND.n706 GND.n683 0.0327326
R2244 GND.n723 GND.n163 0.0563312
R2245 GND.n79 GND.n722 0.0990297
R2246 GND.n702 GND.n686 0.0311977
R2247 GND.n1155 GND.n1153 0.0307916
R2248 GND.n1171 GND.n1168 0.0304418
R2249 GND.n1168 GND.n1166 0.0304418
R2250 GND.n707 GND.n682 0.0301744
R2251 GND.n845 GND.n675 0.030037
R2252 GND.n782 GND.n781 0.0296458
R2253 GND.n244 GND.n1155 0.056227
R2254 GND.n717 GND.n244 9.10031
R2255 GND.n720 GND.n718 0.0292639
R2256 GND.n1029 GND.n767 0.0291458
R2257 GND.n728 GND.n723 0.0288819
R2258 GND.n701 GND.n687 0.0286395
R2259 GND.n1152 GND.t56 0.028
R2260 GND.t58 GND.n243 0.034491
R2261 GND.n1149 GND.n720 0.028
R2262 GND.n239 GND.n1151 0.028
R2263 GND.n1148 GND.n723 0.028
R2264 GND.n253 GND.n262 0.028
R2265 GND.n184 GND.n183 0.0143437
R2266 GND.n780 GND.n771 0.027736
R2267 GND.n708 GND.n681 0.0276163
R2268 GND.n780 GND.n770 0.0269721
R2269 GND.n1032 GND.n767 0.0268542
R2270 GND.n1198 GND.n1197 0.0264141
R2271 GND.n1197 GND.n1196 0.0264141
R2272 GND.n1196 GND.n1195 0.0264141
R2273 GND.n1195 GND.t8 0.0264141
R2274 GND.n125 GND.n1180 0.0264141
R2275 GND.n1187 GND.n1180 0.0264141
R2276 GND.n700 GND.n688 0.0260814
R2277 GND.n782 GND.n769 0.0258263
R2278 GND.n695 GND.n694 0.0255698
R2279 GND.n709 GND.n680 0.0245465
R2280 GND.n843 GND.n673 0.0244352
R2281 GND.n712 GND.n676 0.0240349
R2282 GND.n840 GND.n669 0.0239259
R2283 GND.n699 GND.n689 0.0235233
R2284 GND.t8 GND.n125 0.0234448
R2285 GND.n696 GND.n693 0.0230116
R2286 GND.n1178 GND.n248 0.0221903
R2287 GND.n710 GND.n679 0.0214767
R2288 GND.n774 GND.n766 0.0212426
R2289 GND.n1021 GND.n1020 0.021125
R2290 GND.n711 GND.n677 0.0209651
R2291 GND.n698 GND.n690 0.0209651
R2292 GND.n841 GND.n670 0.0208704
R2293 GND.n704 GND.n685 0.0206794
R2294 GND.n697 GND.n692 0.0204535
R2295 GND.n847 GND.n674 0.0203611
R2296 GND.n1161 GND.n1159 0.0200556
R2297 GND.n1021 GND.n772 0.0199792
R2298 GND.n776 GND.n183 0.0197149
R2299 GND.n733 GND.n77 0.0455412
R2300 GND.n851 GND.n668 0.0194063
R2301 GND.n78 GND.n77 0.0180486
R2302 GND.n704 GND.n684 0.0191445
R2303 GND.t8 GND.n124 0.0188887
R2304 GND.n711 GND.n678 0.018407
R2305 GND.n697 GND.n691 0.018407
R2306 GND.n841 GND.n671 0.0183241
R2307 GND.n248 GND.n247 0.01814
R2308 GND.n710 GND.n678 0.0178953
R2309 GND.n698 GND.n691 0.0178953
R2310 GND.n842 GND.n671 0.0178148
R2311 GND.n1155 GND.n1154 0.0173056
R2312 GND.n1337 GND.n443 0.0170973
R2313 GND.n1319 GND.n443 0.0170973
R2314 GND.n1322 GND.n1319 0.0170973
R2315 GND.n1323 GND.n1322 0.0170973
R2316 GND.n1324 GND.n1323 0.0170973
R2317 GND.n1324 GND.n1312 0.0170973
R2318 GND.n1328 GND.n1312 0.0170973
R2319 GND.n1329 GND.n1328 0.0170973
R2320 GND.n1330 GND.n1329 0.0170973
R2321 GND.n1330 GND.n458 0.0170973
R2322 GND.n1334 GND.n458 0.0170973
R2323 GND.n1334 GND.n456 0.0170973
R2324 GND.n1318 GND.n444 0.0170973
R2325 GND.n1317 GND.n1316 0.0170973
R2326 GND.n1315 GND.n1314 0.0170973
R2327 GND.n1311 GND.n455 0.0170973
R2328 GND.n1310 GND.n455 0.0170973
R2329 GND.n1335 GND.n457 0.0170973
R2330 GND.n547 GND.n546 0.0170973
R2331 GND.n543 GND.n532 0.0170973
R2332 GND.n542 GND.n532 0.0170973
R2333 GND.n541 GND.n540 0.0170973
R2334 GND.n562 GND.n561 0.0170973
R2335 GND.n533 GND.n531 0.0170973
R2336 GND.n549 GND.n548 0.0170973
R2337 GND.n550 GND.n549 0.0170973
R2338 GND.n550 GND.n544 0.0170973
R2339 GND.n554 GND.n544 0.0170973
R2340 GND.n555 GND.n554 0.0170973
R2341 GND.n556 GND.n555 0.0170973
R2342 GND.n556 GND.n535 0.0170973
R2343 GND.n560 GND.n535 0.0170973
R2344 GND.n560 GND.n534 0.0170973
R2345 GND.n536 GND.n534 0.0170973
R2346 GND.n536 GND.n530 0.0170973
R2347 GND.n564 GND.n530 0.0170973
R2348 GND.n545 GND.n310 0.0170647
R2349 GND.n551 GND.n545 0.0170647
R2350 GND.n552 GND.n551 0.0170647
R2351 GND.n553 GND.n552 0.0170647
R2352 GND.n553 GND.n539 0.0170647
R2353 GND.n557 GND.n539 0.0170647
R2354 GND.n558 GND.n557 0.0170647
R2355 GND.n559 GND.n558 0.0170647
R2356 GND.n559 GND.n538 0.0170647
R2357 GND.n538 GND.n537 0.0170647
R2358 GND.n537 GND.n529 0.0170647
R2359 GND.n565 GND.n529 0.0170647
R2360 GND.n568 GND.n567 0.0170647
R2361 GND.n569 GND.n568 0.0170647
R2362 GND.n569 GND.n524 0.0170647
R2363 GND.n574 GND.n524 0.0170647
R2364 GND.n575 GND.n574 0.0170647
R2365 GND.n576 GND.n575 0.0170647
R2366 GND.n576 GND.n521 0.0170647
R2367 GND.n580 GND.n521 0.0170647
R2368 GND.n581 GND.n580 0.0170647
R2369 GND.n582 GND.n581 0.0170647
R2370 GND.n582 GND.n516 0.0170647
R2371 GND.n587 GND.n516 0.0170647
R2372 GND.n590 GND.n589 0.0170647
R2373 GND.n591 GND.n590 0.0170647
R2374 GND.n591 GND.n511 0.0170647
R2375 GND.n596 GND.n511 0.0170647
R2376 GND.n597 GND.n596 0.0170647
R2377 GND.n598 GND.n597 0.0170647
R2378 GND.n598 GND.n507 0.0170647
R2379 GND.n602 GND.n507 0.0170647
R2380 GND.n603 GND.n602 0.0170647
R2381 GND.n604 GND.n603 0.0170647
R2382 GND.n604 GND.n502 0.0170647
R2383 GND.n609 GND.n502 0.0170647
R2384 GND.n612 GND.n611 0.0170647
R2385 GND.n613 GND.n612 0.0170647
R2386 GND.n613 GND.n497 0.0170647
R2387 GND.n618 GND.n497 0.0170647
R2388 GND.n619 GND.n618 0.0170647
R2389 GND.n620 GND.n619 0.0170647
R2390 GND.n620 GND.n494 0.0170647
R2391 GND.n624 GND.n494 0.0170647
R2392 GND.n625 GND.n624 0.0170647
R2393 GND.n626 GND.n625 0.0170647
R2394 GND.n626 GND.n489 0.0170647
R2395 GND.n631 GND.n489 0.0170647
R2396 GND.n1202 GND.n1201 0.0170647
R2397 GND.n1203 GND.n1202 0.0170647
R2398 GND.n1203 GND.n484 0.0170647
R2399 GND.n1207 GND.n484 0.0170647
R2400 GND.n1208 GND.n1207 0.0170647
R2401 GND.n1192 GND.n483 0.0170647
R2402 GND.n1192 GND.n1191 0.0170647
R2403 GND.n1191 GND.n1190 0.0170647
R2404 GND.n1200 GND.n488 0.0170647
R2405 GND.n1204 GND.n488 0.0170647
R2406 GND.n1205 GND.n1204 0.0170647
R2407 GND.n1206 GND.n1205 0.0170647
R2408 GND.n1206 GND.n482 0.0170647
R2409 GND.n1193 GND.n481 0.0170647
R2410 GND.n1193 GND.n1182 0.0170647
R2411 GND.n1189 GND.n1182 0.0170647
R2412 GND.n1189 GND.n1184 0.0170647
R2413 GND.n632 GND.n487 0.0170647
R2414 GND.n487 GND.n486 0.0170647
R2415 GND.n486 GND.n485 0.0170647
R2416 GND.n485 GND.n480 0.0170647
R2417 GND.n1194 GND.n151 0.0170647
R2418 GND.n1194 GND.n1181 0.0170647
R2419 GND.n1188 GND.n1181 0.0170647
R2420 GND.n1188 GND.n1185 0.0170647
R2421 GND.n1212 GND.n478 0.0170647
R2422 GND.n655 GND.n478 0.0170647
R2423 GND.n655 GND.n652 0.0170647
R2424 GND.n659 GND.n652 0.0170647
R2425 GND.n659 GND.n634 0.0170647
R2426 GND.n665 GND.n634 0.0170647
R2427 GND.n143 GND.n633 0.00925198
R2428 GND.n646 GND.n633 0.0170647
R2429 GND.n646 GND.n639 0.0170647
R2430 GND.n640 GND.n639 0.0170647
R2431 GND.n1213 GND.n477 0.0170647
R2432 GND.n654 GND.n477 0.0170647
R2433 GND.n654 GND.n651 0.0170647
R2434 GND.n660 GND.n651 0.0170647
R2435 GND.n660 GND.n636 0.0170647
R2436 GND.n664 GND.n636 0.0170647
R2437 GND.n664 GND.n635 0.0170647
R2438 GND.n647 GND.n635 0.0170647
R2439 GND.n647 GND.n638 0.0170647
R2440 GND.n641 GND.n638 0.0170647
R2441 GND.n263 GND.n442 0.0170647
R2442 GND.n1320 GND.n442 0.0170647
R2443 GND.n1321 GND.n1320 0.0170647
R2444 GND.n1321 GND.n1313 0.0170647
R2445 GND.n1325 GND.n1313 0.0170647
R2446 GND.n1326 GND.n1325 0.0170647
R2447 GND.n1327 GND.n1326 0.0170647
R2448 GND.n1327 GND.n1309 0.0170647
R2449 GND.n1331 GND.n1309 0.0170647
R2450 GND.n1332 GND.n1331 0.0170647
R2451 GND.n1333 GND.n1332 0.0170647
R2452 GND.n1333 GND.n1308 0.0170647
R2453 GND.n1307 GND.n459 0.0170647
R2454 GND.n1286 GND.n459 0.0170647
R2455 GND.n1287 GND.n1286 0.0170647
R2456 GND.n1288 GND.n1287 0.0170647
R2457 GND.n1288 GND.n1281 0.0170647
R2458 GND.n1294 GND.n1281 0.0170647
R2459 GND.n1295 GND.n1294 0.0170647
R2460 GND.n1296 GND.n1295 0.0170647
R2461 GND.n1296 GND.n1277 0.0170647
R2462 GND.n1302 GND.n1277 0.0170647
R2463 GND.n1303 GND.n1302 0.0170647
R2464 GND.n1304 GND.n1303 0.0170647
R2465 GND.n1276 GND.n464 0.0170647
R2466 GND.n1255 GND.n464 0.0170647
R2467 GND.n1256 GND.n1255 0.0170647
R2468 GND.n1257 GND.n1256 0.0170647
R2469 GND.n1257 GND.n1249 0.0170647
R2470 GND.n1263 GND.n1249 0.0170647
R2471 GND.n1264 GND.n1263 0.0170647
R2472 GND.n1265 GND.n1264 0.0170647
R2473 GND.n1265 GND.n1246 0.0170647
R2474 GND.n1271 GND.n1246 0.0170647
R2475 GND.n1272 GND.n1271 0.0170647
R2476 GND.n1273 GND.n1272 0.0170647
R2477 GND.n1245 GND.n469 0.0170647
R2478 GND.n1224 GND.n469 0.0170647
R2479 GND.n1225 GND.n1224 0.0170647
R2480 GND.n1226 GND.n1225 0.0170647
R2481 GND.n1226 GND.n1219 0.0170647
R2482 GND.n1232 GND.n1219 0.0170647
R2483 GND.n1233 GND.n1232 0.0170647
R2484 GND.n1234 GND.n1233 0.0170647
R2485 GND.n1234 GND.n1215 0.0170647
R2486 GND.n1240 GND.n1215 0.0170647
R2487 GND.n1241 GND.n1240 0.0170647
R2488 GND.n1242 GND.n1241 0.0170647
R2489 GND.n1214 GND.n476 0.0170647
R2490 GND.n653 GND.n476 0.0170647
R2491 GND.n653 GND.n650 0.0170647
R2492 GND.n661 GND.n650 0.0170647
R2493 GND.n662 GND.n661 0.0170647
R2494 GND.n663 GND.n662 0.0170647
R2495 GND.n663 GND.n649 0.0170647
R2496 GND.n649 GND.n648 0.0170647
R2497 GND.n648 GND.n637 0.0170647
R2498 GND.n1306 GND.n460 0.0170647
R2499 GND.n1285 GND.n460 0.0170647
R2500 GND.n1285 GND.n1283 0.0170647
R2501 GND.n1289 GND.n1283 0.0170647
R2502 GND.n1289 GND.n1282 0.0170647
R2503 GND.n1293 GND.n1282 0.0170647
R2504 GND.n1293 GND.n1280 0.0170647
R2505 GND.n1297 GND.n1280 0.0170647
R2506 GND.n1297 GND.n1278 0.0170647
R2507 GND.n1301 GND.n1278 0.0170647
R2508 GND.n1301 GND.n463 0.0170647
R2509 GND.n1305 GND.n463 0.0170647
R2510 GND.n1284 GND.n461 0.0170647
R2511 GND.n1290 GND.n461 0.0170647
R2512 GND.n1292 GND.n1291 0.0170647
R2513 GND.n1298 GND.n1279 0.0170647
R2514 GND.n1300 GND.n1299 0.0170647
R2515 GND.n571 GND.n527 0.0170647
R2516 GND.n571 GND.n317 0.00925955
R2517 GND.n572 GND.n323 0.0170647
R2518 GND.n326 GND.n329 0.00925955
R2519 GND.n389 GND.n329 0.0170647
R2520 GND.n389 GND.n315 0.00335487
R2521 GND.n578 GND.n380 0.0170647
R2522 GND.n367 GND.n519 0.00925955
R2523 GND.n584 GND.n519 0.0170647
R2524 GND.n584 GND.n518 0.0170647
R2525 GND.n566 GND.n528 0.0170647
R2526 GND.n570 GND.n528 0.0170647
R2527 GND.n570 GND.n525 0.0170647
R2528 GND.n573 GND.n525 0.0170647
R2529 GND.n573 GND.n523 0.0170647
R2530 GND.n577 GND.n523 0.0170647
R2531 GND.n577 GND.n522 0.0170647
R2532 GND.n579 GND.n522 0.0170647
R2533 GND.n579 GND.n520 0.0170647
R2534 GND.n583 GND.n520 0.0170647
R2535 GND.n583 GND.n517 0.0170647
R2536 GND.n586 GND.n517 0.0170647
R2537 GND.n1275 GND.n465 0.0170647
R2538 GND.n1254 GND.n465 0.0170647
R2539 GND.n1254 GND.n1252 0.0170647
R2540 GND.n1258 GND.n1252 0.0170647
R2541 GND.n1258 GND.n1250 0.0170647
R2542 GND.n1262 GND.n1250 0.0170647
R2543 GND.n1262 GND.n1248 0.0170647
R2544 GND.n1266 GND.n1248 0.0170647
R2545 GND.n1266 GND.n1247 0.0170647
R2546 GND.n1270 GND.n1247 0.0170647
R2547 GND.n1270 GND.n468 0.0170647
R2548 GND.n1274 GND.n468 0.0170647
R2549 GND.n1253 GND.n467 0.0170647
R2550 GND.n1259 GND.n1251 0.0170647
R2551 GND.n1261 GND.n1260 0.0170647
R2552 GND.n1261 GND.n76 0.00993862
R2553 GND.n1267 GND.n466 0.0170647
R2554 GND.n1269 GND.n1268 0.0170647
R2555 GND.n593 GND.n514 0.0170647
R2556 GND.n593 GND.n1 0.00925955
R2557 GND.n594 GND.n2 0.0170647
R2558 GND.n3 GND.n509 0.00925955
R2559 GND.n6 GND.n509 0.0170647
R2560 GND.n0 GND.n5 0.0151317
R2561 GND.n600 GND.n5 0.0170647
R2562 GND.n4 GND.n505 0.00925955
R2563 GND.n606 GND.n505 0.0170647
R2564 GND.n606 GND.n504 0.0170647
R2565 GND.n588 GND.n515 0.0170647
R2566 GND.n592 GND.n515 0.0170647
R2567 GND.n592 GND.n512 0.0170647
R2568 GND.n595 GND.n512 0.0170647
R2569 GND.n595 GND.n510 0.0170647
R2570 GND.n599 GND.n510 0.0170647
R2571 GND.n599 GND.n508 0.0170647
R2572 GND.n601 GND.n508 0.0170647
R2573 GND.n601 GND.n506 0.0170647
R2574 GND.n605 GND.n506 0.0170647
R2575 GND.n605 GND.n503 0.0170647
R2576 GND.n608 GND.n503 0.0170647
R2577 GND.n1244 GND.n470 0.0170647
R2578 GND.n1223 GND.n470 0.0170647
R2579 GND.n1223 GND.n1221 0.0170647
R2580 GND.n1227 GND.n1221 0.0170647
R2581 GND.n1227 GND.n1220 0.0170647
R2582 GND.n1231 GND.n1220 0.0170647
R2583 GND.n1231 GND.n1218 0.0170647
R2584 GND.n1235 GND.n1218 0.0170647
R2585 GND.n1235 GND.n1216 0.0170647
R2586 GND.n1239 GND.n1216 0.0170647
R2587 GND.n1239 GND.n475 0.0170647
R2588 GND.n1243 GND.n475 0.0170647
R2589 GND.n1222 GND.n321 0.0104863
R2590 GND.n1228 GND.n471 0.0170647
R2591 GND.n1230 GND.n1229 0.0170647
R2592 GND.n1236 GND.n1217 0.0170647
R2593 GND.n1238 GND.n1237 0.0170647
R2594 GND.n615 GND.n500 0.0170647
R2595 GND.n615 GND.n316 0.00925955
R2596 GND.n616 GND.n322 0.0170647
R2597 GND.n327 GND.n328 0.00925955
R2598 GND.n388 GND.n328 0.0170647
R2599 GND.n388 GND.n314 0.00335487
R2600 GND.n622 GND.n381 0.0170647
R2601 GND.n368 GND.n492 0.00925955
R2602 GND.n628 GND.n492 0.0170647
R2603 GND.n628 GND.n491 0.0170647
R2604 GND.n610 GND.n501 0.0170647
R2605 GND.n614 GND.n501 0.0170647
R2606 GND.n614 GND.n498 0.0170647
R2607 GND.n617 GND.n498 0.0170647
R2608 GND.n617 GND.n496 0.0170647
R2609 GND.n621 GND.n496 0.0170647
R2610 GND.n621 GND.n495 0.0170647
R2611 GND.n623 GND.n495 0.0170647
R2612 GND.n623 GND.n493 0.0170647
R2613 GND.n627 GND.n493 0.0170647
R2614 GND.n627 GND.n490 0.0170647
R2615 GND.n630 GND.n490 0.0170647
R2616 GND.n696 GND.n692 0.0158488
R2617 GND.n712 GND.n677 0.0153372
R2618 GND.n699 GND.n690 0.0153372
R2619 GND.n709 GND.n679 0.0148256
R2620 GND.n843 GND.n672 0.0147593
R2621 GND.n161 GND.n1032 0.01425
R2622 GND.n1177 GND.n1160 0.0138333
R2623 GND.n848 GND.n672 0.0137407
R2624 GND.n695 GND.n693 0.0132907
R2625 GND.n1152 GND.n243 0.0696317
R2626 GND.n1173 GND.n1172 0.0128164
R2627 GND.n1173 GND.n666 0.0128164
R2628 GND.n700 GND.n689 0.0127791
R2629 GND.n713 GND.n676 0.0122674
R2630 GND.n839 GND.n669 0.012213
R2631 GND.n1029 GND.n1028 0.0119583
R2632 GND.n1211 GND.n479 0.0119472
R2633 GND.n656 GND.n479 0.0119472
R2634 GND.n657 GND.n656 0.0119472
R2635 GND.n658 GND.n657 0.0119472
R2636 GND.n658 GND.t8 0.0119472
R2637 GND.n645 GND.n644 0.0119472
R2638 GND.n708 GND.n680 0.0117558
R2639 GND.n844 GND.n673 0.0117037
R2640 GND.n1158 GND.t24 0.0114091
R2641 GND.n1158 GND.n1157 0.0114091
R2642 GND.n1027 GND.n1026 0.0113854
R2643 GND.n95 GND.n1177 0.0273557
R2644 GND.n260 GND.n694 0.0107326
R2645 GND.n253 GND.n766 0.0104306
R2646 GND.n701 GND.n688 0.0102209
R2647 GND.n729 GND.n728 0.00978471
R2648 GND.n1151 GND.n718 0.00940274
R2649 GND.n1306 GND.n318 2.25851
R2650 GND.n333 GND.n332 0.0110013
R2651 GND.n1275 GND.n63 2.26021
R2652 GND.n69 GND.n68 0.0110013
R2653 GND.n1244 GND.n320 2.25851
R2654 GND.n1243 GND.n331 2.25851
R2655 GND.t2 GND.n315 1.06431
R2656 GND.t6 GND.n314 1.06431
R2657 GND.n7 GND.n311 0.578458
R2658 GND.n1036 GND.n191 0.396958
R2659 GND.n237 GND.n235 0.38798
R2660 GND.n237 GND.n236 0.282697
R2661 GND.n193 GND.n191 0.26725
R2662 GND.n313 GND.n60 0.00718619
R2663 GND.n1290 GND.n325 0.010059
R2664 GND.n319 GND.n462 0.0150317
R2665 GND.n1291 GND.n325 0.0104363
R2666 GND.n1292 GND.n382 0.0104363
R2667 GND.n1298 GND.n369 0.0104363
R2668 GND.n332 GND.n334 0.0150317
R2669 GND.n1251 GND.n64 0.0104363
R2670 GND.n1268 GND.n71 0.010059
R2671 GND.n1269 GND.n70 0.00450749
R2672 GND.n1253 GND.n64 0.010059
R2673 GND.n1259 GND.n80 0.010059
R2674 GND.n1267 GND.n71 0.0104363
R2675 GND.n68 GND.n70 0.0150317
R2676 GND.n1222 GND.n473 0.00927474
R2677 GND.n1229 GND.n324 0.0104363
R2678 GND.n1217 GND.n383 0.010059
R2679 GND.n474 GND.n330 0.0150317
R2680 GND.n473 GND.n472 0.00927474
R2681 GND.n1230 GND.n383 0.0104363
R2682 GND.n1236 GND.n370 0.0104363
R2683 GND.n1238 GND.n330 0.00450749
R2684 GND.n1336 GND.n444 0.00925297
R2685 GND.n1318 GND.n445 0.00925297
R2686 GND.n1315 GND.n446 0.00925297
R2687 GND.n1311 GND.n447 0.00925297
R2688 GND.n1310 GND.n448 0.00925297
R2689 GND.n449 GND.n1335 0.00925297
R2690 GND.n1317 GND.n445 0.00925297
R2691 GND.n1316 GND.n446 0.00925297
R2692 GND.n1314 GND.n447 0.00925297
R2693 GND.n457 GND.n448 0.00925297
R2694 GND.n547 GND.n452 0.00925297
R2695 GND.n546 GND.n451 0.00925297
R2696 GND.n541 GND.n450 0.00925297
R2697 GND.n540 GND.n453 0.00925297
R2698 GND.n454 GND.n562 0.00925297
R2699 GND.n563 GND.n531 0.00925297
R2700 GND.n543 GND.n451 0.00925297
R2701 GND.n542 GND.n450 0.00925297
R2702 GND.n561 GND.n453 0.00925297
R2703 GND.n454 GND.n533 0.00925297
R2704 GND.n1184 GND.n1183 0.00923687
R2705 GND.n643 GND.n640 0.00923112
R2706 GND.n527 GND.n526 0.00923037
R2707 GND.n585 GND.n518 0.00923037
R2708 GND.n514 GND.n513 0.00923037
R2709 GND.n607 GND.n504 0.00923037
R2710 GND.n500 GND.n499 0.00923037
R2711 GND.n629 GND.n491 0.00923037
R2712 GND.n462 GND.n318 0.0110013
R2713 GND.n467 GND.n63 0.0102927
R2714 GND.n472 GND.n320 0.0110013
R2715 GND.n474 GND.n331 0.0110013
R2716 GND.n1199 GND.n632 0.00922413
R2717 GND.n1186 GND.n1185 0.00922413
R2718 GND.n642 GND.n641 0.00922182
R2719 GND.n1209 GND.n1208 0.00878235
R2720 GND.n1209 GND.n483 0.00878235
R2721 GND.n1210 GND.n482 0.00878235
R2722 GND.n1210 GND.n481 0.00878235
R2723 GND.n152 GND.n480 0.00878235
R2724 GND.n123 GND.n151 0.00771435
R2725 GND.n707 GND.n681 0.00868605
R2726 GND.n845 GND.n674 0.00864815
R2727 GND.n736 GND.n719 0.00829167
R2728 GND.n848 GND.n842 0.00813889
R2729 GND.n849 GND.n840 0.00813889
R2730 GND.n1160 GND.n1159 0.00772222
R2731 GND.n702 GND.n687 0.00766279
R2732 GND.n847 GND.n844 0.00762963
R2733 GND.n849 GND.n670 0.00762963
R2734 GND.n1132 GND.n96 0.00691667
R2735 GND.n1128 GND.n1127 0.00691667
R2736 GND.n706 GND.n682 0.00612791
R2737 GND.n846 GND.n675 0.00610185
R2738 GND.n1161 GND.n97 0.0112525
R2739 GND.n1135 GND.n1134 0.00554167
R2740 GND.n703 GND.n686 0.00510465
R2741 GND.n1025 GND.n1024 0.00508333
R2742 GND.n735 GND.n722 0.00399163
R2743 GND.n705 GND.n683 0.00356977
R2744 GND.n733 GND.n731 0.00280126
R2745 GND.n735 GND.n734 0.00280126
R2746 GND.n189 GND.n253 0.716397
R2747 GND.n277 GND.n167 0.256167
R2748 GND.n1139 GND.n181 0.197125
R2749 GND.n170 GND.n169 0.178333
R2750 GND.n169 GND.n231 0.178333
R2751 GND.n231 GND.n229 0.178333
R2752 GND.n229 GND.n227 0.178333
R2753 GND.n227 GND.n225 0.178333
R2754 GND.n225 GND.n223 0.178333
R2755 GND.n223 GND.n221 0.178333
R2756 GND.n221 GND.n219 0.178333
R2757 GND.n219 GND.n217 0.178333
R2758 GND.n217 GND.n215 0.178333
R2759 GND.n215 GND.n213 0.178333
R2760 GND.n213 GND.n211 0.178333
R2761 GND.n211 GND.n209 0.178333
R2762 GND.n209 GND.n207 0.178333
R2763 GND.n207 GND.n205 0.178333
R2764 GND.n205 GND.n203 0.178333
R2765 GND.n203 GND.n201 0.178333
R2766 GND.n201 GND.n199 0.178333
R2767 GND.n199 GND.n197 0.178333
R2768 GND.n197 GND.n195 0.178333
R2769 GND.n195 GND.n193 0.178333
R2770 GND.n170 GND.n160 0.177417
R2771 GND.n190 GND.n92 0.077236
R2772 GND.n727 GND.n240 0.157663
R2773 GND.n168 GND.n264 0.0521845
R2774 GND.n311 GND.n308 0.0894167
R2775 GND.n308 GND.n306 0.0894167
R2776 GND.n306 GND.n304 0.0894167
R2777 GND.n304 GND.n302 0.0894167
R2778 GND.n302 GND.n300 0.0894167
R2779 GND.n300 GND.n298 0.0894167
R2780 GND.n298 GND.n296 0.0894167
R2781 GND.n296 GND.n294 0.0894167
R2782 GND.n294 GND.n292 0.0894167
R2783 GND.n292 GND.n290 0.0894167
R2784 GND.n290 GND.n288 0.0894167
R2785 GND.n288 GND.n286 0.0894167
R2786 GND.n286 GND.n284 0.0894167
R2787 GND.n284 GND.n282 0.0894167
R2788 GND.n282 GND.n280 0.0894167
R2789 GND.n280 GND.n278 0.0894167
R2790 GND.n278 GND.n276 0.0894167
R2791 GND.n276 GND.n168 0.167482
R2792 GND.n275 GND.n264 0.0894167
R2793 GND.n274 GND.n275 0.0894167
R2794 GND.n273 GND.n274 0.0894167
R2795 GND.n272 GND.n273 0.0894167
R2796 GND.n271 GND.n272 0.0894167
R2797 GND.n270 GND.n271 0.0894167
R2798 GND.n269 GND.n270 0.0894167
R2799 GND.n268 GND.n269 0.0894167
R2800 GND.n267 GND.n268 0.0894167
R2801 GND.n266 GND.n267 0.0894167
R2802 GND.n182 GND.n266 0.133287
R2803 GND.n419 GND.n1338 0.00264144
R2804 GND.n419 GND.n352 0.00206464
R2805 GND.n1339 GND.n418 0.00264144
R2806 GND.n417 GND.n1339 0.00206464
R2807 GND.n420 GND.n416 0.00264144
R2808 GND.n350 GND.n416 0.00206464
R2809 GND.n421 GND.n1340 0.00264144
R2810 GND.n421 GND.n349 0.00206464
R2811 GND.n1341 GND.n415 0.00264144
R2812 GND.n414 GND.n1341 0.00206464
R2813 GND.n422 GND.n413 0.00264144
R2814 GND.n348 GND.n413 0.00206464
R2815 GND.n423 GND.n1342 0.00264144
R2816 GND.n423 GND.n345 0.00206464
R2817 GND.n1343 GND.n412 0.00264144
R2818 GND.n411 GND.n1343 0.00206464
R2819 GND.n424 GND.n410 0.00264144
R2820 GND.n343 GND.n410 0.00206464
R2821 GND.n425 GND.n1344 0.00264144
R2822 GND.n425 GND.n344 0.00206464
R2823 GND.n1345 GND.n409 0.00264144
R2824 GND.n408 GND.n1345 0.00206464
R2825 GND.n426 GND.n407 0.00264144
R2826 GND.n346 GND.n407 0.00206464
R2827 GND.n427 GND.n1346 0.00264144
R2828 GND.n427 GND.n347 0.00206464
R2829 GND.n1347 GND.n406 0.00264144
R2830 GND.n405 GND.n1347 0.00206464
R2831 GND.n428 GND.n404 0.00264144
R2832 GND.n355 GND.n404 0.00206464
R2833 GND.n429 GND.n1348 0.00264144
R2834 GND.n429 GND.n354 0.00206464
R2835 GND.n1349 GND.n403 0.00264144
R2836 GND.n402 GND.n1349 0.00206464
R2837 GND.n430 GND.n401 0.00264144
R2838 GND.n353 GND.n401 0.00206464
R2839 GND.n431 GND.n1350 0.00264144
R2840 GND.n431 GND.n356 0.00206464
R2841 GND.n1351 GND.n400 0.00264144
R2842 GND.n399 GND.n1351 0.00206464
R2843 GND.n432 GND.n398 0.00264144
R2844 GND.n358 GND.n398 0.00206464
R2845 GND.n433 GND.n1352 0.00264144
R2846 GND.n433 GND.n357 0.00206464
R2847 GND.n1353 GND.n397 0.00264144
R2848 GND.n396 GND.n1353 0.00206464
R2849 GND.n434 GND.n395 0.00264144
R2850 GND.n363 GND.n395 0.00206464
R2851 GND.n435 GND.n1354 0.00264144
R2852 GND.n435 GND.n364 0.00206464
R2853 GND.n1355 GND.n394 0.00264144
R2854 GND.n393 GND.n1355 0.00206464
R2855 GND.n436 GND.n392 0.00264144
R2856 GND.n362 GND.n392 0.00206464
R2857 GND.n437 GND.n1356 0.00264144
R2858 GND.n437 GND.n361 0.00206464
R2859 GND.n1357 GND.n391 0.00264144
R2860 GND.n390 GND.n1357 0.00206464
R2861 GND.n438 GND.n360 0.00264144
R2862 GND.n1358 GND.n360 0.00264144
R2863 GND.n351 GND.n165 0.191134
R2864 GND.n441 GND.n149 0.00264144
R2865 GND.n12 GND.n149 0.00206464
R2866 GND.n150 GND.n82 0.00264144
R2867 GND.n14 GND.n81 0.00206464
R2868 GND.n147 GND.n81 0.00264144
R2869 GND.n147 GND.n15 0.00206464
R2870 GND.n144 GND.n13 0.00264144
R2871 GND.n84 GND.n13 0.00264144
R2872 GND.n17 GND.n83 0.00206464
R2873 GND.n83 GND.n138 0.00264144
R2874 GND.n18 GND.n138 0.00206464
R2875 GND.n139 GND.n16 0.00264144
R2876 GND.n16 GND.n128 0.00264144
R2877 GND.n20 GND.n128 0.00206464
R2878 GND.n129 GND.n135 0.00264144
R2879 GND.n135 GND.n21 0.00206464
R2880 GND.n19 GND.n130 0.00264144
R2881 GND.n19 GND.n122 0.00264144
R2882 GND.n122 GND.n28 0.00206464
R2883 GND.n120 GND.n111 0.00264144
R2884 GND.n120 GND.n27 0.00206464
R2885 GND.n119 GND.n29 0.00264144
R2886 GND.n110 GND.n29 0.00264144
R2887 GND.n110 GND.n23 0.00206464
R2888 GND.n102 GND.n103 0.00264144
R2889 GND.n24 GND.n103 0.00206464
R2890 GND.n104 GND.n22 0.00264144
R2891 GND.n22 GND.n88 0.00264144
R2892 GND.n89 GND.n25 0.00206464
R2893 GND.n89 GND.n91 0.00264144
R2894 GND.n91 GND.n26 0.00206464
R2895 GND.n86 GND.n90 0.00264144
R2896 GND.n86 GND.n30 0.00206464
R2897 GND.n85 GND.n105 0.00264144
R2898 GND.n108 GND.n31 0.00206464
R2899 GND.n108 GND.n101 0.00264144
R2900 GND.n32 GND.n100 0.00206464
R2901 GND.n35 GND.n100 0.00264144
R2902 GND.n35 GND.n118 0.00264144
R2903 GND.n33 GND.n117 0.00206464
R2904 GND.n113 GND.n117 0.00264144
R2905 GND.n34 GND.n112 0.00206464
R2906 GND.n112 GND.n38 0.00264144
R2907 GND.n132 GND.n38 0.00264144
R2908 GND.n36 GND.n131 0.00206464
R2909 GND.n131 GND.n127 0.00264144
R2910 GND.n137 GND.n37 0.00206464
R2911 GND.n137 GND.n10 0.00264144
R2912 GND.n10 GND.n140 0.00264144
R2913 GND.n142 GND.n11 0.00206464
R2914 GND.n142 GND.n75 0.00264144
R2915 GND.n39 GND.n74 0.00206464
R2916 GND.n8 GND.n74 0.00264144
R2917 GND.n8 GND.n146 0.00264144
R2918 GND.n9 GND.n145 0.00206464
R2919 GND.n73 GND.n145 0.00264144
R2920 GND.n42 GND.n72 0.00206464
R2921 GND.n72 GND.n148 0.00264144
R2922 GND.n155 GND.n40 0.00206464
R2923 GND.n155 GND.n154 0.00264144
R2924 GND.n41 GND.n153 0.191134
R2925 GND.n1359 GND.n359 0.00206464
R2926 GND.n1359 GND.n371 0.00264144
R2927 GND.n335 GND.n371 0.00206464
R2928 GND.n61 GND.n338 0.00362778
R2929 GND.n58 GND.n62 0.00783359
R2930 GND.n58 GND.n43 0.00282964
R2931 GND.n1360 GND.n59 0.0982861
R2932 GND.n387 GND.n1360 0.00206464
R2933 GND.n1361 GND.n386 0.00264144
R2934 GND.n342 GND.n386 0.00206464
R2935 GND.n385 GND.n1362 0.00264144
R2936 GND.n341 GND.n384 0.00206464
R2937 GND.n1363 GND.n384 0.00264144
R2938 GND.n379 GND.n1363 0.00206464
R2939 GND.n1364 GND.n378 0.00264144
R2940 GND.n340 GND.n378 0.00206464
R2941 GND.n377 GND.n1365 0.00264144
R2942 GND.n377 GND.n339 0.00206464
R2943 GND.n1366 GND.n376 0.00264144
R2944 GND.n375 GND.n1366 0.00206464
R2945 GND.n1367 GND.n374 0.00264144
R2946 GND.n337 GND.n374 0.00206464
R2947 GND.n373 GND.n1368 0.00264144
R2948 GND.n373 GND.n336 0.00206464
R2949 GND.n1369 GND.n372 0.00264144
R2950 GND.n1369 GND.n365 0.00206464
R2951 GND.n57 GND.n365 0.0174707
R2952 GND.n359 GND.n166 0.191134
R2953 GND.n156 GND.n440 0.00264144
R2954 GND.n156 GND.n56 0.00406977
R2955 GND.n335 GND.n61 0.00363081
R2956 GND.n62 GND.n56 0.0945998
R2957 GND.n59 GND.n43 0.00379144
R2958 GND.n59 GND.n45 0.00519701
R2959 GND.n141 GND.n44 0.00264144
R2960 GND.n136 GND.n44 0.00264144
R2961 GND.n136 GND.n47 0.00206464
R2962 GND.n126 GND.n133 0.00264144
R2963 GND.n48 GND.n133 0.00206464
R2964 GND.n134 GND.n46 0.00264144
R2965 GND.n46 GND.n114 0.00264144
R2966 GND.n50 GND.n114 0.00206464
R2967 GND.n115 GND.n121 0.00264144
R2968 GND.n121 GND.n51 0.00206464
R2969 GND.n49 GND.n116 0.00264144
R2970 GND.n49 GND.n109 0.00264144
R2971 GND.n109 GND.n53 0.00206464
R2972 GND.n107 GND.n99 0.00264144
R2973 GND.n107 GND.n54 0.00206464
R2974 GND.n106 GND.n52 0.00264144
R2975 GND.n52 GND.n439 0.00264144
R2976 GND.n87 GND.n55 0.00206464
R2977 GND.n87 GND.n57 0.0161864
R2978 GND.n159 GND.n158 0.0445
R2979 GND.n162 GND.n161 0.04175
R2980 GND.n645 GND.t8 0.0391489
R2981 GND.n731 GND.n164 0.0346381
R2982 GND.n1169 GND.n98 4.51706
R2983 GND.t4 GND.n0 1.06629
R2984 GND GND.n0 0.0005
R2985 a_n7059_10169.t7 a_n7059_10169.n4 17.0005
R2986 a_n7059_10169.t7 a_n7059_10169.n78 17.0005
R2987 a_n7059_10169.t7 a_n7059_10169.n5 17.0005
R2988 a_n7059_10169.t6 a_n7059_10169.n14 17.0005
R2989 a_n7059_10169.t6 a_n7059_10169.n19 17.0005
R2990 a_n7059_10169.t5 a_n7059_10169.n49 17.0005
R2991 a_n7059_10169.t5 a_n7059_10169.n54 17.0005
R2992 a_n7059_10169.t4 a_n7059_10169.n31 17.0005
R2993 a_n7059_10169.t4 a_n7059_10169.n36 17.0005
R2994 a_n7059_10169.n9 a_n7059_10169.n6 9.0869
R2995 a_n7059_10169.n23 a_n7059_10169.n10 9.02566
R2996 a_n7059_10169.n58 a_n7059_10169.n45 9.02566
R2997 a_n7059_10169.n40 a_n7059_10169.n27 9.02566
R2998 a_n7059_10169.n22 a_n7059_10169.n11 9.01416
R2999 a_n7059_10169.n57 a_n7059_10169.n46 9.01416
R3000 a_n7059_10169.n39 a_n7059_10169.n28 9.01416
R3001 a_n7059_10169.n72 a_n7059_10169.n8 9.0005
R3002 a_n7059_10169.n75 a_n7059_10169.n3 9.0005
R3003 a_n7059_10169.n77 a_n7059_10169.n76 9.0005
R3004 a_n7059_10169.n71 a_n7059_10169.n70 9.0005
R3005 a_n7059_10169.n74 a_n7059_10169.n73 9.0005
R3006 a_n7059_10169.n75 a_n7059_10169.t0 9.0005
R3007 a_n7059_10169.t0 a_n7059_10169.n74 9.0005
R3008 a_n7059_10169.n44 a_n7059_10169.n27 9.0005
R3009 a_n7059_10169.n44 a_n7059_10169.n28 9.0005
R3010 a_n7059_10169.n62 a_n7059_10169.n45 9.0005
R3011 a_n7059_10169.n62 a_n7059_10169.n46 9.0005
R3012 a_n7059_10169.t0 a_n7059_10169.n10 9.0005
R3013 a_n7059_10169.t0 a_n7059_10169.n11 9.0005
R3014 a_n7059_10169.n15 a_n7059_10169.n13 9.0005
R3015 a_n7059_10169.n25 a_n7059_10169.n24 9.0005
R3016 a_n7059_10169.n21 a_n7059_10169.n20 9.0005
R3017 a_n7059_10169.n18 a_n7059_10169.n17 9.0005
R3018 a_n7059_10169.n50 a_n7059_10169.n48 9.0005
R3019 a_n7059_10169.n60 a_n7059_10169.n59 9.0005
R3020 a_n7059_10169.n56 a_n7059_10169.n55 9.0005
R3021 a_n7059_10169.n53 a_n7059_10169.n52 9.0005
R3022 a_n7059_10169.n32 a_n7059_10169.n30 9.0005
R3023 a_n7059_10169.n42 a_n7059_10169.n41 9.0005
R3024 a_n7059_10169.n38 a_n7059_10169.n37 9.0005
R3025 a_n7059_10169.n35 a_n7059_10169.n34 9.0005
R3026 a_n7059_10169.t7 a_n7059_10169.n7 8.46794
R3027 a_n7059_10169.t6 a_n7059_10169.n16 8.46794
R3028 a_n7059_10169.t5 a_n7059_10169.n51 8.46794
R3029 a_n7059_10169.t4 a_n7059_10169.n33 8.46794
R3030 a_n7059_10169.t0 a_n7059_10169.n2 4.46488
R3031 a_n7059_10169.t0 a_n7059_10169.n9 4.46488
R3032 a_n7059_10169.n44 a_n7059_10169.n43 4.46488
R3033 a_n7059_10169.n44 a_n7059_10169.n29 4.46488
R3034 a_n7059_10169.n62 a_n7059_10169.n61 4.46488
R3035 a_n7059_10169.n62 a_n7059_10169.n47 4.46488
R3036 a_n7059_10169.t0 a_n7059_10169.n26 4.46488
R3037 a_n7059_10169.t0 a_n7059_10169.n12 4.46488
R3038 a_n7059_10169.t7 a_n7059_10169.n3 4.45404
R3039 a_n7059_10169.n23 a_n7059_10169.t6 3.51012
R3040 a_n7059_10169.n58 a_n7059_10169.t5 3.51012
R3041 a_n7059_10169.n40 a_n7059_10169.t4 3.51011
R3042 a_n7059_10169.n63 a_n7059_10169.t15 2.95915
R3043 a_n7059_10169.t0 a_n7059_10169.t2 2.11968
R3044 a_n7059_10169.n69 a_n7059_10169.t8 1.92113
R3045 a_n7059_10169.n68 a_n7059_10169.t9 1.92113
R3046 a_n7059_10169.n67 a_n7059_10169.t10 1.92113
R3047 a_n7059_10169.n66 a_n7059_10169.t11 1.92113
R3048 a_n7059_10169.n65 a_n7059_10169.t12 1.92113
R3049 a_n7059_10169.n64 a_n7059_10169.t13 1.92113
R3050 a_n7059_10169.n63 a_n7059_10169.t14 1.92113
R3051 a_n7059_10169.t6 a_n7059_10169.n22 1.73598
R3052 a_n7059_10169.t5 a_n7059_10169.n57 1.73598
R3053 a_n7059_10169.t4 a_n7059_10169.n39 1.73598
R3054 a_n7059_10169.t7 a_n7059_10169.n6 1.73518
R3055 a_n7059_10169.n64 a_n7059_10169.n63 1.04103
R3056 a_n7059_10169.n65 a_n7059_10169.n64 1.04103
R3057 a_n7059_10169.n66 a_n7059_10169.n65 1.04103
R3058 a_n7059_10169.n67 a_n7059_10169.n66 1.04103
R3059 a_n7059_10169.n68 a_n7059_10169.n67 1.04103
R3060 a_n7059_10169.n69 a_n7059_10169.n68 1.04103
R3061 a_n7059_10169.n70 a_n7059_10169.n6 0.169041
R3062 a_n7059_10169.n22 a_n7059_10169.n21 0.169035
R3063 a_n7059_10169.n57 a_n7059_10169.n56 0.169035
R3064 a_n7059_10169.n39 a_n7059_10169.n38 0.169035
R3065 a_n7059_10169.n41 a_n7059_10169.n40 0.157744
R3066 a_n7059_10169.n24 a_n7059_10169.n23 0.157744
R3067 a_n7059_10169.n59 a_n7059_10169.n58 0.157744
R3068 a_n7059_10169.t0 a_n7059_10169.n0 0.148824
R3069 a_n7059_10169.n76 a_n7059_10169.n75 0.146155
R3070 a_n7059_10169.n74 a_n7059_10169.n72 0.146155
R3071 a_n7059_10169.n74 a_n7059_10169.n71 0.146155
R3072 a_n7059_10169.n25 a_n7059_10169.n10 0.146155
R3073 a_n7059_10169.n17 a_n7059_10169.n13 0.146155
R3074 a_n7059_10169.n20 a_n7059_10169.n11 0.146155
R3075 a_n7059_10169.n60 a_n7059_10169.n45 0.146155
R3076 a_n7059_10169.n52 a_n7059_10169.n48 0.146155
R3077 a_n7059_10169.n55 a_n7059_10169.n46 0.146155
R3078 a_n7059_10169.n42 a_n7059_10169.n27 0.146155
R3079 a_n7059_10169.n34 a_n7059_10169.n30 0.146155
R3080 a_n7059_10169.n37 a_n7059_10169.n28 0.146155
R3081 a_n7059_10169.n4 a_n7059_10169.n3 0.119983
R3082 a_n7059_10169.n78 a_n7059_10169.n8 0.112397
R3083 a_n7059_10169.n15 a_n7059_10169.n14 0.112397
R3084 a_n7059_10169.n50 a_n7059_10169.n49 0.112397
R3085 a_n7059_10169.n32 a_n7059_10169.n31 0.112397
R3086 a_n7059_10169.n73 a_n7059_10169.n5 0.102914
R3087 a_n7059_10169.n19 a_n7059_10169.n18 0.102914
R3088 a_n7059_10169.n54 a_n7059_10169.n53 0.102914
R3089 a_n7059_10169.n36 a_n7059_10169.n35 0.102914
R3090 a_n7059_10169.n73 a_n7059_10169.n7 0.097466
R3091 a_n7059_10169.n18 a_n7059_10169.n16 0.097466
R3092 a_n7059_10169.n53 a_n7059_10169.n51 0.097466
R3093 a_n7059_10169.n35 a_n7059_10169.n33 0.097466
R3094 a_n7059_10169.n8 a_n7059_10169.n7 0.0860866
R3095 a_n7059_10169.n16 a_n7059_10169.n15 0.0860866
R3096 a_n7059_10169.n51 a_n7059_10169.n50 0.0860866
R3097 a_n7059_10169.n33 a_n7059_10169.n32 0.0860866
R3098 a_n7059_10169.n70 a_n7059_10169.n5 0.0801552
R3099 a_n7059_10169.n21 a_n7059_10169.n19 0.0801552
R3100 a_n7059_10169.n56 a_n7059_10169.n54 0.0801552
R3101 a_n7059_10169.n38 a_n7059_10169.n36 0.0801552
R3102 a_n7059_10169.n76 a_n7059_10169.n2 0.073243
R3103 a_n7059_10169.n71 a_n7059_10169.n9 0.073243
R3104 a_n7059_10169.n72 a_n7059_10169.n2 0.073243
R3105 a_n7059_10169.n43 a_n7059_10169.n30 0.073243
R3106 a_n7059_10169.n37 a_n7059_10169.n29 0.073243
R3107 a_n7059_10169.n61 a_n7059_10169.n48 0.073243
R3108 a_n7059_10169.n55 a_n7059_10169.n47 0.073243
R3109 a_n7059_10169.n26 a_n7059_10169.n13 0.073243
R3110 a_n7059_10169.n20 a_n7059_10169.n12 0.073243
R3111 a_n7059_10169.n26 a_n7059_10169.n25 0.073243
R3112 a_n7059_10169.n17 a_n7059_10169.n12 0.073243
R3113 a_n7059_10169.n61 a_n7059_10169.n60 0.073243
R3114 a_n7059_10169.n52 a_n7059_10169.n47 0.073243
R3115 a_n7059_10169.n43 a_n7059_10169.n42 0.073243
R3116 a_n7059_10169.n34 a_n7059_10169.n29 0.073243
R3117 a_n7059_10169.n78 a_n7059_10169.n77 0.0706724
R3118 a_n7059_10169.n24 a_n7059_10169.n14 0.0706724
R3119 a_n7059_10169.n59 a_n7059_10169.n49 0.0706724
R3120 a_n7059_10169.n41 a_n7059_10169.n31 0.0706724
R3121 a_n7059_10169.n77 a_n7059_10169.n4 0.0630862
R3122 a_n7059_10169.n62 a_n7059_10169.n0 0.0409565
R3123 a_n7059_10169.n0 a_n7059_10169.n44 0.0399588
R3124 a_n7059_10169.n62 a_n7059_10169.n1 0.0388207
R3125 a_n7059_10169.n69 a_n7059_10169.n1 12.1361
R3126 a_n7059_10169.t0 a_n7059_10169.t3 2.16347
R3127 a_n7059_10169.n1 a_n7059_10169.t0 1.00288
C170 VBGR GND 7.59725f
C171 VDD GND 77.4924f
C172 m3_1900_17599# GND 0.05927f
C173 a_527_13669# GND 9.10734f ; **FLOATING
C174 a_n7289_14433# GND 4.06519f ; **FLOATING
C175 a_3822_10479# GND 4.87096f ; **FLOATING
C176 a_527_14697# GND 4.05678f ; **FLOATING
C177 a_n7289_14961# GND 4.04704f ; **FLOATING
C178 a_n7289_15489# GND 4.04559f ; **FLOATING
C179 a_527_15753# GND 4.03175f ; **FLOATING
C180 a_n7289_16017# GND 4.045f ; **FLOATING
C181 a_3630_15211# GND 5.28279f ; **FLOATING
C182 a_5580_15247# GND 45.2633f ; **FLOATING
C183 a_4707_16560# GND 1.15657f ; **FLOATING
C184 a_n6059_10861# GND 16.72888f ; **FLOATING
C185 a_1804_15931# GND 5.92808f ; **FLOATING
C186 a_n6059_11418# GND 7.04318f ; **FLOATING
C187 a_527_16281# GND 4.04577f ; **FLOATING
C188 a_n7289_16545# GND 33.27664f ; **FLOATING
C189 a_528_16809# GND 4.79875f ; **FLOATING
C190 a_n7288_17115# GND 4.80647f ; **FLOATING
C191 a_528_17421# GND 4.79941f ; **FLOATING
C192 a_n7288_17727# GND 4.81151f ; **FLOATING
C193 a_528_18033# GND 4.83401f ; **FLOATING
C194 a_981_18638# GND 0.8024f ; **FLOATING
C195 a_n7288_18340# GND 5.2285f ; **FLOATING
C196 w_n7489_9836# GND 0.21456f
C197 w_3320_10081# GND 0.1031f
C198 w_8745_13831# GND 0.02418f
C199 w_3320_16060# GND 0.123f
C200 w_1450_16710# GND 0.03111f
C201 a_n7059_10169.n0 GND 0.72648f ; **FLOATING
C202 a_n7059_10169.t0 GND 53.1499f ; **FLOATING
C203 a_n7059_10169.n1 GND 1.01131f ; **FLOATING
C204 a_n7059_10169.t3 GND 0.31223f ; **FLOATING
C205 a_n7059_10169.n3 GND 0.01375f ; **FLOATING
C206 a_n7059_10169.n6 GND 0.02999f ; **FLOATING
C207 a_n7059_10169.t2 GND 0.25218f ; **FLOATING
C208 a_n7059_10169.n22 GND 0.02993f ; **FLOATING
C209 a_n7059_10169.t6 GND 0.21965f ; **FLOATING
C210 a_n7059_10169.n23 GND 0.01522f ; **FLOATING
C211 a_n7059_10169.n39 GND 0.02993f ; **FLOATING
C212 a_n7059_10169.t4 GND 0.21965f ; **FLOATING
C213 a_n7059_10169.n40 GND 0.01522f ; **FLOATING
C214 a_n7059_10169.n44 GND 1.57171f ; **FLOATING
C215 a_n7059_10169.n57 GND 0.02993f ; **FLOATING
C216 a_n7059_10169.t5 GND 0.21965f ; **FLOATING
C217 a_n7059_10169.n58 GND 0.01522f ; **FLOATING
C218 a_n7059_10169.n62 GND 0.96266f ; **FLOATING
C219 a_n7059_10169.t8 GND 2.31422f ; **FLOATING
C220 a_n7059_10169.t15 GND 2.38205f ; **FLOATING
C221 a_n7059_10169.t14 GND 2.31422f ; **FLOATING
C222 a_n7059_10169.n63 GND 0.32534f ; **FLOATING
C223 a_n7059_10169.t13 GND 2.31422f ; **FLOATING
C224 a_n7059_10169.n64 GND 0.20035f ; **FLOATING
C225 a_n7059_10169.t12 GND 2.31422f ; **FLOATING
C226 a_n7059_10169.n65 GND 0.20035f ; **FLOATING
C227 a_n7059_10169.t11 GND 2.31422f ; **FLOATING
C228 a_n7059_10169.n66 GND 0.20035f ; **FLOATING
C229 a_n7059_10169.t10 GND 2.31422f ; **FLOATING
C230 a_n7059_10169.n67 GND 0.20035f ; **FLOATING
C231 a_n7059_10169.t9 GND 2.31422f ; **FLOATING
C232 a_n7059_10169.n68 GND 0.20035f ; **FLOATING
C233 a_n7059_10169.n69 GND 0.38195f ; **FLOATING
C234 a_n7059_10169.t7 GND 0.21965f ; **FLOATING
C235 GND.t59 GND 6.63315f ; **FLOATING
C236 GND.t31 GND 1.07696f ; **FLOATING
C237 GND.t22 GND 2.63987f ; **FLOATING
C238 VDD.t49 GND 19.1038f ; **FLOATING
C239 VDD.n0 GND 0.08528f ; **FLOATING
C240 VDD.n1 GND 0.18115f ; **FLOATING
C241 VDD.t0 GND 18.3511f ; **FLOATING
C242 VDD.n2 GND 0.29501f ; **FLOATING
C243 VDD.n3 GND 0.18033f ; **FLOATING
C244 VDD.n4 GND 0.18906f ; **FLOATING
C245 VDD.n5 GND 0.01821f ; **FLOATING
C246 VDD.n6 GND 0.06222f ; **FLOATING
C247 VDD.n7 GND 0.02099f ; **FLOATING
C248 VDD.n8 GND 0.1925f ; **FLOATING
C249 VDD.n9 GND 0.18371f ; **FLOATING
C250 VDD.n10 GND 0.01375f ; **FLOATING
C251 VDD.n12 GND 0.01054f ; **FLOATING
C252 VDD.n13 GND 0.31734f ; **FLOATING
C253 VDD.n15 GND 0.25581f ; **FLOATING
C254 VDD.n16 GND 0.12994f ; **FLOATING
C255 VDD.t68 GND 37.4071f ; **FLOATING
C256 VDD.n17 GND 1.40968f ; **FLOATING
C257 VDD.n18 GND 0.94836f ; **FLOATING
C258 VDD.t57 GND 0.0909f ; **FLOATING
C259 VDD.n20 GND 0.05364f ; **FLOATING
C260 VDD.n22 GND 0.01293f ; **FLOATING
C261 VDD.t32 GND 0.12431f ; **FLOATING
C262 VDD.n23 GND 0.02377f ; **FLOATING
C263 VDD.n25 GND 0.03412f ; **FLOATING
C264 VDD.n27 GND 0.06071f ; **FLOATING
C265 VDD.n28 GND 0.04208f ; **FLOATING
C266 VDD.n31 GND 0.0279f ; **FLOATING
C267 VDD.n34 GND 0.10239f ; **FLOATING
C268 VDD.n35 GND 0.0781f ; **FLOATING
C269 VDD.n36 GND 19.1127f ; **FLOATING
C270 VDD.n37 GND 0.08742f ; **FLOATING
C271 VDD.n38 GND 0.19332f ; **FLOATING
C272 VDD.n39 GND 0.03361f ; **FLOATING
C273 VDD.n40 GND 0.07207f ; **FLOATING
C274 VDD.n41 GND 0.10877f ; **FLOATING
C275 VDD.n43 GND 0.01801f ; **FLOATING
C276 VDD.n45 GND 0.06121f ; **FLOATING
C277 VDD.n46 GND 0.26716f ; **FLOATING
C278 VDD.n47 GND 0.01209f ; **FLOATING
C279 VDD.n48 GND 0.02159f ; **FLOATING
C280 VDD.n49 GND 0.01412f ; **FLOATING
C281 VDD.n51 GND 0.03467f ; **FLOATING
C282 VDD.n52 GND 0.01078f ; **FLOATING
C283 VDD.t60 GND 0.09815f ; **FLOATING
C284 VDD.n53 GND 0.03031f ; **FLOATING
C285 VDD.n56 GND 0.02828f ; **FLOATING
C286 VDD.n57 GND 0.01461f ; **FLOATING
C287 VDD.n59 GND 0.02841f ; **FLOATING
C288 VDD.n62 GND 0.01472f ; **FLOATING
C289 VDD.n63 GND 0.01116f ; **FLOATING
C290 VDD.n64 GND 0.01681f ; **FLOATING
C291 VDD.n65 GND 0.01026f ; **FLOATING
C292 VDD.n66 GND 0.49982f ; **FLOATING
C293 VDD.n67 GND 0.03524f ; **FLOATING
C294 VDD.n68 GND 1.18486f ; **FLOATING
C295 VDD.n69 GND 0.45068f ; **FLOATING
C296 VDD.n70 GND 2.51857f ; **FLOATING
C297 VDD.n71 GND 8.21464f ; **FLOATING
C298 VDD.n72 GND 0.66447f ; **FLOATING
C299 VDD.n73 GND 0.04014f ; **FLOATING
C300 VDD.n74 GND 0.0898f ; **FLOATING
C301 VDD.n75 GND 0.07372f ; **FLOATING
C302 VDD.n76 GND 0.01744f ; **FLOATING
C303 VDD.n77 GND 0.08619f ; **FLOATING
C304 VDD.t2 GND 0.03255f ; **FLOATING
C305 VDD.t41 GND 0.02058f ; **FLOATING
C306 VDD.n84 GND 0.05693f ; **FLOATING
C307 VDD.t40 GND 0.01811f ; **FLOATING
C308 VDD.n86 GND 0.05233f ; **FLOATING
C309 VDD.t42 GND 0.01895f ; **FLOATING
C310 VDD.t14 GND 0.05447f ; **FLOATING
C311 VDD.t13 GND 0.03304f ; **FLOATING
C312 VDD.t15 GND 0.0756f ; **FLOATING
C313 VDD.t1 GND 0.03304f ; **FLOATING
C314 VDD.t3 GND 0.05632f ; **FLOATING
C315 VDD.t9 GND 0.05619f ; **FLOATING
C316 VDD.t7 GND 0.03304f ; **FLOATING
C317 VDD.t8 GND 0.06668f ; **FLOATING
C318 VDD.t44 GND 0.01891f ; **FLOATING
C319 VDD.n88 GND 0.05147f ; **FLOATING
C320 VDD.t43 GND 0.01811f ; **FLOATING
C321 VDD.n95 GND 0.05735f ; **FLOATING
C322 VDD.t45 GND 0.02058f ; **FLOATING
C323 VDD.n96 GND 3.63155f ; **FLOATING
C324 VDD.n97 GND 0.0175f ; **FLOATING
C325 VDD.n98 GND 0.01748f ; **FLOATING
C326 VDD.n99 GND 0.03861f ; **FLOATING
C327 VDD.n100 GND 0.01514f ; **FLOATING
C328 VDD.n101 GND 0.06071f ; **FLOATING
C329 VDD.n102 GND 0.02415f ; **FLOATING
C330 VDD.n103 GND 0.01577f ; **FLOATING
C331 VDD.n104 GND 0.02786f ; **FLOATING
C332 VDD.n105 GND 0.13006f ; **FLOATING
C333 VDD.n106 GND 0.01766f ; **FLOATING
C334 VDD.n107 GND 0.07666f ; **FLOATING
C335 VDD.n108 GND 0.07518f ; **FLOATING
C336 VDD.n111 GND 0.01943f ; **FLOATING
C337 VDD.t25 GND 0.4519f ; **FLOATING
C338 VDD.n113 GND 0.01434f ; **FLOATING
C339 VDD.n114 GND 0.01322f ; **FLOATING
C340 VDD.t23 GND 0.4519f ; **FLOATING
C341 VDD.n117 GND 0.01515f ; **FLOATING
C342 VDD.t24 GND 0.06481f ; **FLOATING
C343 VDD.n118 GND 0.01902f ; **FLOATING
C344 VDD.n122 GND 0.02901f ; **FLOATING
C345 VDD.n123 GND 0.01826f ; **FLOATING
C346 VDD.n126 GND 0.01288f ; **FLOATING
C347 VDD.n131 GND 0.01237f ; **FLOATING
C348 VDD.t18 GND 0.07349f ; **FLOATING
C349 VDD.t16 GND 0.4519f ; **FLOATING
C350 VDD.n140 GND 0.01678f ; **FLOATING
C351 VDD.n143 GND 0.0142f ; **FLOATING
C352 VDD.t21 GND 0.4519f ; **FLOATING
C353 VDD.t22 GND 0.06794f ; **FLOATING
C354 VDD.t28 GND 0.06812f ; **FLOATING
C355 VDD.n145 GND 0.0629f ; **FLOATING
C356 VDD.n146 GND 0.01038f ; **FLOATING
C357 VDD.n147 GND 0.01137f ; **FLOATING
C358 VDD.n149 GND 0.01137f ; **FLOATING
C359 VDD.n150 GND 0.01137f ; **FLOATING
C360 VDD.n151 GND 0.01137f ; **FLOATING
C361 VDD.n153 GND 0.01137f ; **FLOATING
C362 VDD.n154 GND 0.01647f ; **FLOATING
C363 VDD.n156 GND 0.01697f ; **FLOATING
C364 VDD.n158 GND 0.01683f ; **FLOATING
C365 VDD.n160 GND 0.01748f ; **FLOATING
C366 VDD.t27 GND 0.4519f ; **FLOATING
C367 VDD.n161 GND 0.03301f ; **FLOATING
C368 VDD.n162 GND 0.02658f ; **FLOATING
C369 VDD.t29 GND 0.35448f ; **FLOATING
C370 VDD.n163 GND 0.26751f ; **FLOATING
C371 VDD.n167 GND 0.0501f ; **FLOATING
C372 VDD.t51 GND 1.03287f ; **FLOATING
C373 VDD.t55 GND 1.03287f ; **FLOATING
C374 VDD.t50 GND 0.10094f ; **FLOATING
C375 VDD.n168 GND 0.0104f ; **FLOATING
C376 VDD.n169 GND 0.01233f ; **FLOATING
C377 VDD.n170 GND 0.0104f ; **FLOATING
C378 VDD.n172 GND 0.0104f ; **FLOATING
C379 VDD.n173 GND 0.01012f ; **FLOATING
C380 VDD.n174 GND 0.0822f ; **FLOATING
C381 VDD.t67 GND 0.1061f ; **FLOATING
C382 VDD.t63 GND 1.07943f ; **FLOATING
C383 VDD.t61 GND 1.07943f ; **FLOATING
C384 VDD.n176 GND 0.08875f ; **FLOATING
C385 VDD.n177 GND 0.15984f ; **FLOATING
C386 VDD.n178 GND 0.05286f ; **FLOATING
C387 VDD.n179 GND 0.05931f ; **FLOATING
C388 VDD.t31 GND 0.4519f ; **FLOATING
C389 VDD.n180 GND 0.05947f ; **FLOATING
C390 VDD.n181 GND 0.06491f ; **FLOATING
C391 VDD.n182 GND 0.01012f ; **FLOATING
C392 VDD.n183 GND 0.13656f ; **FLOATING
C393 VDD.n184 GND 0.02031f ; **FLOATING
C394 VDD.n186 GND 0.01091f ; **FLOATING
C395 VDD.n188 GND 0.01091f ; **FLOATING
C396 VDD.n190 GND 0.01092f ; **FLOATING
C397 VDD.n192 GND 0.01092f ; **FLOATING
C398 VDD.n194 GND 0.01092f ; **FLOATING
C399 VDD.n196 GND 0.01092f ; **FLOATING
C400 VDD.n198 GND 0.01092f ; **FLOATING
C401 VDD.n200 GND 0.01092f ; **FLOATING
C402 VDD.n202 GND 0.01092f ; **FLOATING
C403 VDD.n204 GND 0.01092f ; **FLOATING
C404 VDD.n206 GND 0.01091f ; **FLOATING
C405 VDD.n208 GND 0.01091f ; **FLOATING
C406 VDD.n210 GND 0.01837f ; **FLOATING
C407 VDD.n211 GND 0.05875f ; **FLOATING
C408 VDD.n213 GND 0.05851f ; **FLOATING
C409 VDD.n215 GND 0.06261f ; **FLOATING
C410 VDD.n217 GND 0.0652f ; **FLOATING
C411 VDD.n218 GND 0.0615f ; **FLOATING
C412 VDD.n219 GND 0.01279f ; **FLOATING
C413 VDD.n220 GND 0.0154f ; **FLOATING
C414 VDD.n227 GND 0.03243f ; **FLOATING
C415 VDD.n228 GND 0.04199f ; **FLOATING
C416 VDD.n230 GND 0.01484f ; **FLOATING
C417 VDD.n231 GND 0.01322f ; **FLOATING
C418 VDD.n232 GND 0.01303f ; **FLOATING
C419 VDD.n233 GND 0.01322f ; **FLOATING
C420 VDD.n234 GND 0.01303f ; **FLOATING
C421 VDD.n235 GND 0.01322f ; **FLOATING
C422 VDD.n236 GND 0.01303f ; **FLOATING
C423 VDD.n237 GND 0.01303f ; **FLOATING
C424 VDD.n238 GND 0.01322f ; **FLOATING
C425 VDD.n239 GND 0.01222f ; **FLOATING
C426 VDD.n240 GND 0.0124f ; **FLOATING
C427 VDD.n241 GND 0.01222f ; **FLOATING
C428 VDD.n242 GND 0.0124f ; **FLOATING
C429 VDD.n243 GND 0.01222f ; **FLOATING
C430 VDD.n244 GND 0.01222f ; **FLOATING
C431 VDD.n245 GND 0.02241f ; **FLOATING
C432 VDD.n246 GND 0.01358f ; **FLOATING
C433 VDD.n247 GND 0.01358f ; **FLOATING
C434 VDD.n248 GND 0.01358f ; **FLOATING
C435 VDD.n249 GND 0.01408f ; **FLOATING
C436 VDD.n250 GND 0.0144f ; **FLOATING
C437 VDD.n251 GND 0.0144f ; **FLOATING
C438 VDD.n252 GND 0.0144f ; **FLOATING
C439 VDD.n253 GND 0.0144f ; **FLOATING
C440 VDD.n254 GND 0.01449f ; **FLOATING
C441 VDD.n255 GND 0.01322f ; **FLOATING
C442 VDD.n256 GND 0.01358f ; **FLOATING
C443 VDD.n257 GND 0.01358f ; **FLOATING
C444 VDD.n258 GND 0.01358f ; **FLOATING
C445 VDD.t59 GND 0.05118f ; **FLOATING
C446 VDD.n259 GND 0.09427f ; **FLOATING
C447 VDD.n260 GND 0.15655f ; **FLOATING
C448 VDD.t26 GND 0.05146f ; **FLOATING
C449 VDD.t20 GND 0.0514f ; **FLOATING
C450 VDD.n263 GND 0.01931f ; **FLOATING
C451 VDD.n264 GND 0.01728f ; **FLOATING
C452 VDD.n265 GND 0.01024f ; **FLOATING
C453 VDD.n268 GND 0.03601f ; **FLOATING
C454 VDD.n269 GND 0.02926f ; **FLOATING
C455 VDD.n270 GND 0.01895f ; **FLOATING
C456 VDD.n272 GND 0.01253f ; **FLOATING
C457 VDD.t19 GND 0.4519f ; **FLOATING
C458 VDD.n273 GND 0.02915f ; **FLOATING
C459 VDD.n275 GND 0.08201f ; **FLOATING
C460 VDD.n276 GND 0.0225f ; **FLOATING
C461 VDD.t58 GND 2.50224f ; **FLOATING
C462 VDD.n278 GND 0.04207f ; **FLOATING
C463 VDD.n279 GND 0.05923f ; **FLOATING
C464 VDD.n280 GND 0.05048f ; **FLOATING
C465 VDD.n281 GND 0.06017f ; **FLOATING
C466 VDD.t17 GND 14.1065f ; **FLOATING
C467 VDD.n283 GND 0.05531f ; **FLOATING
C468 VDD.n284 GND 0.03133f ; **FLOATING
C469 VDD.n285 GND 0.06023f ; **FLOATING
C470 VDD.n286 GND 0.08675f ; **FLOATING
C471 VDD.n288 GND 0.05683f ; **FLOATING
C472 VDD.n290 GND 0.07365f ; **FLOATING
C473 VDD.n291 GND 0.05731f ; **FLOATING
C474 VDD.n295 GND 0.03142f ; **FLOATING
C475 VDD.t34 GND 0.02158f ; **FLOATING
C476 VDD.n296 GND 0.02347f ; **FLOATING
C477 VDD.t36 GND 0.04809f ; **FLOATING
C478 VDD.t37 GND 0.04066f ; **FLOATING
C479 VDD.n298 GND 0.04911f ; **FLOATING
C480 VDD.n299 GND 0.05672f ; **FLOATING
C481 VDD.n300 GND 0.01148f ; **FLOATING
C482 VDD.t35 GND 0.05777f ; **FLOATING
C483 VDD.n302 GND 0.01212f ; **FLOATING
C484 VDD.n304 GND 0.08513f ; **FLOATING
C485 VDD.n306 GND 0.0354f ; **FLOATING
C486 VDD.n307 GND 0.03238f ; **FLOATING
C487 VDD.n308 GND 0.02854f ; **FLOATING
C488 VDD.n309 GND 0.11271f ; **FLOATING
C489 VDD.t39 GND 0.08509f ; **FLOATING
C490 VDD.t38 GND 1.14916f ; **FLOATING
C491 VDD.n311 GND 0.01555f ; **FLOATING
C492 VDD.n312 GND 0.01317f ; **FLOATING
C493 VDD.n314 GND 0.05647f ; **FLOATING
C494 VDD.n315 GND 0.07417f ; **FLOATING
C495 VDD.t33 GND 2.49877f ; **FLOATING
C496 VDD.n318 GND 0.03134f ; **FLOATING
C497 VDD.n319 GND 0.09517f ; **FLOATING
C498 VDD.n320 GND 0.02207f ; **FLOATING
C499 VDD.n321 GND 0.08745f ; **FLOATING
C500 VDD.n322 GND 0.02326f ; **FLOATING
C501 VDD.n323 GND 0.1671f ; **FLOATING
C502 VDD.n324 GND 0.11867f ; **FLOATING
C503 VDD.n325 GND 0.0303f ; **FLOATING
C504 VDD.n326 GND 0.07863f ; **FLOATING
C505 VDD.n327 GND 0.02338f ; **FLOATING
C506 VDD.n328 GND 0.02267f ; **FLOATING
C507 VDD.n329 GND 0.06071f ; **FLOATING
C508 VDD.n330 GND 0.02362f ; **FLOATING
C509 VDD.n331 GND 0.06071f ; **FLOATING
C510 VDD.n332 GND 0.02326f ; **FLOATING
C511 VDD.n333 GND 0.12659f ; **FLOATING
C512 VDD.n334 GND 0.02326f ; **FLOATING
C513 VDD.n335 GND 0.06071f ; **FLOATING
C514 VDD.n336 GND 0.02362f ; **FLOATING
C515 VDD.n337 GND 0.10095f ; **FLOATING
C516 VDD.n338 GND 0.02279f ; **FLOATING
C517 VDD.n339 GND 0.0235f ; **FLOATING
C518 VDD.n340 GND 0.06071f ; **FLOATING
C519 VDD.n341 GND 0.02338f ; **FLOATING
.ends
