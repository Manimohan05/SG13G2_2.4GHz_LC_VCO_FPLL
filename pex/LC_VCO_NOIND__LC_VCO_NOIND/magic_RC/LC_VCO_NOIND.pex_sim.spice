* Simulation copy of LC_VCO_NOIND.pex.spice: the four N-lines (sg13_hv_svaricap) are replaced by two Xvar instances (G1 W G2 bn) so ngspice can bind the PDK subcircuit.
* NGSPICE file created from LC_VCO_NOIND.ext - technology: ihp-sg13g2

.subckt LC_VCO_NOIND OUTp OUTn FOUT VCTRL VBGR GND VDD
X0 OUTn OUTp VDD VDD sg13_lv_pmos ad=1.368p pd=7.58u as=1.368p ps=7.58u w=7.2u l=0.13u
X1 a_22432_9659# OUTn VDD VDD sg13_lv_pmos ad=0.285p pd=1.88u as=0.285p ps=1.88u w=1.5u l=0.13u
X2 VDD OUTp FOUT VDD sg13_lv_pmos ad=0.285p pd=1.88u as=0.285p ps=1.88u w=1.5u l=0.13u
X3 VDD OUTp FOUT VDD sg13_lv_pmos ad=0.285p pd=1.88u as=0.285p ps=1.88u w=1.5u l=0.13u
X4 a_17580_450# a_12790_2770# GND.t13 GND.t12 sg13_lv_nmos ad=3.264p pd=19.88u as=1.824p ps=9.98u w=9.6u l=1u
X5 a_22432_9659# OUTn VDD VDD sg13_lv_pmos ad=0.285p pd=1.88u as=0.285p ps=1.88u w=1.5u l=0.13u
X6 GND.t40 a_12790_2770# a_17580_450# GND.t43 sg13_lv_nmos ad=1.824p pd=9.98u as=1.824p ps=9.98u w=9.6u l=1u
X7 GND.t54 a_12790_2770# a_17580_450# GND.t55 sg13_lv_nmos ad=1.824p pd=9.98u as=1.824p ps=9.98u w=9.6u l=1u
X8 a_17580_450# a_12790_2770# GND.t57 GND.t59 sg13_lv_nmos ad=1.824p pd=9.98u as=1.824p ps=9.98u w=9.6u l=1u
X9 a_17580_450# a_12790_2770# GND.t65 GND.t64 sg13_lv_nmos ad=1.824p pd=9.98u as=1.824p ps=9.98u w=9.6u l=1u
X10 GND.t65 a_12790_2770# a_17580_450# GND.t68 sg13_lv_nmos ad=1.824p pd=9.98u as=1.824p ps=9.98u w=9.6u l=1u
X11 GND.t16 a_12790_2770# a_17580_450# GND.t17 sg13_lv_nmos ad=1.824p pd=9.98u as=1.824p ps=9.98u w=9.6u l=1u
X12 a_12790_2770# VBGR VDD VDD sg13_lv_pmos ad=1.444p pd=7.98u as=1.444p ps=7.98u w=7.6u l=1u
X13 OUTn OUTp a_17580_450# GND.t7 sg13_lv_nmos ad=1.3927p pd=7.71u as=2.4922p ps=15.34u w=7.33u l=0.13u
X14 a_17580_450# a_12790_2770# GND.t54 GND.t53 sg13_lv_nmos ad=1.824p pd=9.98u as=1.824p ps=9.98u w=9.6u l=1u
X15 GND.t62 a_12790_2770# a_17580_450# GND.t63 sg13_lv_nmos ad=1.824p pd=9.98u as=1.824p ps=9.98u w=9.6u l=1u
X17 VDD VBGR a_12790_2770# VDD sg13_lv_pmos ad=1.444p pd=7.98u as=1.444p ps=7.98u w=7.6u l=1u
X18 GND.t21 a_12790_2770# a_17580_450# GND.t22 sg13_lv_nmos ad=1.824p pd=9.98u as=1.824p ps=9.98u w=9.6u l=1u
X19 a_17580_450# a_12790_2770# GND.t24 GND.t26 sg13_lv_nmos ad=1.824p pd=9.98u as=1.824p ps=9.98u w=9.6u l=1u
X20 a_17580_450# a_12790_2770# GND.t21 GND.t20 sg13_lv_nmos ad=1.824p pd=9.98u as=1.824p ps=9.98u w=9.6u l=1u
X21 a_17580_450# OUTn OUTp GND.t4 sg13_lv_nmos ad=1.3927p pd=7.71u as=2.4922p ps=15.34u w=7.33u l=0.13u
X22 OUTn OUTp VDD VDD sg13_lv_pmos ad=1.368p pd=7.58u as=1.368p ps=7.58u w=7.2u l=0.13u
X23 a_12790_2770# a_12790_2770# GND.t11 GND.t46 sg13_lv_nmos ad=1.52p pd=8.38u as=1.52p ps=8.38u w=8u l=1u
X24 VDD OUTp FOUT VDD sg13_lv_pmos ad=0.285p pd=1.88u as=0.285p ps=1.88u w=1.5u l=0.13u
X25 a_17580_450# OUTn OUTp GND.t2 sg13_lv_nmos ad=2.4922p pd=15.34u as=1.3927p ps=7.71u w=7.33u l=0.13u
X26 a_12790_2770# a_12790_2770# GND.t42 GND.t41 sg13_lv_nmos ad=2.72p pd=16.68u as=1.52p ps=8.38u w=8u l=1u
X27 VDD OUTn OUTp VDD sg13_lv_pmos ad=1.368p pd=7.58u as=1.368p ps=7.58u w=7.2u l=0.13u
X28 FOUT OUTp VDD VDD sg13_lv_pmos ad=0.285p pd=1.88u as=0.285p ps=1.88u w=1.5u l=0.13u
X29 FOUT OUTp VDD VDD sg13_lv_pmos ad=0.51p pd=3.68u as=0.285p ps=1.88u w=1.5u l=0.13u
X30 VDD OUTn a_22432_9659# VDD sg13_lv_pmos ad=0.285p pd=1.88u as=0.285p ps=1.88u w=1.5u l=0.13u
X31 VDD OUTn a_22432_9659# VDD sg13_lv_pmos ad=0.285p pd=1.88u as=0.285p ps=1.88u w=1.5u l=0.13u
X33 VDD OUTn OUTp VDD sg13_lv_pmos ad=1.368p pd=7.58u as=1.368p ps=7.58u w=7.2u l=0.13u
X34 a_17580_450# a_12790_2770# GND.t65 GND.t67 sg13_lv_nmos ad=1.824p pd=9.98u as=1.824p ps=9.98u w=9.6u l=1u
X35 GND.t29 a_12790_2770# a_17580_450# GND.t30 sg13_lv_nmos ad=1.824p pd=9.98u as=1.824p ps=9.98u w=9.6u l=1u
X36 GND.t32 a_12790_2770# a_17580_450# GND.t35 sg13_lv_nmos ad=1.824p pd=9.98u as=1.824p ps=9.98u w=9.6u l=1u
X37 GND.t73 a_12790_2770# a_17580_450# GND.t74 sg13_lv_nmos ad=1.824p pd=9.98u as=3.264p ps=19.88u w=9.6u l=1u
X38 a_17580_450# a_12790_2770# GND.t16 GND.t15 sg13_lv_nmos ad=1.824p pd=9.98u as=1.824p ps=9.98u w=9.6u l=1u
X39 GND.t24 a_12790_2770# a_17580_450# GND.t25 sg13_lv_nmos ad=1.824p pd=9.98u as=1.824p ps=9.98u w=9.6u l=1u
X40 a_17580_450# a_12790_2770# GND.t32 GND.t34 sg13_lv_nmos ad=1.824p pd=9.98u as=1.824p ps=9.98u w=9.6u l=1u
X41 a_17580_450# a_12790_2770# GND.t40 GND.t39 sg13_lv_nmos ad=1.824p pd=9.98u as=1.824p ps=9.98u w=9.6u l=1u
X42 GND.t40 a_12790_2770# a_17580_450# GND.t52 sg13_lv_nmos ad=1.824p pd=9.98u as=1.824p ps=9.98u w=9.6u l=1u
X43 GND.t57 a_12790_2770# a_17580_450# GND.t58 sg13_lv_nmos ad=1.824p pd=9.98u as=1.824p ps=9.98u w=9.6u l=1u
X44 VDD OUTp FOUT VDD sg13_lv_pmos ad=0.285p pd=1.88u as=0.51p ps=3.68u w=1.5u l=0.13u
X45 FOUT OUTp VDD VDD sg13_lv_pmos ad=0.285p pd=1.88u as=0.285p ps=1.88u w=1.5u l=0.13u
X46 GND.t16 a_12790_2770# a_17580_450# GND.t19 sg13_lv_nmos ad=1.824p pd=9.98u as=1.824p ps=9.98u w=9.6u l=1u
X47 a_17580_450# OUTp OUTn GND.t6 sg13_lv_nmos ad=1.3927p pd=7.71u as=1.3927p ps=7.71u w=7.33u l=0.13u
X48 GND.t37 a_12790_2770# a_17580_450# GND.t38 sg13_lv_nmos ad=1.824p pd=9.98u as=1.824p ps=9.98u w=9.6u l=1u
X49 a_17580_450# a_12790_2770# GND.t57 GND.t56 sg13_lv_nmos ad=1.824p pd=9.98u as=1.824p ps=9.98u w=9.6u l=1u
X50 a_17580_450# a_12790_2770# GND.t62 GND.t61 sg13_lv_nmos ad=1.824p pd=9.98u as=1.824p ps=9.98u w=9.6u l=1u
X51 FOUT OUTp GND.t9 GND.t8 sg13_lv_nmos ad=0.51p pd=3.68u as=0.51p ps=3.68u w=1.5u l=0.13u
X52 GND.t13 a_12790_2770# a_17580_450# GND.t14 sg13_lv_nmos ad=1.824p pd=9.98u as=1.824p ps=9.98u w=9.6u l=1u
X53 VDD OUTn a_22432_9659# VDD sg13_lv_pmos ad=0.285p pd=1.88u as=0.285p ps=1.88u w=1.5u l=0.13u
X54 GND.t11 a_12790_2770# a_12790_2770# GND.t45 sg13_lv_nmos ad=1.52p pd=8.38u as=1.52p ps=8.38u w=8u l=1u
X55 GND.t49 a_12790_2770# a_12790_2770# GND.t50 sg13_lv_nmos ad=1.52p pd=8.38u as=2.72p ps=16.68u w=8u l=1u
X56 VDD OUTp FOUT VDD sg13_lv_pmos ad=0.285p pd=1.88u as=0.285p ps=1.88u w=1.5u l=0.13u
X57 a_12790_2770# VBGR VDD VDD sg13_lv_pmos ad=1.444p pd=7.98u as=1.444p ps=7.98u w=7.6u l=1u
X58 VDD VBGR a_12790_2770# VDD sg13_lv_pmos ad=1.444p pd=7.98u as=2.584p ps=15.88u w=7.6u l=1u
X59 a_22432_9659# OUTn VDD VDD sg13_lv_pmos ad=0.285p pd=1.88u as=0.285p ps=1.88u w=1.5u l=0.13u
X60 a_22432_9659# OUTn VDD VDD sg13_lv_pmos ad=0.51p pd=3.68u as=0.285p ps=1.88u w=1.5u l=0.13u
X61 VDD OUTp OUTn VDD sg13_lv_pmos ad=1.368p pd=7.58u as=1.368p ps=7.58u w=7.2u l=0.13u
X62 OUTp OUTn a_17580_450# GND.t3 sg13_lv_nmos ad=1.3927p pd=7.71u as=1.3927p ps=7.71u w=7.33u l=0.13u
X63 a_12790_2770# a_12790_2770# GND.t49 GND.t48 sg13_lv_nmos ad=1.52p pd=8.38u as=1.52p ps=8.38u w=8u l=1u
X65 VDD OUTp OUTn VDD sg13_lv_pmos ad=2.448p pd=15.08u as=1.368p ps=7.58u w=7.2u l=0.13u
X66 OUTp OUTn VDD VDD sg13_lv_pmos ad=1.368p pd=7.58u as=1.368p ps=7.58u w=7.2u l=0.13u
X67 FOUT OUTp VDD VDD sg13_lv_pmos ad=0.285p pd=1.88u as=0.285p ps=1.88u w=1.5u l=0.13u
X68 a_17580_450# a_12790_2770# GND.t29 GND.t28 sg13_lv_nmos ad=1.824p pd=9.98u as=1.824p ps=9.98u w=9.6u l=1u
X69 OUTp OUTn VDD VDD sg13_lv_pmos ad=2.448p pd=15.08u as=1.368p ps=7.58u w=7.2u l=0.13u
X70 GND.t65 a_12790_2770# a_17580_450# GND.t66 sg13_lv_nmos ad=1.824p pd=9.98u as=1.824p ps=9.98u w=9.6u l=1u
X71 GND.t70 a_12790_2770# a_17580_450# GND.t71 sg13_lv_nmos ad=1.824p pd=9.98u as=1.824p ps=9.98u w=9.6u l=1u
X72 a_17580_450# a_12790_2770# GND.t16 GND.t18 sg13_lv_nmos ad=1.824p pd=9.98u as=1.824p ps=9.98u w=9.6u l=1u
X73 VDD OUTn a_22432_9659# VDD sg13_lv_pmos ad=0.285p pd=1.88u as=0.51p ps=3.68u w=1.5u l=0.13u
X74 a_22432_9659# OUTn VDD VDD sg13_lv_pmos ad=0.285p pd=1.88u as=0.285p ps=1.88u w=1.5u l=0.13u
X75 GND.t57 a_12790_2770# a_17580_450# GND.t60 sg13_lv_nmos ad=1.824p pd=9.98u as=1.824p ps=9.98u w=9.6u l=1u
X77 FOUT OUTp VDD VDD sg13_lv_pmos ad=0.285p pd=1.88u as=0.285p ps=1.88u w=1.5u l=0.13u
X78 a_17580_450# a_12790_2770# GND.t70 GND.t69 sg13_lv_nmos ad=1.824p pd=9.98u as=1.824p ps=9.98u w=9.6u l=1u
X79 OUTn OUTp GND cap_rfcmim l=21.9u w=21.9u
X80 a_22432_9659# OUTn GND.t1 GND.t0 sg13_lv_nmos ad=0.51p pd=3.68u as=0.51p ps=3.68u w=1.5u l=0.13u
X81 a_17580_450# a_12790_2770# GND.t24 GND.t23 sg13_lv_nmos ad=1.824p pd=9.98u as=1.824p ps=9.98u w=9.6u l=1u
X82 GND.t32 a_12790_2770# a_17580_450# GND.t33 sg13_lv_nmos ad=1.824p pd=9.98u as=1.824p ps=9.98u w=9.6u l=1u
X83 a_17580_450# a_12790_2770# GND.t40 GND.t51 sg13_lv_nmos ad=1.824p pd=9.98u as=1.824p ps=9.98u w=9.6u l=1u
X84 VDD OUTn a_22432_9659# VDD sg13_lv_pmos ad=0.285p pd=1.88u as=0.285p ps=1.88u w=1.5u l=0.13u
X85 GND.t24 a_12790_2770# a_17580_450# GND.t27 sg13_lv_nmos ad=1.824p pd=9.98u as=1.824p ps=9.98u w=9.6u l=1u
X86 a_17580_450# a_12790_2770# GND.t32 GND.t31 sg13_lv_nmos ad=1.824p pd=9.98u as=1.824p ps=9.98u w=9.6u l=1u
X87 a_17580_450# a_12790_2770# GND.t37 GND.t36 sg13_lv_nmos ad=1.824p pd=9.98u as=1.824p ps=9.98u w=9.6u l=1u
X88 VDD OUTp OUTn VDD sg13_lv_pmos ad=1.368p pd=7.58u as=2.448p ps=15.08u w=7.2u l=0.13u
X89 VDD VBGR a_12790_2770# VDD sg13_lv_pmos ad=2.584p pd=15.88u as=1.444p ps=7.98u w=7.6u l=1u
X90 OUTn OUTp a_17580_450# GND.t5 sg13_lv_nmos ad=2.4922p pd=15.34u as=1.3927p ps=7.71u w=7.33u l=0.13u
X91 OUTp OUTn VDD VDD sg13_lv_pmos ad=1.368p pd=7.58u as=2.448p ps=15.08u w=7.2u l=0.13u
X92 a_12790_2770# a_12790_2770# GND.t11 GND.t10 sg13_lv_nmos ad=1.52p pd=8.38u as=1.52p ps=8.38u w=8u l=1u
X93 GND.t11 a_12790_2770# a_12790_2770# GND.t47 sg13_lv_nmos ad=1.52p pd=8.38u as=1.52p ps=8.38u w=8u l=1u
X94 GND.t42 a_12790_2770# a_12790_2770# GND.t44 sg13_lv_nmos ad=1.52p pd=8.38u as=1.52p ps=8.38u w=8u l=1u
X95 a_17580_450# a_12790_2770# GND.t73 GND.t72 sg13_lv_nmos ad=1.824p pd=9.98u as=1.824p ps=9.98u w=9.6u l=1u
C0 OUTp OUTn 12.4747f
C1 a_12790_2770# VBGR 1.57285f
C2 a_12790_2770# a_17580_450# 13.1888f
C3 VDD VBGR 6.06096f
C4 OUTp FOUT 0.88973f
C5 VDD a_17580_450# 0.08971f
C6 a_12790_2770# VDD 2.81334f
C7 OUTn a_17580_450# 2.3591f
C8 OUTn VCTRL 15.2641f
C9 OUTn VDD 8.53754f
C10 OUTp a_17580_450# 1.99763f
C11 OUTp VCTRL 14.279f
C12 a_22432_9659# VDD 1.67429f
C13 OUTn a_22432_9659# 0.88927f
C14 OUTp VDD 8.63667f
C15 FOUT VDD 1.6402f
R0 GND.t50 GND.n315 24512.1
R1 GND.n47 GND.n240 5073.02
R2 GND.n241 GND.n47 5075.27
R3 GND.t45 GND.n38 64.7829
R4 GND.t46 GND.n36 64.7824
R5 GND.n39 GND.t10 60.2183
R6 GND.n40 GND.t50 0.00505593
R7 GND.n46 GND.t44 55.6574
R8 GND.t41 GND.n46 23.0385
R9 GND.n40 GND.t48 22.366
R10 GND.t44 GND.n39 37.395
R11 GND.t47 GND.n36 32.8305
R12 GND.t10 GND.n38 32.8299
R13 GND.n37 GND.t46 28.1827
R14 GND.n65 GND.t45 26.9387
R15 GND.n87 GND.n84 18.9718
R16 GND.n82 GND.n77 18.9718
R17 GND.n79 GND.n78 18.9718
R18 GND.n80 GND.n66 18.9718
R19 GND.n314 GND.n313 18.9718
R20 GND.n244 GND.n243 18.6556
R21 GND.n183 GND.n162 18.6556
R22 GND.n182 GND.n181 18.6556
R23 GND.n179 GND.n178 18.6556
R24 GND.n177 GND.n165 18.6556
R25 GND.n180 GND.t67 18.3395
R26 GND.t19 GND.n81 18.3395
R27 GND.n249 GND.n20 22.4548
R28 GND.n154 GND.n110 17.7071
R29 GND.n151 GND.n111 17.7071
R30 GND.n150 GND.n149 17.7071
R31 GND.n121 GND.n120 17.7071
R32 GND.n119 GND.n118 17.7071
R33 GND.n115 GND.n95 17.7071
R34 GND.t68 GND.n8 23.4971
R35 GND.n28 GND.t59 23.1681
R36 GND.t27 GND.n25 23.4971
R37 GND.n294 GND.n33 17.0005
R38 GND.n24 GND.n0 1.87788
R39 GND.n24 GND.n315 14.8663
R40 GND.n3 GND.n0 1.87788
R41 GND.t15 GND.n3 19.2929
R42 GND.n26 GND.n0 0.102443
R43 GND.n314 GND.n0 8.49654
R44 GND.n66 GND.n0 8.49558
R45 GND.n81 GND.n0 8.48993
R46 GND.n86 GND.n0 8.49763
R47 GND.n85 GND.n0 8.49752
R48 GND.n88 GND.n0 8.49089
R49 GND.n92 GND.n0 8.49233
R50 GND.n7 GND.n0 0.102704
R51 GND.n4 GND.n0 0.102443
R52 GND.t27 GND.n6 10.8499
R53 GND.n25 GND.n0 0.102467
R54 GND.t28 GND.n25 12.1147
R55 GND.n11 GND.n0 0.102443
R56 GND.n17 GND.n0 0.102443
R57 GND.n310 GND.n30 22.4548
R58 GND.n116 GND.n0 8.50029
R59 GND.n124 GND.n0 8.49736
R60 GND.n129 GND.n0 8.49582
R61 GND.n135 GND.n0 8.4963
R62 GND.t36 GND.n29 18.0282
R63 GND.n22 GND.n0 0.102443
R64 GND.n1 GND.n0 0.0818581
R65 GND.n23 GND.n0 0.102443
R66 GND.n27 GND.n0 1.87788
R67 GND.n137 GND.n27 18.0282
R68 GND.n142 GND.n0 8.49428
R69 GND.n144 GND.n0 8.49379
R70 GND.n145 GND.n0 8.49606
R71 GND.n149 GND.n0 8.49185
R72 GND.n151 GND.n0 8.49137
R73 GND.n20 GND.n0 1.87788
R74 GND.t56 GND.n18 20.968
R75 GND.n19 GND.n0 0.102467
R76 GND.t58 GND.n19 22.2327
R77 GND.n168 GND.n0 8.49282
R78 GND.n175 GND.n0 8.49041
R79 GND.n174 GND.n0 8.4995
R80 GND.n178 GND.n0 8.49703
R81 GND.n180 GND.n0 8.49678
R82 GND.n181 GND.n0 8.49558
R83 GND.n183 GND.n0 8.49331
R84 GND.n243 GND.n0 8.49727
R85 GND.n8 GND.n0 0.102467
R86 GND.t69 GND.n8 12.1147
R87 GND.n13 GND.n0 0.102467
R88 GND.t71 GND.n13 13.3794
R89 GND.n9 GND.n0 0.102467
R90 GND.t72 GND.n9 14.6442
R91 GND.n10 GND.n0 0.23487
R92 GND.n242 GND.n0 8.4933
R93 GND.n235 GND.n0 17.0005
R94 GND.n177 GND.n0 8.49479
R95 GND.n173 GND.n0 8.49582
R96 GND.n171 GND.n0 8.4904
R97 GND.n170 GND.n0 8.49088
R98 GND.n155 GND.n0 8.49454
R99 GND.n248 GND.n0 8.49404
R100 GND.n154 GND.n0 8.49184
R101 GND.n152 GND.n0 8.49065
R102 GND.n148 GND.n0 8.49257
R103 GND.n146 GND.n0 8.49281
R104 GND.n141 GND.n0 8.49788
R105 GND.n139 GND.n0 8.49161
R106 GND.n138 GND.n0 8.4943
R107 GND.n133 GND.n0 8.49405
R108 GND.n131 GND.n0 8.48992
R109 GND.n127 GND.n0 8.49113
R110 GND.n125 GND.n0 8.49306
R111 GND.n122 GND.n0 8.49209
R112 GND.n120 GND.n0 8.49503
R113 GND.n118 GND.n0 8.49453
R114 GND.n95 GND.n0 8.49136
R115 GND.n94 GND.n0 8.49017
R116 GND.n91 GND.n0 8.49975
R117 GND.n89 GND.n0 8.49355
R118 GND.n84 GND.n0 8.49379
R119 GND.n82 GND.n0 8.49397
R120 GND.n217 GND.n0 17.0005
R121 GND.n79 GND.n0 8.49233
R122 GND.n239 GND.n0 8.49428
R123 GND.n312 GND.n70 17.0005
R124 GND.n312 GND.n69 17.0005
R125 GND.n266 GND.n250 17.0005
R126 GND.n245 GND.n159 17.0005
R127 GND.n245 GND.n158 17.0005
R128 GND.t50 GND.n59 17.0005
R129 GND.t69 GND.n13 22.2323
R130 GND.t28 GND.n11 22.2323
R131 GND.t4 GND.n112 15.4938
R132 GND.n123 GND.t5 15.4938
R133 GND.n247 GND.n37 14.8972
R134 GND.t8 GND.n174 14.8614
R135 GND.n86 GND.t0 14.8614
R136 GND.t71 GND.n9 20.9675
R137 GND.n247 GND.n28 20.0056
R138 GND.t72 GND.n242 13.2804
R139 GND.n147 GND.n144 13.2804
R140 GND.n142 GND.n113 13.2804
R141 GND.n143 GND.n141 13.2804
R142 GND.n140 GND.n138 13.2804
R143 GND.n27 GND.t43 18.0287
R144 GND.n29 GND.n136 18.0287
R145 GND.n135 GND.n134 13.2804
R146 GND.n131 GND.n130 13.2804
R147 GND.n129 GND.n128 13.2804
R148 GND.n127 GND.n126 13.2804
R149 GND.t31 GND.n30 18.0287
R150 GND.n239 GND.t14 13.2804
R151 GND.t17 GND.n26 12.1152
R152 GND.t23 GND.n4 27.2923
R153 GND.n23 GND.t39 20.9685
R154 GND.t61 GND.n21 8.32094
R155 GND.t63 GND.n12 7.05618
R156 GND.t30 GND.n17 20.9685
R157 GND.t25 GND.n2 26.0275
R158 GND.n7 GND.t23 7.05482
R159 GND.n247 GND.n65 12.7962
R160 GND.n311 GND.n94 11.3833
R161 GND.n92 GND.n74 11.3833
R162 GND.n93 GND.n91 11.3833
R163 GND.n89 GND.n75 11.3833
R164 GND.n90 GND.n88 11.3833
R165 GND.n85 GND.n76 11.3833
R166 GND.n315 GND.n3 16.1316
R167 GND.n176 GND.n175 11.0671
R168 GND.n173 GND.n166 11.0671
R169 GND.n172 GND.n171 11.0671
R170 GND.n170 GND.n167 11.0671
R171 GND.n169 GND.n168 11.0671
R172 GND.n246 GND.n155 11.0671
R173 GND.t52 GND.n145 10.7509
R174 GND.t34 GND.n124 10.7509
R175 GND.n171 GND.n166 10.4347
R176 GND.n172 GND.n170 10.4347
R177 GND.n168 GND.n167 10.4347
R178 GND.n311 GND.n7 16.5416
R179 GND.n93 GND.n92 10.1185
R180 GND.n91 GND.n75 10.1185
R181 GND.n90 GND.n89 10.1185
R182 GND.n169 GND.t64 9.80235
R183 GND.n10 GND.t74 8.35953
R184 GND.t53 GND.n152 9.48617
R185 GND.n139 GND.t51 9.48617
R186 GND.n133 GND.t35 9.48617
R187 GND.t33 GND.n116 9.48617
R188 GND.t22 GND.n74 9.48617
R189 GND.n15 GND.t12 8.35961
R190 GND.n176 GND.t66 8.5376
R191 GND.n146 GND.t3 8.5376
R192 GND.n125 GND.t6 8.5376
R193 GND.n310 GND.n33 0.58525
R194 GND.n312 GND.n74 8.5005
R195 GND.n312 GND.n93 8.5005
R196 GND.n312 GND.n75 8.5005
R197 GND.n312 GND.n90 8.5005
R198 GND.n312 GND.n76 8.5005
R199 GND.n312 GND.n87 8.5005
R200 GND.n312 GND.n77 8.5005
R201 GND.n312 GND.n83 8.5005
R202 GND.n312 GND.n78 8.5005
R203 GND.n312 GND.n80 8.5005
R204 GND.n134 GND.n33 8.5005
R205 GND.n132 GND.n33 8.5005
R206 GND.n130 GND.n33 8.5005
R207 GND.n128 GND.n33 8.5005
R208 GND.n126 GND.n33 8.5005
R209 GND.n123 GND.n33 8.5005
R210 GND.n121 GND.n33 8.5005
R211 GND.n119 GND.n33 8.5005
R212 GND.n117 GND.n33 8.5005
R213 GND.n115 GND.n33 8.5005
R214 GND.n250 GND.n110 8.5005
R215 GND.n250 GND.n153 8.5005
R216 GND.n250 GND.n111 8.5005
R217 GND.n250 GND.n150 8.5005
R218 GND.n250 GND.n112 8.5005
R219 GND.n250 GND.n147 8.5005
R220 GND.n250 GND.n113 8.5005
R221 GND.n250 GND.n143 8.5005
R222 GND.n250 GND.n114 8.5005
R223 GND.n250 GND.n140 8.5005
R224 GND.n245 GND.n162 8.5005
R225 GND.n245 GND.n182 8.5005
R226 GND.n245 GND.n164 8.5005
R227 GND.n245 GND.n179 8.5005
R228 GND.n245 GND.n165 8.5005
R229 GND.n245 GND.n176 8.5005
R230 GND.n245 GND.n166 8.5005
R231 GND.n245 GND.n172 8.5005
R232 GND.n245 GND.n167 8.5005
R233 GND.n245 GND.n169 8.5005
R234 GND.n308 GND.n33 8.46995
R235 GND.n306 GND.n33 8.46995
R236 GND.n304 GND.n33 8.46995
R237 GND.n302 GND.n33 8.46995
R238 GND.n300 GND.n33 8.46995
R239 GND.n298 GND.n33 8.46995
R240 GND.n296 GND.n33 8.46995
R241 GND.n292 GND.n33 8.46995
R242 GND.n290 GND.n33 8.46995
R243 GND.n288 GND.n33 8.46995
R244 GND.n286 GND.n33 8.46995
R245 GND.n284 GND.n33 8.46995
R246 GND.n31 GND.n0 0.00474936
R247 GND.t13 GND.n31 0.330164
R248 GND.n312 GND.n73 8.46995
R249 GND.n312 GND.n71 8.46995
R250 GND.n312 GND.n68 8.46995
R251 GND.n312 GND.n67 8.46995
R252 GND.n268 GND.n250 8.46995
R253 GND.n270 GND.n250 8.46995
R254 GND.n272 GND.n250 8.46995
R255 GND.n274 GND.n250 8.46995
R256 GND.n276 GND.n250 8.46995
R257 GND.n278 GND.n250 8.46995
R258 GND.n245 GND.n161 8.46995
R259 GND.n245 GND.n160 8.46995
R260 GND.n245 GND.n157 8.46995
R261 GND.n245 GND.n156 8.46995
R262 GND.t50 GND.n60 8.46995
R263 GND.t50 GND.n61 8.46995
R264 GND.t50 GND.n62 8.46995
R265 GND.t50 GND.n63 8.46995
R266 GND.t50 GND.n64 8.46995
R267 GND.n237 GND.n0 8.46995
R268 GND.n233 GND.n0 8.46995
R269 GND.n231 GND.n0 8.46995
R270 GND.n229 GND.n0 8.46995
R271 GND.n223 GND.n0 8.46995
R272 GND.n221 GND.n0 8.46995
R273 GND.n219 GND.n0 8.46995
R274 GND.n215 GND.n0 8.46995
R275 GND.n254 GND.n250 8.46995
R276 GND.n256 GND.n250 8.46995
R277 GND.n258 GND.n250 8.46995
R278 GND.n260 GND.n250 8.46995
R279 GND.n262 GND.n250 8.46995
R280 GND.n264 GND.n250 8.46995
R281 GND.n332 GND.t50 8.46995
R282 GND.n330 GND.t50 8.46995
R283 GND.n328 GND.t50 8.46995
R284 GND.n326 GND.t50 8.46995
R285 GND.n324 GND.t50 8.46995
R286 GND.n322 GND.t50 8.46995
R287 GND.n207 GND.t1 8.44975
R288 GND.t1 GND.n206 8.44975
R289 GND.n193 GND.t9 8.44975
R290 GND.t9 GND.n192 8.44975
R291 GND.t55 GND.n18 14.6438
R292 GND.n153 GND.t53 8.22141
R293 GND.n147 GND.n146 8.22141
R294 GND.n143 GND.n142 8.22141
R295 GND.n141 GND.n114 8.22141
R296 GND.n140 GND.n139 8.22141
R297 GND.n138 GND.n137 8.22141
R298 GND.n22 GND.t36 14.6438
R299 GND.n136 GND.n135 8.22141
R300 GND.n134 GND.n133 8.22141
R301 GND.n132 GND.n131 8.22141
R302 GND.n130 GND.n129 8.22141
R303 GND.n126 GND.n125 8.22141
R304 GND.n117 GND.t33 8.22141
R305 GND.t20 GND.n76 8.22141
R306 GND.t14 GND.n24 12.9697
R307 GND.n248 GND.n247 7.58903
R308 GND.t56 GND.n19 13.379
R309 GND.n1 GND.t38 13.4202
R310 GND.t15 GND.n14 13.3786
R311 GND.n175 GND.t8 6.64047
R312 GND.t0 GND.n85 6.64047
R313 GND.n240 GND.n15 22.4159
R314 GND.t26 GND.n6 24.7618
R315 GND.n241 GND.n10 22.1005
R316 GND.n12 GND.n246 16.8571
R317 GND.n21 GND.t63 27.2913
R318 GND.n5 GND.t61 26.0273
R319 GND.n16 GND.t60 24.7625
R320 GND.n20 GND.t55 18.0287
R321 GND.t43 GND.n23 14.6438
R322 GND.t39 GND.n1 13.4211
R323 GND.t38 GND.n22 20.9685
R324 GND.n17 GND.t31 14.6438
R325 GND.n11 GND.t30 13.38
R326 GND.n2 GND.t26 9.58475
R327 GND.n4 GND.t25 8.31999
R328 GND.n26 GND.t18 23.4971
R329 GND.n14 GND.t17 22.233
R330 GND.t2 GND.n113 6.00809
R331 GND.n128 GND.t7 6.00809
R332 GND.n242 GND.n241 5.6919
R333 GND.t58 GND.n248 5.6919
R334 GND.n282 GND.n33 5.61281
R335 GND.n252 GND.n250 5.61281
R336 GND.n334 GND.t50 5.61281
R337 GND.t50 GND.n45 5.61281
R338 GND.n240 GND.n239 5.37571
R339 GND.n14 GND.n0 0.102704
R340 GND.n28 GND.n0 0.436999
R341 GND.n16 GND.n0 0.102704
R342 GND.n5 GND.n0 0.102704
R343 GND.n12 GND.n0 0.102443
R344 GND.n21 GND.n0 0.102443
R345 GND.n18 GND.n0 0.102467
R346 GND.n29 GND.n0 1.87788
R347 GND.n30 GND.n0 1.87788
R348 GND.n6 GND.n0 0.102467
R349 GND.n2 GND.n0 0.102443
R350 GND.n15 GND.n0 0.234753
R351 GND.n228 GND.n227 5.01375
R352 GND.n238 GND.n185 5.01375
R353 GND.n236 GND.n187 5.01375
R354 GND.n234 GND.n188 5.01375
R355 GND.n232 GND.n35 5.01375
R356 GND.n230 GND.n195 5.01375
R357 GND.n226 GND.n44 5.02357
R358 GND.n43 GND.n198 5.02355
R359 GND.n214 GND.n213 5.01375
R360 GND.n216 GND.n211 5.01375
R361 GND.n218 GND.n209 5.01375
R362 GND.n220 GND.n49 5.01375
R363 GND.n222 GND.n48 5.01375
R364 GND.n224 GND.n200 5.01375
R365 GND.n243 GND.t68 4.42714
R366 GND.t59 GND.n16 10.8491
R367 GND.t18 GND.n314 4.42714
R368 GND.n249 GND.n154 3.79477
R369 GND.n152 GND.n110 3.79477
R370 GND.n153 GND.n151 3.79477
R371 GND.n149 GND.n111 3.79477
R372 GND.n150 GND.n148 3.79477
R373 GND.n145 GND.n112 3.79477
R374 GND.t51 GND.n114 3.79477
R375 GND.t35 GND.n132 3.79477
R376 GND.n124 GND.n123 3.79477
R377 GND.n122 GND.n121 3.79477
R378 GND.n120 GND.n119 3.79477
R379 GND.n118 GND.n117 3.79477
R380 GND.n116 GND.n115 3.79477
R381 GND.n310 GND.n95 3.79477
R382 GND.t60 GND.n5 9.58433
R383 GND.n244 GND.n183 2.8462
R384 GND.n181 GND.n162 2.8462
R385 GND.n182 GND.n180 2.8462
R386 GND.n178 GND.n164 2.8462
R387 GND.n179 GND.n177 2.8462
R388 GND.n174 GND.n165 2.8462
R389 GND.n87 GND.n86 2.53001
R390 GND.n84 GND.n77 2.53001
R391 GND.n83 GND.n82 2.53001
R392 GND.n81 GND.n78 2.53001
R393 GND.n80 GND.n79 2.53001
R394 GND.n313 GND.n66 2.53001
R395 GND.t73 GND.n32 1.46393
R396 GND.n148 GND.t4 2.21382
R397 GND.t3 GND.t52 2.21382
R398 GND.n144 GND.t2 2.21382
R399 GND.t7 GND.n127 2.21382
R400 GND.t6 GND.t34 2.21382
R401 GND.t5 GND.n122 2.21382
R402 GND.n335 GND.n317 2.01342
R403 GND.n338 GND.n316 2.01342
R404 GND.n337 GND.t50 1.9709
R405 GND.n338 GND.n58 1.96675
R406 GND.n339 GND.n57 1.96675
R407 GND.n340 GND.n56 1.96675
R408 GND.n341 GND.n55 1.96675
R409 GND.n342 GND.n54 1.96675
R410 GND.n343 GND.n53 1.96675
R411 GND.n323 GND.n52 1.96675
R412 GND.n325 GND.n321 1.96675
R413 GND.n327 GND.n320 1.96675
R414 GND.n329 GND.n319 1.96675
R415 GND.n331 GND.n318 1.96675
R416 GND.n333 GND.n317 1.96675
R417 GND.n42 GND.n51 1.96675
R418 GND.t66 GND.n173 1.89763
R419 GND.n88 GND.t20 1.89763
R420 GND.n313 GND.n312 1.89014
R421 GND.n246 GND.n245 1.89014
R422 GND.n312 GND.n311 1.88939
R423 GND.n245 GND.n244 1.88939
R424 GND.n336 GND.n335 1.47166
R425 GND.n251 GND.n109 1.45447
R426 GND.t42 GND.n336 1.44175
R427 GND.n44 GND.n0 1.2903
R428 GND.n0 GND.n43 1.28875
R429 GND.t50 GND.n65 1.40261
R430 GND.n279 GND.n109 1.35463
R431 GND.n281 GND.n34 1.4561
R432 GND.n197 GND.n72 1.21291
R433 GND.n225 GND.n163 1.21189
R434 GND.n184 GND.n163 1.21107
R435 GND.n212 GND.n72 1.21005
R436 GND.t54 GND.t57 1.17427
R437 GND.t24 GND.t29 1.17406
R438 GND.t13 GND.t16 1.17332
R439 GND.t37 GND.t40 1.14041
R440 GND.t32 GND.t37 1.14021
R441 GND.t29 GND.t32 1.1376
R442 GND.t40 GND.t54 1.13739
R443 GND.t49 GND.n316 1.1235
R444 GND.t21 GND.t24 1.11803
R445 GND.t65 GND.t62 1.11779
R446 GND.t57 GND.t62 1.11778
R447 GND.t21 GND.t16 1.11778
R448 GND.t49 GND.t11 1.08637
R449 GND.n34 GND.n33 0.0402858
R450 GND.n281 GND.n280 1.02442
R451 GND.n280 GND.n279 1.02442
R452 GND.n307 GND.n97 1.02075
R453 GND.n305 GND.n98 1.02075
R454 GND.n303 GND.n99 1.02075
R455 GND.n301 GND.n100 1.02075
R456 GND.n299 GND.n101 1.02075
R457 GND.n297 GND.n102 1.02075
R458 GND.n295 GND.n41 1.02075
R459 GND.n293 GND.n103 1.02075
R460 GND.n291 GND.n104 1.02075
R461 GND.n289 GND.n105 1.02075
R462 GND.n287 GND.n106 1.02075
R463 GND.n285 GND.n107 1.02075
R464 GND.n283 GND.n108 1.02075
R465 GND.n277 GND.n108 1.02075
R466 GND.n275 GND.n107 1.02075
R467 GND.n273 GND.n106 1.02075
R468 GND.n271 GND.n105 1.02075
R469 GND.n269 GND.n104 1.02075
R470 GND.n267 GND.n103 1.02075
R471 GND.n265 GND.n41 1.02075
R472 GND.n263 GND.n102 1.02075
R473 GND.n261 GND.n101 1.02075
R474 GND.n259 GND.n100 1.02075
R475 GND.n257 GND.n99 1.02075
R476 GND.n255 GND.n98 1.02075
R477 GND.n253 GND.n97 1.02075
R478 GND.n251 GND.n96 1.02075
R479 GND.n309 GND.n96 1.02075
R480 GND.t65 GND.t70 0.913076
R481 GND.t70 GND.t73 0.862159
R482 GND.t70 GND.n0 0.791865
R483 GND.n208 GND.n207 0.681003
R484 GND.n206 GND.n205 0.681003
R485 GND.n194 GND.n193 0.681003
R486 GND.n192 GND.n191 0.681003
R487 GND.t64 GND.n155 0.632878
R488 GND.n94 GND.t22 0.632878
R489 GND.n83 GND.t19 0.632878
R490 GND.n250 GND.n137 0.587457
R491 GND.n136 GND.n33 0.586707
R492 GND.n250 GND.n249 0.586707
R493 GND.n204 GND.n203 0.578
R494 GND.n190 GND.n189 0.578
R495 GND.t11 GND.n337 0.481092
R496 GND.n226 GND.n225 0.46525
R497 GND.n227 GND.n196 0.46525
R498 GND.n213 GND.n212 0.46525
R499 GND.n211 GND.n210 0.46525
R500 GND.n209 GND.n208 0.46525
R501 GND.n203 GND.n49 0.46525
R502 GND.n205 GND.n48 0.46525
R503 GND.n200 GND.n199 0.46525
R504 GND.n198 GND.n197 0.46525
R505 GND.n195 GND.n194 0.46525
R506 GND.n191 GND.n188 0.46525
R507 GND.n187 GND.n186 0.46525
R508 GND.n185 GND.n184 0.46525
R509 GND.n189 GND.n35 0.46525
R510 GND.n201 GND.n35 1.1279
R511 GND.n49 GND.n202 1.2821
R512 GND.n337 GND.t42 0.443214
R513 GND.n238 GND.n32 1.44045
R514 GND.t49 GND.t50 0.387537
R515 GND.t54 GND.n0 0.379676
R516 GND.t29 GND.n0 0.379676
R517 GND.t37 GND.n0 0.374603
R518 GND.t21 GND.n0 0.347662
R519 GND.t62 GND.n0 0.347607
R520 GND.t67 GND.n164 0.316689
R521 GND.n344 GND.n50 0.313271
R522 GND.n34 GND.n309 1.33348
R523 GND.n214 GND.n31 1.47682
R524 GND.n312 GND.n72 0.264828
R525 GND.n245 GND.n163 0.264828
R526 GND.n50 GND.n47 2.31205
R527 GND.n309 GND.n308 0.187772
R528 GND.n279 GND.n278 0.187772
R529 GND.n284 GND.n283 0.184106
R530 GND.n64 GND.n58 0.184106
R531 GND.n277 GND.n276 0.184106
R532 GND.n333 GND.n332 0.184106
R533 GND.n307 GND.n306 0.180439
R534 GND.n254 GND.n253 0.180439
R535 GND.n202 GND.n41 0.485987
R536 GND.n344 GND.n42 0.493958
R537 GND.n286 GND.n285 0.176772
R538 GND.n63 GND.n57 0.176772
R539 GND.n331 GND.n330 0.176772
R540 GND.n275 GND.n274 0.176772
R541 GND.n305 GND.n304 0.173106
R542 GND.n256 GND.n255 0.173106
R543 GND.n295 GND.n294 0.172833
R544 GND.n59 GND.n51 0.172833
R545 GND.n266 GND.n265 0.172833
R546 GND.n207 GND.n204 0.172253
R547 GND.n206 GND.n204 0.172253
R548 GND.n193 GND.n190 0.172253
R549 GND.n192 GND.n190 0.172253
R550 GND.n288 GND.n287 0.169439
R551 GND.n62 GND.n56 0.169439
R552 GND.n273 GND.n272 0.169439
R553 GND.n329 GND.n328 0.169439
R554 GND.n303 GND.n302 0.165772
R555 GND.n258 GND.n257 0.165772
R556 GND.n290 GND.n289 0.162106
R557 GND.n61 GND.n55 0.162106
R558 GND.n271 GND.n270 0.162106
R559 GND.n327 GND.n326 0.162106
R560 GND.n301 GND.n300 0.158439
R561 GND.n260 GND.n259 0.158439
R562 GND.n292 GND.n291 0.154772
R563 GND.n60 GND.n54 0.154772
R564 GND.n325 GND.n324 0.154772
R565 GND.n269 GND.n268 0.154772
R566 GND.n202 GND.n201 0.154743
R567 GND.n210 GND.n71 0.152939
R568 GND.n299 GND.n298 0.151106
R569 GND.n186 GND.n157 0.151106
R570 GND.n196 GND.n160 0.151106
R571 GND.n262 GND.n261 0.151106
R572 GND.n233 GND.n232 0.149272
R573 GND.n220 GND.n219 0.149272
R574 GND.n199 GND.n68 0.149272
R575 GND.n323 GND.n322 0.147439
R576 GND.n297 GND.n296 0.143772
R577 GND.n264 GND.n263 0.143772
R578 GND.n238 GND.n237 0.138272
R579 GND.n215 GND.n214 0.138272
R580 GND.n253 GND.n252 0.132419
R581 GND.n230 GND.n229 0.130939
R582 GND.n223 GND.n222 0.130939
R583 GND.n335 GND.n334 0.129092
R584 GND.n45 GND.n58 0.129092
R585 GND.n283 GND.n282 0.128752
R586 GND.n316 GND.n45 0.128752
R587 GND.n334 GND.n333 0.128752
R588 GND.n282 GND.n281 0.125425
R589 GND.n252 GND.n251 0.125425
R590 GND.n212 GND.n73 0.123606
R591 GND.n184 GND.n156 0.121772
R592 GND.n225 GND.n161 0.121772
R593 GND.n197 GND.n67 0.119939
R594 GND.n231 GND.n230 0.119939
R595 GND.n222 GND.n221 0.119939
R596 GND.n208 GND.n70 0.119667
R597 GND.n191 GND.n158 0.117833
R598 GND.n194 GND.n159 0.117833
R599 GND.n235 GND.n234 0.116
R600 GND.n218 GND.n217 0.116
R601 GND.n205 GND.n69 0.116
R602 GND.n296 GND.n295 0.114439
R603 GND.n265 GND.n264 0.114439
R604 GND.n322 GND.n51 0.110772
R605 GND.n298 GND.n297 0.107106
R606 GND.n263 GND.n262 0.107106
R607 GND.n236 GND.n235 0.105
R608 GND.n217 GND.n216 0.105
R609 GND.n203 GND.n69 0.105
R610 GND.n293 GND.n292 0.103439
R611 GND.n60 GND.n53 0.103439
R612 GND.n268 GND.n267 0.103439
R613 GND.n324 GND.n323 0.103439
R614 GND.n189 GND.n158 0.103167
R615 GND.n189 GND.n159 0.103167
R616 GND.n199 GND.n67 0.101606
R617 GND.n232 GND.n231 0.101606
R618 GND.n221 GND.n220 0.101606
R619 GND.n203 GND.n70 0.101333
R620 GND.n300 GND.n299 0.0997723
R621 GND.n186 GND.n156 0.0997723
R622 GND.n196 GND.n161 0.0997723
R623 GND.n261 GND.n260 0.0997723
R624 GND.n210 GND.n73 0.0979389
R625 GND.n228 GND.n44 0.21087
R626 GND.n43 GND.n224 0.210881
R627 GND.n291 GND.n290 0.0961056
R628 GND.n61 GND.n54 0.0961056
R629 GND.n270 GND.n269 0.0961056
R630 GND.n326 GND.n325 0.0961056
R631 GND.n302 GND.n301 0.092439
R632 GND.n259 GND.n258 0.0924389
R633 GND.t50 GND.n37 0.0916021
R634 GND.n229 GND.n228 0.0906056
R635 GND.n224 GND.n223 0.0906056
R636 GND.n289 GND.n288 0.0887723
R637 GND.n62 GND.n55 0.0887723
R638 GND.n272 GND.n271 0.0887723
R639 GND.n328 GND.n327 0.0887723
R640 GND.n304 GND.n303 0.0851056
R641 GND.n257 GND.n256 0.0851056
R642 GND.n294 GND.n293 0.0848333
R643 GND.n59 GND.n53 0.0848333
R644 GND.n267 GND.n266 0.0848333
R645 GND.n237 GND.n236 0.0832723
R646 GND.n216 GND.n215 0.0832723
R647 GND.n287 GND.n286 0.081439
R648 GND.n63 GND.n56 0.081439
R649 GND.n274 GND.n273 0.081439
R650 GND.n330 GND.n329 0.0814389
R651 GND.n306 GND.n305 0.0777723
R652 GND.n255 GND.n254 0.0777723
R653 GND.n32 GND.n0 0.0115551
R654 GND.n285 GND.n284 0.0741056
R655 GND.n64 GND.n57 0.0741056
R656 GND.n276 GND.n275 0.0741056
R657 GND.n332 GND.n331 0.0741056
R658 GND.n205 GND.n68 0.0722723
R659 GND.n234 GND.n233 0.0722723
R660 GND.n219 GND.n218 0.0722723
R661 GND.n308 GND.n307 0.070439
R662 GND.n191 GND.n157 0.070439
R663 GND.n194 GND.n160 0.070439
R664 GND.n208 GND.n71 0.0686056
R665 GND.n278 GND.n277 0.0667723
R666 GND GND.n344 0.0557
R667 GND.n280 GND.n108 0.0471667
R668 GND.n108 GND.n107 0.0471667
R669 GND.n107 GND.n106 0.0471667
R670 GND.n106 GND.n105 0.0471667
R671 GND.n105 GND.n104 0.0471667
R672 GND.n104 GND.n103 0.0471667
R673 GND.n103 GND.n41 0.0471667
R674 GND.n41 GND.n102 0.0471667
R675 GND.n102 GND.n101 0.0471667
R676 GND.n101 GND.n100 0.0471667
R677 GND.n100 GND.n99 0.0471667
R678 GND.n99 GND.n98 0.0471667
R679 GND.n98 GND.n97 0.0471667
R680 GND.n97 GND.n96 0.0471667
R681 GND.n339 GND.n338 0.0471667
R682 GND.n340 GND.n339 0.0471667
R683 GND.n341 GND.n340 0.0471667
R684 GND.n342 GND.n341 0.0471667
R685 GND.n343 GND.n342 0.0471667
R686 GND.n42 GND.n343 0.0471667
R687 GND.n42 GND.n52 0.0471667
R688 GND.n321 GND.n52 0.0471667
R689 GND.n321 GND.n320 0.0471667
R690 GND.n320 GND.n319 0.0471667
R691 GND.n319 GND.n318 0.0471667
R692 GND.n318 GND.n317 0.0471667
R693 GND.n250 GND.n109 0.0419174
R694 GND.n187 GND.n185 0.0405
R695 GND.n188 GND.n187 0.0405
R696 GND.n35 GND.n188 0.0405
R697 GND.n195 GND.n35 0.0405
R698 GND.n227 GND.n195 0.0405
R699 GND.n227 GND.n226 0.0405
R700 GND.n200 GND.n198 0.0405
R701 GND.n48 GND.n200 0.0405
R702 GND.n209 GND.n49 0.0405
R703 GND.n211 GND.n209 0.0405
R704 GND.n213 GND.n211 0.0405
R705 GND.n49 GND.n48 0.0405
R706 GND.n201 GND.n50 0.0176
R707 GND.t50 GND.n46 0.00960807
R708 GND.n336 GND.t50 0.00903968
R709 GND.t50 GND.n38 0.00754998
R710 GND.t50 GND.n36 0.00731111
R711 GND.t50 GND.n39 0.00729889
R712 GND.n40 GND.t47 60.2209
C16 FOUT GND 1.93463f
C17 OUTp GND 35.1691f
C18 OUTn GND 27.9452f
C19 VBGR GND 3.62291f
C20 VCTRL GND 3.45818f
C21 VDD GND 14.7558f
C22 a_22432_9659# GND 1.05229f ; **FLOATING
C23 a_12790_2770# GND 81.5905f ; **FLOATING
C24 a_17580_450# GND 15.9614f ; **FLOATING
Xvar1 OUTp VCTRL OUTn GND sg13_hv_svaricap w=9.7814u l=0.8u Nx=7
Xvar2 OUTp VCTRL OUTn GND sg13_hv_svaricap w=9.7814u l=0.8u Nx=7
.ends
