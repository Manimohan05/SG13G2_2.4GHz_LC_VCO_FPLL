* NGSPICE file created from DSM_N_FREQ_DIV.ext - technology: ihp-sg13g2

.subckt DSM_N_FREQ_DIV_PEX freq_in rst sclk sdata en freq_out VDD GND
X0 a_12886_13350# _128_.B1 GND.t108 GND.t1500 sg13_lv_nmos ad=0.1406p pd=1.12u as=0.1406p ps=1.12u w=0.74u l=0.15u
X1 VDD GND.t441 VDD VDD sg13_lv_pmos ad=0.19p pd=1.38u as=1.19017n ps=5.16309m w=1u l=1u
X2 a_14651_10996# _131_.B1 _131_.Y VDD sg13_lv_pmos ad=0.2128p pd=1.5u as=0.3808p ps=2.92u w=1.12u l=0.13u
X3 GND.t703 VDD GND.t703 GND.t704 sg13_lv_nmos ad=79.8f pd=0.8u as=0 ps=0 w=0.42u l=1u
X4 a_12549_12189# _263_.CLK VDD VDD sg13_lv_pmos ad=0.4088p pd=2.97u as=1.36162p ps=8.745u w=1.12u l=0.13u
X5 VDD GND.t644 VDD VDD sg13_lv_pmos ad=0.34p pd=2.68u as=0 ps=0 w=1u l=1u
X6 GND.t5 VDD GND.t1149 GND.t83 sg13_lv_nmos ad=0.1428p pd=1.52u as=0 ps=0 w=0.42u l=1u
X7 VDD a_10672_13942# a_10617_14037# VDD sg13_lv_pmos ad=5.15485p pd=34.14u as=93.45f ps=0.865u w=0.42u l=0.13u
X8 VDD GND.t508 VDD VDD sg13_lv_pmos ad=0.19p pd=1.38u as=0 ps=0 w=1u l=1u
X9 a_13505_8784# _145_.X _158_.Y GND.t331 sg13_lv_nmos ad=0.1406p pd=1.12u as=0.1406p ps=1.12u w=0.74u l=0.13u
X10 VDD a_2126_13912# _119_.X VDD sg13_lv_pmos ad=0.2198p pd=1.52u as=0.6048p ps=3.32u w=1.12u l=0.13u
X11 VDD GND.t136 VDD VDD sg13_lv_pmos ad=0.34p pd=2.68u as=0 ps=0 w=1u l=1u
X12 VDD GND.t890 VDD VDD sg13_lv_pmos ad=0.34p pd=2.68u as=0 ps=0 w=1u l=1u
X13 a_6825_5041# a_6468_4968# VDD VDD sg13_lv_pmos ad=63f pd=0.72u as=0.1563p ps=1.22u w=0.42u l=0.13u
X14 a_3717_5423# _243_.CLK GND.t5 GND.t230 sg13_lv_nmos ad=0.2516p pd=2.16u as=7.07497p ps=46.475u w=0.74u l=0.13u
X15 a_8964_12210# _182_.Y a_8870_12210# GND.t1522 sg13_lv_nmos ad=60.89999f pd=0.71u as=0.1428p ps=1.52u w=0.42u l=0.13u
X16 GND.t806 VDD GND.t806 GND.t807 sg13_lv_nmos ad=79.8f pd=0.8u as=0 ps=0 w=0.42u l=1u
X17 VDD _133_.Y _134_.Y VDD sg13_lv_pmos ad=0.3808p pd=2.92u as=0.2128p ps=1.5u w=1.12u l=0.15u
X18 GND.t1200 VDD GND.t1199 GND.t1198 sg13_lv_nmos ad=0.1428p pd=1.52u as=0 ps=0 w=0.42u l=1u
X19 VDD GND.t345 VDD VDD sg13_lv_pmos ad=0.34p pd=2.68u as=0 ps=0 w=1u l=1u
X20 VDD GND.t1000 VDD VDD sg13_lv_pmos ad=0.19p pd=1.38u as=0 ps=0 w=1u l=1u
X21 clkbuf_1_0__f_sclk.A a_3886_10702# VDD VDD sg13_lv_pmos ad=0.2128p pd=1.5u as=0.2128p ps=1.5u w=1.12u l=0.13u
X22 VDD _259_.RESET_B a_8266_16969# VDD sg13_lv_pmos ad=0.1563p pd=1.22u as=0.147p ps=1.54u w=0.42u l=0.13u
X23 a_4761_4965# a_3819_4772# a_4559_4727# VDD sg13_lv_pmos ad=93.45f pd=0.865u as=0.2048p ps=1.63u w=0.42u l=0.13u
X24 a_11698_17946# _240_.Y GND.t121 GND.t158 sg13_lv_nmos ad=37.8f pd=0.6u as=79.8f ps=0.8u w=0.42u l=0.13u
X25 a_10715_7720# _166_.A GND.t348 GND.t637 sg13_lv_nmos ad=78.39999f pd=0.885u as=0.2272p ps=1.99u w=0.64u l=0.13u
X26 a_3695_8797# a_2853_8447# a_2436_8440# VDD sg13_lv_pmos ad=0.2048p pd=1.63u as=0.34p ps=2.68u w=1u l=0.13u
X27 clkbuf_1_0__f_sclk.A a_3886_10702# GND.t1027 GND.t1449 sg13_lv_nmos ad=0.1406p pd=1.12u as=0.1406p ps=1.12u w=0.74u l=0.13u
X28 GND.t77 VDD GND.t77 GND.t1011 sg13_lv_nmos ad=0.1428p pd=1.52u as=0 ps=0 w=0.42u l=1u
X29 GND.t104 _131_.A2 a_13978_13342# GND.t103 sg13_lv_nmos ad=0.2516p pd=2.16u as=0.1406p ps=1.12u w=0.74u l=0.13u
X30 _170_.B _166_.A a_9466_7678# GND.t636 sg13_lv_nmos ad=0.2516p pd=2.16u as=0.1406p ps=1.12u w=0.74u l=0.13u
X31 a_14451_13320# _126_.B1 GND.t441 GND.t440 sg13_lv_nmos ad=0.1406p pd=1.12u as=0.2516p ps=2.16u w=0.74u l=0.13u
X32 a_2558_7972# _122_.A0 a_2126_7864# VDD sg13_lv_pmos ad=0.3325p pd=1.665u as=0.2225p ps=1.445u w=1u l=0.13u
X33 VDD GND.t493 VDD VDD sg13_lv_pmos ad=0.19p pd=1.38u as=0 ps=0 w=1u l=1u
X34 a_3609_16119# a_2667_16007# a_3407_16357# VDD sg13_lv_pmos ad=93.45f pd=0.865u as=0.2048p ps=1.63u w=0.42u l=0.13u
X35 VDD GND.t703 VDD VDD sg13_lv_pmos ad=0.34p pd=2.68u as=0 ps=0 w=1u l=1u
X36 GND.t918 VDD GND.t920 GND.t919 sg13_lv_nmos ad=79.8f pd=0.8u as=0 ps=0 w=0.42u l=1u
X37 GND.t826 VDD GND.t825 GND.t824 sg13_lv_nmos ad=0.1428p pd=1.52u as=0 ps=0 w=0.42u l=1u
X38 a_4625_16800# _250_.Q GND.t50 GND.t14 sg13_lv_nmos ad=0.17462p pd=1.185u as=0.374p ps=2.46u w=0.55u l=0.13u
X39 a_16498_9186# _260_.RESET_B GND.t303 GND.t72 sg13_lv_nmos ad=37.8f pd=0.6u as=79.8f ps=0.8u w=0.42u l=0.13u
X40 clkbuf_1_0__f_sclk.A a_3886_10702# VDD VDD sg13_lv_pmos ad=0.2128p pd=1.5u as=0.2128p ps=1.5u w=1.12u l=0.13u
X41 VDD GND.t100 VDD VDD sg13_lv_pmos ad=0.34p pd=2.68u as=0 ps=0 w=1u l=1u
X42 GND.t356 VDD GND.t356 GND.t217 sg13_lv_nmos ad=79.8f pd=0.8u as=0 ps=0 w=0.42u l=1u
X43 GND.t1353 VDD GND.t1355 GND.t1354 sg13_lv_nmos ad=79.8f pd=0.8u as=0 ps=0 w=0.42u l=1u
X44 a_16018_15234# _239_.Y GND.t310 GND.t309 sg13_lv_nmos ad=37.8f pd=0.6u as=79.8f ps=0.8u w=0.42u l=0.13u
X45 VDD GND.t787 VDD VDD sg13_lv_pmos ad=0.34p pd=2.68u as=0 ps=0 w=1u l=1u
X46 GND.t569 VDD GND.t557 GND.t1089 sg13_lv_nmos ad=0.1428p pd=1.52u as=0 ps=0 w=0.42u l=1u
X47 a_14724_12528# a_15243_12332# a_15983_12287# GND.t583 sg13_lv_nmos ad=0.3473p pd=2.71u as=0.12665p ps=1.145u w=0.74u l=0.13u
X48 VDD GND.t404 VDD VDD sg13_lv_pmos ad=0.34p pd=2.68u as=0 ps=0 w=1u l=1u
X49 _199_.Y _195_.Y a_5427_15260# GND.t178 sg13_lv_nmos ad=0.1406p pd=1.12u as=0.1406p ps=1.12u w=0.74u l=0.13u
X50 a_2374_13397# _221_.Y GND.t133 GND.t546 sg13_lv_nmos ad=37.8f pd=0.6u as=0.1701p ps=1.65u w=0.42u l=0.13u
X51 VDD fanout8.A a_9352_17508# VDD sg13_lv_pmos ad=0.2114p pd=1.54u as=0.2856p ps=2.36u w=0.84u l=0.13u
X52 GND.t794 VDD GND.t794 GND.t795 sg13_lv_nmos ad=0.1428p pd=1.52u as=0 ps=0 w=0.42u l=1u
X53 GND.t1191 VDD GND.t39 GND.t5 sg13_lv_nmos ad=0.1428p pd=1.52u as=0 ps=0 w=0.42u l=1u
X54 VDD GND.t1094 VDD VDD sg13_lv_pmos ad=0.34p pd=2.68u as=0 ps=0 w=1u l=1u
X55 VDD GND.t1000 VDD VDD sg13_lv_pmos ad=0.19p pd=1.38u as=0 ps=0 w=1u l=1u
X56 a_8325_16007# fanout7.A GND.t14 GND.t1518 sg13_lv_nmos ad=0.2516p pd=2.16u as=2.6164p ps=16.515u w=0.74u l=0.13u
X57 a_2724_9199# a_2955_9308# a_2410_9409# GND.t165 sg13_lv_nmos ad=0.2373p pd=1.97u as=79.8f ps=0.8u w=0.42u l=0.13u
X58 VDD GND.t136 VDD VDD sg13_lv_pmos ad=0.34p pd=2.68u as=0 ps=0 w=1u l=1u
X59 a_2628_3904# a_2602_3868# GND.t119 GND.t118 sg13_lv_nmos ad=0.2516p pd=2.16u as=0.1626p ps=1.415u w=0.74u l=0.13u
X60 a_16336_11702# a_16079_11821# a_16498_11898# GND.t3 sg13_lv_nmos ad=0.1428p pd=1.52u as=37.8f ps=0.6u w=0.42u l=0.13u
X61 GND.t901 VDD GND.t901 GND.t902 sg13_lv_nmos ad=79.8f pd=0.8u as=0 ps=0 w=0.42u l=1u
X62 VDD a_16079_8797# a_16336_8678# VDD sg13_lv_pmos ad=2.75005p pd=18.05u as=79.8f ps=0.8u w=0.42u l=0.13u
X63 a_2232_15428# _124_.S VDD VDD sg13_lv_pmos ad=0.2856p pd=2.36u as=0.253p ps=1.53u w=0.84u l=0.13u
X64 VDD GND.t1000 VDD VDD sg13_lv_pmos ad=0.19p pd=1.38u as=0 ps=0 w=1u l=1u
X65 VDD a_15237_11471# a_15339_11471# VDD sg13_lv_pmos ad=5.15485p pd=34.14u as=0.3864p ps=2.93u w=1.12u l=0.13u
X66 a_9369_16119# a_8427_16007# a_9167_16357# VDD sg13_lv_pmos ad=93.45f pd=0.865u as=0.2048p ps=1.63u w=0.42u l=0.13u
X67 VDD GND.t307 VDD VDD sg13_lv_pmos ad=0.34p pd=2.68u as=0 ps=0 w=1u l=1u
X68 VDD GND.t514 VDD VDD sg13_lv_pmos ad=0.34p pd=2.68u as=0 ps=0 w=1u l=1u
X69 a_13366_13350# _126_.B1 GND.t108 GND.t443 sg13_lv_nmos ad=0.1406p pd=1.12u as=0.1406p ps=1.12u w=0.74u l=0.15u
X70 VDD GND.t125 VDD VDD sg13_lv_pmos ad=0.34p pd=2.68u as=0 ps=0 w=1u l=1u
X71 a_13391_12287# a_12549_12189# a_13297_12287# GND.t250 sg13_lv_nmos ad=0.12665p pd=1.145u as=0.1428p ps=1.52u w=0.42u l=0.13u
X72 a_2512_4654# _243_.Q a_2398_4654# GND.t641 sg13_lv_nmos ad=0.3367p pd=1.65u as=0.1628p ps=1.18u w=0.74u l=0.13u
X73 _199_.Y _199_.B1 a_5333_15532# VDD sg13_lv_pmos ad=0.3808p pd=2.92u as=0.2128p ps=1.5u w=1.12u l=0.13u
X74 GND.t1287 VDD GND.t1286 GND.t1285 sg13_lv_nmos ad=0.1428p pd=1.52u as=0 ps=0 w=0.42u l=1u
X75 _168_.B _136_.A a_5466_9202# GND.t21 sg13_lv_nmos ad=0.1628p pd=1.18u as=88.8f ps=0.98u w=0.74u l=0.13u
X76 a_3609_17061# a_2667_16868# a_3407_16823# VDD sg13_lv_pmos ad=93.45f pd=0.865u as=0.2048p ps=1.63u w=0.42u l=0.13u
X77 a_12623_16823# a_11781_16725# a_12529_16823# GND.t1570 sg13_lv_nmos ad=0.12665p pd=1.145u as=0.1428p ps=1.52u w=0.42u l=0.13u
X78 GND.t671 VDD GND.t671 GND.t1017 sg13_lv_nmos ad=79.8f pd=0.8u as=0 ps=0 w=0.42u l=1u
X79 a_2122_16969# a_2565_16725# a_1862_16746# GND.t95 sg13_lv_nmos ad=79.8f pd=0.8u as=0.1296p ps=1.52u w=0.42u l=0.13u
X80 GND.t1338 VDD GND.t1340 GND.t1339 sg13_lv_nmos ad=79.8f pd=0.8u as=0 ps=0 w=0.42u l=1u
X81 a_2126_11726# _173_.A a_2298_11484# VDD sg13_lv_pmos ad=0.2225p pd=1.445u as=0.2975p ps=1.595u w=1u l=0.13u
X82 a_2436_16421# a_2667_16007# a_2122_15964# GND.t615 sg13_lv_nmos ad=0.2373p pd=1.97u as=79.8f ps=0.8u w=0.42u l=0.13u
X83 a_7258_8806# _136_.A GND.t606 GND.t21 sg13_lv_nmos ad=0.1406p pd=1.12u as=0.2516p ps=2.16u w=0.74u l=0.13u
X84 VDD a_15861_16904# a_14940_16710# VDD sg13_lv_pmos ad=0.36237p pd=2.605u as=0.34p ps=2.68u w=1u l=0.13u
X85 VDD GND.t800 VDD VDD sg13_lv_pmos ad=0.34p pd=2.68u as=0 ps=0 w=1u l=1u
X86 VDD _128_.B1 _129_.B1 VDD sg13_lv_pmos ad=0.3808p pd=2.92u as=0.2128p ps=1.5u w=1.12u l=0.15u
X87 VDD GND.t348 VDD VDD sg13_lv_pmos ad=0.34p pd=2.68u as=0 ps=0 w=1u l=1u
X88 GND.t26 VDD GND.t26 GND.t684 sg13_lv_nmos ad=79.8f pd=0.8u as=0 ps=0 w=0.42u l=1u
X89 VDD _173_.A a_5372_9484# VDD sg13_lv_pmos ad=0.2128p pd=1.5u as=0.3808p ps=2.92u w=1.12u l=0.13u
X90 GND.t125 a_3760_12430# a_3409_12287# GND.t258 sg13_lv_nmos ad=79.8f pd=0.8u as=0.1428p ps=1.52u w=0.42u l=0.13u
X91 GND.t1006 VDD GND.t1010 GND.t1009 sg13_lv_nmos ad=79.8f pd=0.8u as=0 ps=0 w=0.42u l=1u
X92 VDD _124_.S a_2558_17532# VDD sg13_lv_pmos ad=0.253p pd=1.53u as=0.3325p ps=1.665u w=1u l=0.13u
X93 VDD GND.t1169 VDD VDD sg13_lv_pmos ad=0.34p pd=2.68u as=0 ps=0 w=1u l=1u
X94 VDD GND.t1072 VDD VDD sg13_lv_pmos ad=0.34p pd=2.68u as=0 ps=0 w=1u l=1u
X95 GND.t607 _136_.A a_5242_8806# GND.t21 sg13_lv_nmos ad=0.2516p pd=2.16u as=0.1406p ps=1.12u w=0.74u l=0.13u
X96 VDD a_2853_9165# a_2955_9308# VDD sg13_lv_pmos ad=1.94845p pd=12.685u as=0.3864p ps=2.93u w=1.12u l=0.13u
X97 a_8580_16759# a_8811_16868# a_8266_16969# GND.t251 sg13_lv_nmos ad=0.2373p pd=1.97u as=79.8f ps=0.8u w=0.42u l=0.13u
X98 VDD a_3380_13690# _247_.CLK VDD sg13_lv_pmos ad=0.2128p pd=1.5u as=0.2128p ps=1.5u w=1.12u l=0.13u
X99 a_9636_4663# a_9867_4772# a_9322_4873# GND.t1578 sg13_lv_nmos ad=0.2373p pd=1.97u as=79.8f ps=0.8u w=0.42u l=0.13u
X100 _124_.S a_1192_11460# VDD VDD sg13_lv_pmos ad=0.42p pd=2.99u as=0.2114p ps=1.54u w=1.12u l=0.13u
X101 a_6468_4968# a_6442_4873# VDD VDD sg13_lv_pmos ad=0.34p pd=2.68u as=0.36237p ps=2.605u w=1u l=0.13u
X102 VDD GND.t1010 VDD VDD sg13_lv_pmos ad=0.34p pd=2.68u as=0 ps=0 w=1u l=1u
X103 GND.t177 _266_.CLK _212_.Y GND.t596 sg13_lv_nmos ad=0.2516p pd=2.16u as=0.2516p ps=2.16u w=0.74u l=0.13u
X104 VDD GND.t171 VDD VDD sg13_lv_pmos ad=0.34p pd=2.68u as=0 ps=0 w=1u l=1u
X105 VDD _222_.Y a_1862_16746# VDD sg13_lv_pmos ad=0.36237p pd=2.605u as=79.8f ps=0.8u w=0.42u l=0.13u
X106 VDD _238_.Y a_14572_16746# VDD sg13_lv_pmos ad=1.30717p pd=8.395u as=79.8f ps=0.8u w=0.42u l=0.13u
X107 GND.t195 _124_.S a_2620_15238# GND.t194 sg13_lv_nmos ad=0.18945p pd=1.27u as=0.13135p ps=1.095u w=0.74u l=0.13u
X108 _242_.D a_2398_5782# GND.t5 GND.t83 sg13_lv_nmos ad=0.4033p pd=2.57u as=0.148p ps=1.14u w=0.74u l=0.13u
X109 a_12110_8784# _145_.X a_11731_8698# GND.t330 sg13_lv_nmos ad=81.6f pd=0.895u as=0.1216p ps=1.02u w=0.64u l=0.13u
X110 a_14724_12528# a_14698_12433# GND.t55 GND.t54 sg13_lv_nmos ad=0.2516p pd=2.16u as=0.1626p ps=1.415u w=0.74u l=0.13u
X111 GND.t79 a_10769_4258# _139_.X GND.t78 sg13_lv_nmos ad=0.3108p pd=2.32u as=0.1628p ps=1.18u w=0.74u l=0.13u
X112 GND.t182 VDD GND.t1193 GND.t5 sg13_lv_nmos ad=0.1428p pd=1.52u as=0 ps=0 w=0.42u l=1u
X113 _190_.A a_11082_14020# VDD VDD sg13_lv_pmos ad=0.3808p pd=2.92u as=0.2128p ps=1.5u w=1.12u l=0.13u
X114 GND.t253 VDD GND.t404 GND.t940 sg13_lv_nmos ad=79.8f pd=0.8u as=0 ps=0 w=0.42u l=1u
X115 _168_.A a_11946_9484# VDD VDD sg13_lv_pmos ad=0.3808p pd=2.92u as=0.2128p ps=1.5u w=1.12u l=0.13u
X116 a_14757_15213# _266_.CLK GND.t578 GND.t577 sg13_lv_nmos ad=0.2516p pd=2.16u as=13.40377p ps=86.265u w=0.74u l=0.13u
X117 GND.t726 VDD GND.t726 GND.t712 sg13_lv_nmos ad=0.1428p pd=1.52u as=0 ps=0 w=0.42u l=1u
X118 a_5201_9240# _173_.A GND.t1413 GND.t21 sg13_lv_nmos ad=0.17462p pd=1.185u as=0.374p ps=2.46u w=0.55u l=0.13u
X119 VDD GND.t26 VDD VDD sg13_lv_pmos ad=0.34p pd=2.68u as=0 ps=0 w=1u l=1u
X120 VDD GND.t404 VDD VDD sg13_lv_pmos ad=0.19p pd=1.38u as=0 ps=0 w=1u l=1u
X121 GND.t768 VDD GND.t768 GND.t601 sg13_lv_nmos ad=0.1428p pd=1.52u as=0 ps=0 w=0.42u l=1u
X122 GND.t1272 VDD GND.t1271 GND.t1270 sg13_lv_nmos ad=0.1428p pd=1.52u as=0 ps=0 w=0.42u l=1u
X123 GND.t77 _260_.CLK _132_.Y GND.t542 sg13_lv_nmos ad=0.2516p pd=2.16u as=0.1406p ps=1.12u w=0.74u l=0.13u
X124 a_13092_16421# a_12804_16000# a_13030_16421# GND.t117 sg13_lv_nmos ad=0.1428p pd=1.52u as=37.8f ps=0.6u w=0.42u l=0.13u
X125 a_2436_13397# a_2148_12976# a_2374_13397# GND.t587 sg13_lv_nmos ad=0.1428p pd=1.52u as=37.8f ps=0.6u w=0.42u l=0.13u
X126 VDD GND.t703 VDD VDD sg13_lv_pmos ad=0.34p pd=2.68u as=0 ps=0 w=1u l=1u
X127 a_9444_12223# a_9675_12332# a_9130_12433# GND.t215 sg13_lv_nmos ad=0.2373p pd=1.97u as=79.8f ps=0.8u w=0.42u l=0.13u
X128 VDD GND.t42 VDD VDD sg13_lv_pmos ad=0.34p pd=2.68u as=0 ps=0 w=1u l=1u
X129 VDD GND.t391 VDD VDD sg13_lv_pmos ad=0.34p pd=2.68u as=0 ps=0 w=1u l=1u
X130 a_2148_16000# a_2667_16007# a_3407_16357# GND.t14 sg13_lv_nmos ad=0.3473p pd=2.71u as=0.12665p ps=1.145u w=0.74u l=0.13u
X131 a_15141_12189# _263_.CLK VDD VDD sg13_lv_pmos ad=0.4088p pd=2.97u as=1.36162p ps=8.745u w=1.12u l=0.13u
X132 _171_.Y a_8014_8492# GND.t337 GND.t21 sg13_lv_nmos ad=0.1406p pd=1.12u as=0.17255p ps=1.25u w=0.74u l=0.13u
X133 a_8196_16421# a_8427_16007# a_7882_15964# GND.t1415 sg13_lv_nmos ad=0.2373p pd=1.97u as=79.8f ps=0.8u w=0.42u l=0.13u
X134 GND.t829 VDD GND.t195 GND.t828 sg13_lv_nmos ad=0.1428p pd=1.52u as=0 ps=0 w=0.42u l=1u
X135 VDD a_13391_12287# a_13648_12430# VDD sg13_lv_pmos ad=1.42082p pd=9.125u as=79.8f ps=0.8u w=0.42u l=0.13u
X136 VDD _260_.CLK a_13804_10996# VDD sg13_lv_pmos ad=0.4032p pd=2.96u as=0.1176p ps=1.33u w=1.12u l=0.13u
X137 GND.t94 a_9808_16966# a_9457_16823# GND.t19 sg13_lv_nmos ad=79.8f pd=0.8u as=0.1428p ps=1.52u w=0.42u l=0.13u
X138 GND.t222 a_16079_8797# a_16746_8436# GND.t72 sg13_lv_nmos ad=0.1406p pd=1.12u as=0.2516p ps=2.16u w=0.74u l=0.13u
X139 a_8709_16725# fanout7.A GND.t14 GND.t93 sg13_lv_nmos ad=0.2516p pd=2.16u as=2.6164p ps=16.515u w=0.74u l=0.13u
X140 _124_.S a_1192_11460# GND.t63 GND.t62 sg13_lv_nmos ad=0.2886p pd=2.26u as=0.14875p ps=1.16u w=0.74u l=0.13u
X141 VDD GND.t1000 VDD VDD sg13_lv_pmos ad=0.34p pd=2.68u as=0 ps=0 w=1u l=1u
X142 VDD GND.t198 VDD VDD sg13_lv_pmos ad=0.34p pd=2.68u as=0 ps=0 w=1u l=1u
X143 VDD GND.t404 VDD VDD sg13_lv_pmos ad=0.34p pd=2.68u as=0 ps=0 w=1u l=1u
X144 VDD GND.t1027 VDD VDD sg13_lv_pmos ad=0.19p pd=1.38u as=0 ps=0 w=1u l=1u
X145 a_2232_15428# _124_.S GND.t195 GND.t196 sg13_lv_nmos ad=0.187p pd=1.78u as=0.18945p ps=1.27u w=0.55u l=0.13u
X146 GND.t402 VDD GND.t404 GND.t964 sg13_lv_nmos ad=0.1428p pd=1.52u as=0 ps=0 w=0.42u l=1u
X147 GND.t249 a_15141_12189# a_15243_12332# GND.t455 sg13_lv_nmos ad=3.6571p pd=23.85u as=0.2516p ps=2.16u w=0.74u l=0.13u
X148 _131_.Y _131_.B1 GND.t77 GND.t76 sg13_lv_nmos ad=0.1406p pd=1.12u as=0.2516p ps=2.16u w=0.74u l=0.13u
X149 GND.t800 VDD GND.t221 GND.t799 sg13_lv_nmos ad=0.1428p pd=1.52u as=0 ps=0 w=0.42u l=1u
X150 a_13464_12952# _131_.A2 VDD VDD sg13_lv_pmos ad=0.2128p pd=1.5u as=0.3808p ps=2.92u w=1.12u l=0.15u
X151 a_10864_4870# _252_.RESET_B VDD VDD sg13_lv_pmos ad=79.8f pd=0.8u as=1.48542p ps=9.54u w=0.42u l=0.13u
X152 a_3380_13690# clkbuf_1_0__f_sclk.A VDD VDD sg13_lv_pmos ad=0.2128p pd=1.5u as=0.2128p ps=1.5u w=1.12u l=0.13u
X153 GND.t65 _136_.B _138_.Y GND.t240 sg13_lv_nmos ad=0.2516p pd=2.16u as=0.1406p ps=1.12u w=0.74u l=0.13u
X154 GND.t836 VDD GND.t797 GND.t835 sg13_lv_nmos ad=0.1428p pd=1.52u as=0 ps=0 w=0.42u l=1u
X155 GND.t809 VDD GND.t812 GND.t856 sg13_lv_nmos ad=79.8f pd=0.8u as=0 ps=0 w=0.42u l=1u
X156 VDD GND.t348 VDD VDD sg13_lv_pmos ad=0.34p pd=2.68u as=0 ps=0 w=1u l=1u
X157 VDD _160_.X a_10895_8436# VDD sg13_lv_pmos ad=0.2128p pd=1.5u as=0.3808p ps=2.92u w=1.12u l=0.13u
X158 GND.t419 _148_.B a_12331_5760# GND.t5 sg13_lv_nmos ad=0.1331p pd=1.12u as=0.1216p ps=1.02u w=0.64u l=0.13u
X159 VDD a_2126_7864# _122_.X VDD sg13_lv_pmos ad=0.2198p pd=1.52u as=0.6048p ps=3.32u w=1.12u l=0.13u
X160 VDD GND.t223 VDD VDD sg13_lv_pmos ad=0.34p pd=2.68u as=0 ps=0 w=1u l=1u
X161 a_14698_12433# a_15141_12189# a_15081_12601# VDD sg13_lv_pmos ad=79.8f pd=0.8u as=63f ps=0.72u w=0.42u l=0.13u
X162 GND.t1318 VDD GND.t225 GND.t1317 sg13_lv_nmos ad=0.1428p pd=1.52u as=0 ps=0 w=0.42u l=1u
X163 GND.t519 VDD GND.t519 GND.t1111 sg13_lv_nmos ad=79.8f pd=0.8u as=0 ps=0 w=0.42u l=1u
X164 GND.t465 VDD GND.t26 GND.t732 sg13_lv_nmos ad=0.1428p pd=1.52u as=0 ps=0 w=0.42u l=1u
X165 a_14757_15213# _266_.CLK VDD VDD sg13_lv_pmos ad=0.4088p pd=2.97u as=1.54765p ps=10.005u w=1.12u l=0.13u
X166 VDD GND.t809 VDD VDD sg13_lv_pmos ad=0.19p pd=1.38u as=0 ps=0 w=1u l=1u
X167 GND.t689 _118_.A0 a_4661_17878# GND.t1529 sg13_lv_nmos ad=0.1898p pd=1.36u as=0.2516p ps=2.16u w=0.74u l=0.13u
X168 a_8292_17064# a_8266_16969# GND.t261 GND.t1577 sg13_lv_nmos ad=0.2516p pd=2.16u as=0.1626p ps=1.415u w=0.74u l=0.13u
X169 VDD a_12880_16966# a_12825_17061# VDD sg13_lv_pmos ad=1.30717p pd=8.395u as=93.45f ps=0.865u w=0.42u l=0.13u
X170 _208_.X a_4625_16800# a_4796_17044# VDD sg13_lv_pmos ad=0.3808p pd=2.92u as=0.2128p ps=1.5u w=1.12u l=0.13u
X171 GND.t14 a_2565_16007# a_2667_16007# GND.t96 sg13_lv_nmos ad=2.85425p pd=18.015u as=0.2516p ps=2.16u w=0.74u l=0.13u
X172 _247_.CLK a_3380_13690# GND.t379 GND.t46 sg13_lv_nmos ad=0.1406p pd=1.12u as=0.1406p ps=1.12u w=0.74u l=0.13u
X173 GND.t1328 VDD GND.t1330 GND.t1329 sg13_lv_nmos ad=79.8f pd=0.8u as=0 ps=0 w=0.42u l=1u
X174 GND.t139 _183_.Y a_8050_10326# GND.t620 sg13_lv_nmos ad=0.1406p pd=1.12u as=0.1406p ps=1.12u w=0.74u l=0.15u
X175 a_16079_11821# a_15237_11471# a_15985_11821# GND.t3 sg13_lv_nmos ad=0.12665p pd=1.145u as=0.1428p ps=1.52u w=0.42u l=0.13u
X176 GND.t1027 a_3886_10702# clkbuf_1_0__f_sclk.A GND.t1450 sg13_lv_nmos ad=0.1406p pd=1.12u as=0.1406p ps=1.12u w=0.74u l=0.13u
X177 a_10308_17933# a_10539_17519# a_9994_17476# GND.t382 sg13_lv_nmos ad=0.2373p pd=1.97u as=79.8f ps=0.8u w=0.42u l=0.13u
X178 a_7634_8802# _168_.Y GND.t622 GND.t21 sg13_lv_nmos ad=0.1406p pd=1.12u as=0.2886p ps=2.26u w=0.74u l=0.13u
X179 VDD _228_.Y a_9994_9409# VDD sg13_lv_pmos ad=0.1563p pd=1.22u as=0.147p ps=1.54u w=0.42u l=0.13u
X180 GND.t77 VDD GND.t77 GND.t1013 sg13_lv_nmos ad=0.1428p pd=1.52u as=0 ps=0 w=0.42u l=1u
X181 _241_.Y _236_.A VDD VDD sg13_lv_pmos ad=0.3808p pd=2.92u as=0.3808p ps=2.92u w=1.12u l=0.13u
X182 GND.t947 VDD GND.t125 GND.t946 sg13_lv_nmos ad=0.1428p pd=1.52u as=0 ps=0 w=0.42u l=1u
X183 a_6528_8475# _168_.A VDD VDD sg13_lv_pmos ad=0.1596p pd=1.22u as=0.4536p ps=2.76u w=0.84u l=0.13u
X184 GND.t222 a_16079_9263# a_16746_9484# GND.t72 sg13_lv_nmos ad=0.1406p pd=1.12u as=0.2516p ps=2.16u w=0.74u l=0.13u
X185 a_6949_5782# _210_.A GND.t85 GND.t5 sg13_lv_nmos ad=0.1406p pd=1.12u as=0.14505p ps=1.15u w=0.74u l=0.13u
X186 GND.t144 _222_.Y a_1956_16746# GND.t629 sg13_lv_nmos ad=0.1626p pd=1.415u as=60.89999f ps=0.71u w=0.42u l=0.13u
X187 VDD GND.t815 VDD VDD sg13_lv_pmos ad=0.34p pd=2.68u as=0 ps=0 w=1u l=1u
X188 GND.t788 VDD GND.t787 GND.t786 sg13_lv_nmos ad=0.1428p pd=1.52u as=0 ps=0 w=0.42u l=1u
X189 a_2301_4654# _124_.S GND.t119 GND.t208 sg13_lv_nmos ad=0.13135p pd=1.095u as=0.18945p ps=1.27u w=0.74u l=0.13u
X190 a_8501_10702# _181_.Y GND.t136 GND.t575 sg13_lv_nmos ad=0.1406p pd=1.12u as=0.1898p ps=1.36u w=0.74u l=0.13u
X191 a_10737_3900# _243_.Q VDD VDD sg13_lv_pmos ad=0.1225p pd=1.245u as=0.36p ps=2.72u w=1u l=0.13u
X192 a_2342_4338# a_3147_3911# a_2602_3868# VDD sg13_lv_pmos ad=0.1428p pd=1.52u as=79.8f ps=0.8u w=0.42u l=0.13u
X193 a_7908_16000# a_8427_16007# a_9167_16357# GND.t1416 sg13_lv_nmos ad=0.3473p pd=2.71u as=0.12665p ps=1.145u w=0.74u l=0.13u
X194 a_6885_4629# _251_.CLK GND.t234 GND.t1557 sg13_lv_nmos ad=0.2516p pd=2.16u as=4.10715p ps=27.105u w=0.74u l=0.13u
X195 a_13824_7989# _160_.B VDD VDD sg13_lv_pmos ad=0.1596p pd=1.22u as=0.4536p ps=2.76u w=0.84u l=0.13u
X196 VDD _166_.A _170_.B VDD sg13_lv_pmos ad=0.3808p pd=2.92u as=0.2128p ps=1.5u w=1.12u l=0.13u
X197 GND.t77 VDD GND.t77 GND.t1047 sg13_lv_nmos ad=0.1428p pd=1.52u as=0 ps=0 w=0.42u l=1u
X198 VDD a_3886_10702# clkbuf_1_0__f_sclk.A VDD sg13_lv_pmos ad=0.2128p pd=1.5u as=0.2128p ps=1.5u w=1.12u l=0.13u
X199 fanout8.A a_1192_17508# VDD VDD sg13_lv_pmos ad=0.42p pd=2.99u as=0.2114p ps=1.54u w=1.12u l=0.13u
X200 a_7553_14832# _186_.Y _202_.Y GND.t1525 sg13_lv_nmos ad=0.1406p pd=1.12u as=0.1406p ps=1.12u w=0.74u l=0.13u
X201 a_1580_12936# fanout8.A VDD VDD sg13_lv_pmos ad=0.2856p pd=2.36u as=0.2114p ps=1.54u w=0.84u l=0.13u
X202 VDD _170_.Y a_8014_8492# VDD sg13_lv_pmos ad=0.2618p pd=1.63u as=0.2856p ps=2.36u w=0.84u l=0.13u
X203 a_12132_12528# a_12651_12332# a_13391_12287# GND.t476 sg13_lv_nmos ad=0.3473p pd=2.71u as=0.12665p ps=1.145u w=0.74u l=0.13u
X204 VDD _180_.X a_8603_9484# VDD sg13_lv_pmos ad=0.2128p pd=1.5u as=0.2128p ps=1.5u w=1.12u l=0.13u
X205 a_2298_10318# a_2232_10210# GND.t100 GND.t99 sg13_lv_nmos ad=0.3367p pd=1.65u as=0.148p ps=1.14u w=0.74u l=0.13u
X206 a_16281_11583# a_15339_11471# a_16079_11821# VDD sg13_lv_pmos ad=93.45f pd=0.865u as=0.2048p ps=1.63u w=0.42u l=0.13u
X207 GND.t21 a_15237_8447# a_15339_8447# GND.t71 sg13_lv_nmos ad=4.0443p pd=25.39u as=0.2516p ps=2.16u w=0.74u l=0.13u
X208 a_6320_10296# _174_.Y a_6218_10296# GND.t633 sg13_lv_nmos ad=0.1216p pd=1.02u as=0.1216p ps=1.02u w=0.64u l=0.13u
X209 GND.t139 _178_.Y _185_.Y GND.t313 sg13_lv_nmos ad=0.2516p pd=2.16u as=0.1406p ps=1.12u w=0.74u l=0.13u
X210 _201_.Y a_6286_15276# GND.t315 GND.t314 sg13_lv_nmos ad=0.1406p pd=1.12u as=0.17255p ps=1.25u w=0.74u l=0.13u
X211 GND.t264 VDD GND.t264 GND.t1142 sg13_lv_nmos ad=79.8f pd=0.8u as=0 ps=0 w=0.42u l=1u
X212 VDD _250_.RESET_B a_2122_15964# VDD sg13_lv_pmos ad=0.1563p pd=1.22u as=0.147p ps=1.54u w=0.42u l=0.13u
X213 VDD GND.t1000 VDD VDD sg13_lv_pmos ad=0.34p pd=2.68u as=0 ps=0 w=1u l=1u
X214 VDD GND.t1064 VDD VDD sg13_lv_pmos ad=0.34p pd=2.68u as=0 ps=0 w=1u l=1u
X215 VDD GND.t1027 VDD VDD sg13_lv_pmos ad=0.19p pd=1.38u as=0 ps=0 w=1u l=1u
X216 a_14820_11464# a_14794_11428# GND.t55 GND.t1580 sg13_lv_nmos ad=0.2516p pd=2.16u as=0.1626p ps=1.415u w=0.74u l=0.13u
X217 GND.t307 VDD GND.t307 GND.t887 sg13_lv_nmos ad=79.8f pd=0.8u as=0 ps=0 w=0.42u l=1u
X218 GND.t1421 _148_.B a_4913_13330# GND.t46 sg13_lv_nmos ad=0.15245p pd=1.17u as=0.17462p ps=1.185u w=0.55u l=0.13u
X219 a_6442_4873# a_6885_4629# a_6825_5041# VDD sg13_lv_pmos ad=79.8f pd=0.8u as=63f ps=0.72u w=0.42u l=0.13u
X220 _210_.B a_6810_3863# GND.t65 GND.t64 sg13_lv_nmos ad=0.1628p pd=1.18u as=0.3108p ps=2.32u w=0.74u l=0.13u
X221 GND.t693 VDD GND.t693 GND.t695 sg13_lv_nmos ad=79.8f pd=0.8u as=0 ps=0 w=0.42u l=1u
X222 VDD GND.t519 VDD VDD sg13_lv_pmos ad=0.19p pd=1.38u as=0 ps=0 w=1u l=1u
X223 GND.t776 VDD GND.t674 GND.t775 sg13_lv_nmos ad=79.8f pd=0.8u as=0 ps=0 w=0.42u l=1u
X224 VDD GND.t441 VDD VDD sg13_lv_pmos ad=0.34p pd=2.68u as=0 ps=0 w=1u l=1u
X225 a_10020_9504# a_9994_9409# VDD VDD sg13_lv_pmos ad=0.34p pd=2.68u as=0.36237p ps=2.605u w=1u l=0.13u
X226 _259_.RESET_B _222_.A GND.t261 GND.t14 sg13_lv_nmos ad=0.2516p pd=2.16u as=0.2516p ps=2.16u w=0.74u l=0.13u
X227 GND.t14 a_8325_16007# a_8427_16007# GND.t28 sg13_lv_nmos ad=2.85425p pd=18.015u as=0.2516p ps=2.16u w=0.74u l=0.13u
X228 a_15983_12287# a_15141_12189# a_15889_12287# GND.t456 sg13_lv_nmos ad=0.12665p pd=1.145u as=0.1428p ps=1.52u w=0.42u l=0.13u
X229 _149_.A a_16650_5412# GND.t469 GND.t82 sg13_lv_nmos ad=0.2516p pd=2.16u as=0.1406p ps=1.12u w=0.74u l=0.13u
X230 VDD GND.t815 VDD VDD sg13_lv_pmos ad=0.19p pd=1.38u as=0 ps=0 w=1u l=1u
X231 a_6962_9194# _178_.B1 GND.t40 GND.t21 sg13_lv_nmos ad=0.1406p pd=1.12u as=0.2886p ps=2.26u w=0.74u l=0.13u
X232 a_15108_8861# a_15339_8447# a_14794_8404# GND.t128 sg13_lv_nmos ad=0.2373p pd=1.97u as=79.8f ps=0.8u w=0.42u l=0.13u
X233 GND.t404 VDD GND.t404 GND.t963 sg13_lv_nmos ad=79.8f pd=0.8u as=0 ps=0 w=0.42u l=1u
X234 GND.t1168 VDD GND.t1169 GND.t5 sg13_lv_nmos ad=0.1428p pd=1.52u as=0 ps=0 w=0.42u l=1u
X235 _179_.Y _177_.X GND.t42 GND.t650 sg13_lv_nmos ad=0.1406p pd=1.12u as=0.2516p ps=2.16u w=0.74u l=0.13u
X236 a_2620_17878# _118_.A0 a_2126_17774# GND.t1528 sg13_lv_nmos ad=0.13135p pd=1.095u as=0.1628p ps=1.18u w=0.74u l=0.13u
X237 a_2122_12940# a_2565_12983# a_1862_13410# GND.t1430 sg13_lv_nmos ad=79.8f pd=0.8u as=0.1296p ps=1.52u w=0.42u l=0.13u
X238 a_2244_12528# a_2218_12433# GND.t122 GND.t62 sg13_lv_nmos ad=0.2516p pd=2.16u as=0.1626p ps=1.415u w=0.74u l=0.13u
X239 a_2512_5782# _210_.A a_2398_5782# GND.t83 sg13_lv_nmos ad=0.3367p pd=1.65u as=0.1628p ps=1.18u w=0.74u l=0.13u
X240 _210_.A a_5226_4948# GND.t400 GND.t471 sg13_lv_nmos ad=0.2516p pd=2.16u as=0.1406p ps=1.12u w=0.74u l=0.13u
X241 a_12518_16434# _135_.X VDD VDD sg13_lv_pmos ad=79.8f pd=0.8u as=0.1428p ps=1.52u w=0.42u l=0.13u
X242 GND.t305 a_12992_15437# _135_.X GND.t304 sg13_lv_nmos ad=0.1331p pd=1.12u as=0.2516p ps=2.16u w=0.74u l=0.13u
X243 a_3014_4650# _242_.D VDD VDD sg13_lv_pmos ad=79.8f pd=0.8u as=0.1428p ps=1.52u w=0.42u l=0.13u
X244 a_2853_9165# _243_.CLK GND.t21 GND.t231 sg13_lv_nmos ad=0.2516p pd=2.16u as=3.59495p ps=22.57u w=0.74u l=0.13u
X245 a_8352_11013# _179_.Y VDD VDD sg13_lv_pmos ad=0.1596p pd=1.22u as=0.4536p ps=2.76u w=0.84u l=0.13u
X246 _192_.Y _192_.C VDD VDD sg13_lv_pmos ad=0.2128p pd=1.5u as=0.3808p ps=2.92u w=1.12u l=0.13u
X247 fanout6.A a_10218_17044# VDD VDD sg13_lv_pmos ad=0.3808p pd=2.92u as=0.2128p ps=1.5u w=1.12u l=0.13u
X248 _119_.A0 a_4074_12972# VDD VDD sg13_lv_pmos ad=0.3808p pd=2.92u as=0.2128p ps=1.5u w=1.12u l=0.13u
X249 VDD GND.t1149 VDD VDD sg13_lv_pmos ad=0.34p pd=2.68u as=0 ps=0 w=1u l=1u
X250 GND.t1000 VDD GND.t1000 GND.t1003 sg13_lv_nmos ad=0.1428p pd=1.52u as=0 ps=0 w=0.42u l=1u
X251 GND.t703 VDD GND.t703 GND.t745 sg13_lv_nmos ad=0.1428p pd=1.52u as=0 ps=0 w=0.42u l=1u
X252 a_15861_16904# _238_.Y VDD VDD sg13_lv_pmos ad=0.147p pd=1.54u as=0.1563p ps=1.22u w=0.42u l=0.13u
X253 a_15081_5459# a_14724_5416# VDD VDD sg13_lv_pmos ad=63f pd=0.72u as=0.1563p ps=1.22u w=0.42u l=0.13u
X254 a_12215_7664# _162_.Y GND.t264 GND.t1558 sg13_lv_nmos ad=0.1406p pd=1.12u as=0.3811p ps=2.51u w=0.74u l=0.13u
X255 GND.t1176 VDD GND.t1177 GND.t5 sg13_lv_nmos ad=79.8f pd=0.8u as=0 ps=0 w=0.42u l=1u
X256 a_8315_10744# _179_.Y GND.t139 GND.t138 sg13_lv_nmos ad=78.39999f pd=0.885u as=0.2272p ps=1.99u w=0.64u l=0.13u
X257 _250_.Q a_4074_15996# GND.t173 GND.t14 sg13_lv_nmos ad=0.2516p pd=2.16u as=0.1406p ps=1.12u w=0.74u l=0.13u
X258 _218_.Y _215_.A VDD VDD sg13_lv_pmos ad=0.3808p pd=2.92u as=0.3808p ps=2.92u w=1.12u l=0.13u
X259 VDD GND.t718 VDD VDD sg13_lv_pmos ad=0.19p pd=1.38u as=0 ps=0 w=1u l=1u
X260 VDD GND.t493 VDD VDD sg13_lv_pmos ad=0.34p pd=2.68u as=0 ps=0 w=1u l=1u
X261 a_13019_6460# _152_.X _153_.Y VDD sg13_lv_pmos ad=0.2128p pd=1.5u as=0.3808p ps=2.92u w=1.12u l=0.13u
X262 VDD GND.t768 VDD VDD sg13_lv_pmos ad=0.34p pd=2.68u as=0 ps=0 w=1u l=1u
X263 _153_.Y _152_.X GND.t602 GND.t5 sg13_lv_nmos ad=0.1406p pd=1.12u as=0.2516p ps=2.16u w=0.74u l=0.13u
X264 _219_.Y _215_.A GND.t356 GND.t217 sg13_lv_nmos ad=0.2516p pd=2.16u as=0.2516p ps=2.16u w=0.74u l=0.13u
X265 a_12992_15437# _135_.A a_13129_15280# GND.t1505 sg13_lv_nmos ad=0.2176p pd=1.96u as=0.1216p ps=1.02u w=0.64u l=0.13u
X266 a_2661_12189# _247_.CLK VDD VDD sg13_lv_pmos ad=0.4088p pd=2.97u as=1.36162p ps=8.745u w=1.12u l=0.13u
X267 a_6862_15260# _200_.Y GND.t114 GND.t335 sg13_lv_nmos ad=0.1406p pd=1.12u as=0.2516p ps=2.16u w=0.74u l=0.13u
X268 GND.t557 a_3956_6888# _243_.CLK GND.t564 sg13_lv_nmos ad=0.1406p pd=1.12u as=0.1406p ps=1.12u w=0.74u l=0.13u
X269 a_10377_9577# a_10020_9504# VDD VDD sg13_lv_pmos ad=63f pd=0.72u as=0.1563p ps=1.22u w=0.42u l=0.13u
X270 VDD GND.t198 VDD VDD sg13_lv_pmos ad=0.19p pd=1.38u as=0 ps=0 w=1u l=1u
X271 VDD GND.t1188 VDD VDD sg13_lv_pmos ad=0.34p pd=2.68u as=0 ps=0 w=1u l=1u
X272 a_16281_8559# a_15339_8447# a_16079_8797# VDD sg13_lv_pmos ad=93.45f pd=0.865u as=0.2048p ps=1.63u w=0.42u l=0.13u
X273 a_16402_5850# _226_.Y GND.t1205 GND.t82 sg13_lv_nmos ad=37.8f pd=0.6u as=79.8f ps=0.8u w=0.42u l=0.13u
X274 VDD _260_.RESET_B a_14794_9409# VDD sg13_lv_pmos ad=0.1563p pd=1.22u as=0.147p ps=1.54u w=0.42u l=0.13u
X275 GND.t249 a_2661_12189# a_2763_12332# GND.t293 sg13_lv_nmos ad=3.6571p pd=23.85u as=0.2516p ps=2.16u w=0.74u l=0.13u
X276 VDD GND.t264 VDD VDD sg13_lv_pmos ad=0.19p pd=1.38u as=0 ps=0 w=1u l=1u
X277 a_6389_9484# _173_.Y VDD VDD sg13_lv_pmos ad=0.2128p pd=1.5u as=0.2128p ps=1.5u w=1.12u l=0.13u
X278 a_5147_15996# _207_.A2 VDD VDD sg13_lv_pmos ad=0.3808p pd=2.92u as=0.2128p ps=1.5u w=1.12u l=0.13u
X279 a_11279_9263# a_10437_9165# a_10020_9504# VDD sg13_lv_pmos ad=0.2048p pd=1.63u as=0.34p ps=2.68u w=1u l=0.13u
X280 GND.t247 a_15599_15311# a_16266_15532# GND.t474 sg13_lv_nmos ad=0.1406p pd=1.12u as=0.2516p ps=2.16u w=0.74u l=0.13u
X281 VDD GND.t253 VDD VDD sg13_lv_pmos ad=0.34p pd=2.68u as=0 ps=0 w=1u l=1u
X282 a_2342_4338# _243_.D VDD VDD sg13_lv_pmos ad=79.8f pd=0.8u as=0.1428p ps=1.52u w=0.42u l=0.13u
X283 GND.t79 _147_.B1 _147_.Y GND.t1508 sg13_lv_nmos ad=0.2516p pd=2.16u as=0.1406p ps=1.12u w=0.74u l=0.13u
X284 GND.t85 _210_.B a_6747_5468# GND.t5 sg13_lv_nmos ad=0.14505p pd=1.15u as=0.187p ps=1.78u w=0.55u l=0.13u
X285 GND.t838 VDD GND.t838 GND.t839 sg13_lv_nmos ad=0.1428p pd=1.52u as=0 ps=0 w=0.42u l=1u
X286 GND.t181 _148_.X a_13775_5782# GND.t5 sg13_lv_nmos ad=0.1898p pd=1.36u as=0.1406p ps=1.12u w=0.74u l=0.13u
X287 _243_.CLK a_3956_6888# GND.t557 GND.t561 sg13_lv_nmos ad=0.1406p pd=1.12u as=0.1406p ps=1.12u w=0.74u l=0.13u
X288 a_6011_13320# _190_.A GND.t447 GND.t46 sg13_lv_nmos ad=78.39999f pd=0.885u as=0.2272p ps=1.99u w=0.64u l=0.13u
X289 _128_.B1 _260_.CLK VDD VDD sg13_lv_pmos ad=0.2128p pd=1.5u as=0.3808p ps=2.92u w=1.12u l=0.13u
X290 GND.t1108 VDD GND.t1108 GND.t1144 sg13_lv_nmos ad=79.8f pd=0.8u as=0 ps=0 w=0.42u l=1u
X291 VDD GND.t310 VDD VDD sg13_lv_pmos ad=0.34p pd=2.68u as=0 ps=0 w=1u l=1u
X292 a_13030_16421# _237_.Y GND.t177 GND.t186 sg13_lv_nmos ad=37.8f pd=0.6u as=0.1701p ps=1.65u w=0.42u l=0.13u
X293 _187_.Y _120_.A0 VDD VDD sg13_lv_pmos ad=0.2128p pd=1.5u as=0.3808p ps=2.92u w=1.12u l=0.13u
X294 GND.t819 VDD GND.t495 GND.t865 sg13_lv_nmos ad=79.8f pd=0.8u as=0 ps=0 w=0.42u l=1u
X295 a_12420_12223# a_12132_12528# a_12358_12223# GND.t145 sg13_lv_nmos ad=0.1428p pd=1.52u as=37.8f ps=0.6u w=0.42u l=0.13u
X296 a_7872_5451# _145_.A2 a_7835_5760# GND.t5 sg13_lv_nmos ad=0.2176p pd=1.96u as=78.39999f ps=0.885u w=0.64u l=0.13u
X297 _247_.CLK a_3380_13690# VDD VDD sg13_lv_pmos ad=0.2128p pd=1.5u as=0.3976p ps=2.95u w=1.12u l=0.13u
X298 GND.t557 a_3956_6888# _243_.CLK GND.t558 sg13_lv_nmos ad=0.1406p pd=1.12u as=0.1406p ps=1.12u w=0.74u l=0.13u
X299 VDD _207_.A2 a_5376_17061# VDD sg13_lv_pmos ad=0.2891p pd=1.695u as=0.1596p ps=1.22u w=0.84u l=0.13u
X300 a_11590_16759# _241_.Y GND.t514 GND.t19 sg13_lv_nmos ad=37.8f pd=0.6u as=0.1701p ps=1.65u w=0.42u l=0.13u
X301 a_3274_5380# a_3717_5423# a_3014_5850# GND.t52 sg13_lv_nmos ad=79.8f pd=0.8u as=0.1296p ps=1.52u w=0.42u l=0.13u
X302 VDD GND.t909 VDD VDD sg13_lv_pmos ad=0.19p pd=1.38u as=0 ps=0 w=1u l=1u
X303 VDD _124_.S a_2558_15532# VDD sg13_lv_pmos ad=0.253p pd=1.53u as=0.3325p ps=1.665u w=1u l=0.13u
X304 GND.t1027 VDD GND.t1027 GND.t1030 sg13_lv_nmos ad=79.8f pd=0.8u as=0 ps=0 w=0.42u l=1u
X305 VDD _191_.Y a_6862_15532# VDD sg13_lv_pmos ad=0.3808p pd=2.92u as=0.2128p ps=1.5u w=1.12u l=0.13u
X306 a_14534_11898# a_15339_11471# a_14794_11428# VDD sg13_lv_pmos ad=0.1428p pd=1.52u as=79.8f ps=0.8u w=0.42u l=0.13u
X307 a_2436_8440# a_2410_8404# VDD VDD sg13_lv_pmos ad=0.34p pd=2.68u as=0.36237p ps=2.605u w=1u l=0.13u
X308 VDD _240_.Y a_9994_17476# VDD sg13_lv_pmos ad=0.1563p pd=1.22u as=0.147p ps=1.54u w=0.42u l=0.13u
X309 a_4890_16762# _250_.Q GND.t51 GND.t14 sg13_lv_nmos ad=88.8f pd=0.98u as=0.15245p ps=1.17u w=0.74u l=0.13u
X310 a_2232_7868# _124_.S GND.t188 GND.t203 sg13_lv_nmos ad=0.187p pd=1.78u as=0.18945p ps=1.27u w=0.55u l=0.13u
X311 GND.t1245 VDD GND.t79 GND.t1244 sg13_lv_nmos ad=0.1428p pd=1.52u as=0 ps=0 w=0.42u l=1u
X312 _134_.Y _133_.Y a_12886_13350# GND.t497 sg13_lv_nmos ad=0.2516p pd=2.16u as=0.1406p ps=1.12u w=0.74u l=0.15u
X313 _247_.CLK a_3380_13690# GND.t180 GND.t46 sg13_lv_nmos ad=0.1406p pd=1.12u as=0.1406p ps=1.12u w=0.74u l=0.13u
X314 VDD GND.t1179 VDD VDD sg13_lv_pmos ad=0.34p pd=2.68u as=0 ps=0 w=1u l=1u
X315 GND.t718 VDD GND.t718 GND.t158 sg13_lv_nmos ad=79.8f pd=0.8u as=0 ps=0 w=0.42u l=1u
X316 a_11338_16969# a_11781_16725# a_11721_17137# VDD sg13_lv_pmos ad=79.8f pd=0.8u as=63f ps=0.72u w=0.42u l=0.13u
X317 a_12778_15964# a_13221_16007# a_12518_16434# GND.t580 sg13_lv_nmos ad=79.8f pd=0.8u as=0.1296p ps=1.52u w=0.42u l=0.13u
X318 a_8506_10318# _171_.Y _183_.Y GND.t88 sg13_lv_nmos ad=0.1406p pd=1.12u as=0.2516p ps=2.16u w=0.74u l=0.13u
X319 GND.t249 a_12549_12189# a_12651_12332# GND.t248 sg13_lv_nmos ad=3.6571p pd=23.85u as=0.2516p ps=2.16u w=0.74u l=0.13u
X320 GND.t1333 VDD GND.t1332 GND.t1331 sg13_lv_nmos ad=0.1428p pd=1.52u as=0 ps=0 w=0.42u l=1u
X321 a_15141_5423# _251_.CLK VDD VDD sg13_lv_pmos ad=0.4088p pd=2.97u as=1.42082p ps=9.125u w=1.12u l=0.13u
X322 VDD _218_.Y a_2410_8404# VDD sg13_lv_pmos ad=0.1563p pd=1.22u as=0.147p ps=1.54u w=0.42u l=0.13u
X323 VDD _256_.RESET_B a_9130_12433# VDD sg13_lv_pmos ad=0.1563p pd=1.22u as=0.147p ps=1.54u w=0.42u l=0.13u
X324 _147_.A1 a_11274_4948# GND.t79 GND.t1471 sg13_lv_nmos ad=0.2516p pd=2.16u as=0.1406p ps=1.12u w=0.74u l=0.13u
X325 a_13321_7272# _160_.B GND.t264 GND.t530 sg13_lv_nmos ad=0.1216p pd=1.02u as=0.1331p ps=1.12u w=0.64u l=0.13u
X326 VDD a_16240_5654# a_16185_5535# VDD sg13_lv_pmos ad=1.48542p pd=9.54u as=93.45f ps=0.865u w=0.42u l=0.13u
X327 a_2575_5436# _125_.A1 a_2398_5782# VDD sg13_lv_pmos ad=0.2975p pd=1.595u as=0.2225p ps=1.445u w=1u l=0.13u
X328 GND.t264 _162_.B a_13073_7728# GND.t263 sg13_lv_nmos ad=0.15245p pd=1.17u as=0.17462p ps=1.185u w=0.55u l=0.13u
X329 GND.t14 a_8709_16725# a_8811_16868# GND.t93 sg13_lv_nmos ad=2.85425p pd=18.015u as=0.2516p ps=2.16u w=0.74u l=0.13u
X330 GND.t26 VDD GND.t26 GND.t685 sg13_lv_nmos ad=0.1428p pd=1.52u as=0 ps=0 w=0.42u l=1u
X331 GND.t1240 VDD GND.t1242 GND.t1241 sg13_lv_nmos ad=79.8f pd=0.8u as=0 ps=0 w=0.42u l=1u
X332 VDD GND.t1025 VDD VDD sg13_lv_pmos ad=0.19p pd=1.38u as=0 ps=0 w=1u l=1u
X333 GND.t234 a_3717_4629# a_3819_4772# GND.t350 sg13_lv_nmos ad=4.7917p pd=31.625u as=0.2516p ps=2.16u w=0.74u l=0.13u
X334 _207_.Y _207_.B1 GND.t295 GND.t14 sg13_lv_nmos ad=0.1406p pd=1.12u as=0.2516p ps=2.16u w=0.74u l=0.13u
X335 VDD GND.t20 VDD VDD sg13_lv_pmos ad=0.34p pd=2.68u as=0 ps=0 w=1u l=1u
X336 a_8709_16725# fanout7.A VDD VDD sg13_lv_pmos ad=0.4088p pd=2.97u as=1.30717p ps=8.395u w=1.12u l=0.13u
X337 a_5084_12972# _148_.B VDD VDD sg13_lv_pmos ad=0.2128p pd=1.5u as=0.2128p ps=1.5u w=1.12u l=0.13u
X338 VDD _145_.X a_13820_4948# VDD sg13_lv_pmos ad=0.2128p pd=1.5u as=0.3808p ps=2.92u w=1.12u l=0.13u
X339 _214_.A a_11946_17508# GND.t121 GND.t158 sg13_lv_nmos ad=0.2516p pd=2.16u as=0.1406p ps=1.12u w=0.74u l=0.13u
X340 GND.t272 a_3380_13690# _247_.CLK GND.t46 sg13_lv_nmos ad=0.1406p pd=1.12u as=0.1406p ps=1.12u w=0.74u l=0.13u
X341 a_4761_5535# a_3819_5423# a_4559_5773# VDD sg13_lv_pmos ad=93.45f pd=0.865u as=0.2048p ps=1.63u w=0.42u l=0.13u
X342 VDD a_10220_18222# _236_.A VDD sg13_lv_pmos ad=0.2114p pd=1.54u as=0.42p ps=2.99u w=1.12u l=0.13u
X343 a_3503_12287# a_2661_12189# a_3409_12287# GND.t294 sg13_lv_nmos ad=0.12665p pd=1.145u as=0.1428p ps=1.52u w=0.42u l=0.13u
X344 _192_.B _176_.B VDD VDD sg13_lv_pmos ad=0.2128p pd=1.5u as=0.3808p ps=2.92u w=1.12u l=0.13u
X345 GND.t37 _252_.RESET_B a_9156_4650# GND.t528 sg13_lv_nmos ad=0.1626p pd=1.415u as=60.89999f ps=0.71u w=0.42u l=0.13u
X346 a_2301_5782# _124_.S GND.t5 GND.t83 sg13_lv_nmos ad=0.13135p pd=1.095u as=0.18945p ps=1.27u w=0.74u l=0.13u
X347 a_15177_9577# a_14820_9504# VDD VDD sg13_lv_pmos ad=63f pd=0.72u as=0.1563p ps=1.22u w=0.42u l=0.13u
X348 a_12804_16000# a_12778_15964# VDD VDD sg13_lv_pmos ad=0.34p pd=2.68u as=0.36237p ps=2.605u w=1u l=0.13u
X349 VDD GND.t247 VDD VDD sg13_lv_pmos ad=0.34p pd=2.68u as=0 ps=0 w=1u l=1u
X350 VDD _174_.Y _184_.Y VDD sg13_lv_pmos ad=0.2128p pd=1.5u as=0.2128p ps=1.5u w=1.12u l=0.13u
X351 GND.t718 VDD GND.t718 GND.t712 sg13_lv_nmos ad=0.1428p pd=1.52u as=0 ps=0 w=0.42u l=1u
X352 VDD GND.t345 VDD VDD sg13_lv_pmos ad=0.19p pd=1.38u as=0 ps=0 w=1u l=1u
X353 a_16079_9263# a_15237_9165# a_14820_9504# VDD sg13_lv_pmos ad=0.2048p pd=1.63u as=0.34p ps=2.68u w=1u l=0.13u
X354 GND.t377 a_3380_13690# _247_.CLK GND.t46 sg13_lv_nmos ad=0.1406p pd=1.12u as=0.1406p ps=1.12u w=0.74u l=0.13u
X355 _173_.Y _173_.A VDD VDD sg13_lv_pmos ad=0.2128p pd=1.5u as=0.3808p ps=2.92u w=1.12u l=0.13u
X356 a_8564_5412# _138_.Y VDD VDD sg13_lv_pmos ad=0.3808p pd=2.92u as=0.2128p ps=1.5u w=1.12u l=0.13u
X357 a_3952_9406# a_3695_9263# a_4114_9186# GND.t21 sg13_lv_nmos ad=0.1428p pd=1.52u as=37.8f ps=0.6u w=0.42u l=0.13u
X358 GND.t768 a_1580_16710# _222_.A GND.t601 sg13_lv_nmos ad=0.14875p pd=1.16u as=0.2886p ps=2.26u w=0.74u l=0.13u
X359 VDD GND.t693 VDD VDD sg13_lv_pmos ad=0.34p pd=2.68u as=0 ps=0 w=1u l=1u
X360 a_10895_8436# _160_.X VDD VDD sg13_lv_pmos ad=0.2128p pd=1.5u as=0.2128p ps=1.5u w=1.12u l=0.13u
X361 a_8705_9212# _180_.X _181_.Y GND.t21 sg13_lv_nmos ad=0.1406p pd=1.12u as=0.1406p ps=1.12u w=0.74u l=0.13u
X362 a_14438_5850# _151_.X VDD VDD sg13_lv_pmos ad=79.8f pd=0.8u as=0.1428p ps=1.52u w=0.42u l=0.13u
X363 a_13787_7720# _160_.B GND.t264 GND.t531 sg13_lv_nmos ad=78.39999f pd=0.885u as=0.2272p ps=1.99u w=0.64u l=0.13u
X364 _147_.B1 a_11661_4696# GND.t79 GND.t322 sg13_lv_nmos ad=0.2516p pd=2.16u as=0.1331p ps=1.12u w=0.74u l=0.13u
X365 a_14314_15457# a_14757_15213# a_14697_15625# VDD sg13_lv_pmos ad=79.8f pd=0.8u as=63f ps=0.72u w=0.42u l=0.13u
X366 GND.t1068 VDD GND.t21 GND.t1081 sg13_lv_nmos ad=0.1428p pd=1.52u as=0 ps=0 w=0.42u l=1u
X367 a_5339_16792# _207_.A1 GND.t213 GND.t14 sg13_lv_nmos ad=78.39999f pd=0.885u as=0.2272p ps=1.99u w=0.64u l=0.13u
X368 VDD GND.t767 VDD VDD sg13_lv_pmos ad=0.19p pd=1.38u as=0 ps=0 w=1u l=1u
X369 a_12984_12952# _148_.B VDD VDD sg13_lv_pmos ad=0.2128p pd=1.5u as=0.3808p ps=2.92u w=1.12u l=0.15u
X370 GND.t253 VDD GND.t253 GND.t958 sg13_lv_nmos ad=0.1428p pd=1.52u as=0 ps=0 w=0.42u l=1u
X371 GND.t119 _243_.RESET_B a_2436_4338# GND.t422 sg13_lv_nmos ad=0.1626p pd=1.415u as=60.89999f ps=0.71u w=0.42u l=0.13u
X372 GND.t1338 VDD GND.t1337 GND.t1336 sg13_lv_nmos ad=0.1428p pd=1.52u as=0 ps=0 w=0.42u l=1u
X373 VDD GND.t726 VDD VDD sg13_lv_pmos ad=0.19p pd=1.38u as=0 ps=0 w=1u l=1u
X374 a_1580_12936# fanout8.A GND.t359 GND.t358 sg13_lv_nmos ad=0.187p pd=1.78u as=0.14875p ps=1.16u w=0.55u l=0.13u
X375 GND.t937 VDD GND.t63 GND.t62 sg13_lv_nmos ad=0.1428p pd=1.52u as=0 ps=0 w=0.42u l=1u
X376 _133_.Y _132_.Y GND.t106 GND.t164 sg13_lv_nmos ad=0.2618p pd=2.22u as=0.1463p ps=1.15u w=0.77u l=0.13u
X377 a_2232_11722# _124_.S VDD VDD sg13_lv_pmos ad=0.2856p pd=2.36u as=0.253p ps=1.53u w=0.84u l=0.13u
X378 a_13649_4704# _145_.X GND.t333 GND.t334 sg13_lv_nmos ad=0.17462p pd=1.185u as=0.374p ps=2.46u w=0.55u l=0.13u
X379 a_3956_6888# clkbuf_1_0__f_sclk.A GND.t279 GND.t283 sg13_lv_nmos ad=0.1406p pd=1.12u as=0.1406p ps=1.12u w=0.74u l=0.13u
X380 GND.t157 a_10437_17519# a_10539_17519# GND.t156 sg13_lv_nmos ad=13.15737p pd=85.385u as=0.2516p ps=2.16u w=0.74u l=0.13u
X381 GND.t234 a_9765_4629# a_9867_4772# GND.t1469 sg13_lv_nmos ad=4.7917p pd=31.625u as=0.2516p ps=2.16u w=0.74u l=0.13u
X382 a_6508_15532# a_6286_15276# VDD VDD sg13_lv_pmos ad=0.1176p pd=1.33u as=0.2618p ps=1.63u w=1.12u l=0.13u
X383 VDD _221_.Y a_2122_12940# VDD sg13_lv_pmos ad=0.1563p pd=1.22u as=0.147p ps=1.54u w=0.42u l=0.13u
X384 _129_.B1 _128_.B1 a_13366_13350# GND.t1501 sg13_lv_nmos ad=0.2516p pd=2.16u as=0.1406p ps=1.12u w=0.74u l=0.15u
X385 a_9444_13735# a_9675_13844# a_9130_13945# GND.t174 sg13_lv_nmos ad=0.2373p pd=1.97u as=79.8f ps=0.8u w=0.42u l=0.13u
X386 a_9382_13735# _230_.Y GND.t321 GND.t392 sg13_lv_nmos ad=37.8f pd=0.6u as=0.1701p ps=1.65u w=0.42u l=0.13u
X387 _242_.D a_2398_5782# VDD VDD sg13_lv_pmos ad=0.6048p pd=3.32u as=0.2198p ps=1.52u w=1.12u l=0.13u
X388 a_12549_7996# _161_.Y VDD VDD sg13_lv_pmos ad=0.34p pd=2.68u as=0.19p ps=1.38u w=1u l=0.13u
X389 a_7251_15996# _201_.Y VDD VDD sg13_lv_pmos ad=0.1428p pd=1.375u as=0.2891p ps=1.695u w=1.12u l=0.13u
X390 VDD GND.t121 VDD VDD sg13_lv_pmos ad=0.34p pd=2.68u as=0 ps=0 w=1u l=1u
X391 VDD a_3956_6888# _243_.CLK VDD sg13_lv_pmos ad=0.2128p pd=1.5u as=0.2128p ps=1.5u w=1.12u l=0.13u
X392 GND.t867 VDD GND.t270 GND.t868 sg13_lv_nmos ad=79.8f pd=0.8u as=0 ps=0 w=0.42u l=1u
X393 VDD _153_.Y _161_.Y VDD sg13_lv_pmos ad=0.3808p pd=2.92u as=0.2128p ps=1.5u w=1.12u l=0.13u
X394 a_6491_8784# _168_.A GND.t634 GND.t21 sg13_lv_nmos ad=78.39999f pd=0.885u as=0.2272p ps=1.99u w=0.64u l=0.13u
X395 a_5178_13330# _119_.A0 GND.t1421 GND.t46 sg13_lv_nmos ad=88.8f pd=0.98u as=0.15245p ps=1.17u w=0.74u l=0.13u
X396 a_13244_7972# _162_.B VDD VDD sg13_lv_pmos ad=0.2128p pd=1.5u as=0.2128p ps=1.5u w=1.12u l=0.13u
X397 a_7727_4727# a_6885_4629# a_7633_4727# GND.t1562 sg13_lv_nmos ad=0.12665p pd=1.145u as=0.1428p ps=1.52u w=0.42u l=0.13u
X398 VDD a_3503_12287# a_3760_12430# VDD sg13_lv_pmos ad=1.42082p pd=9.125u as=79.8f ps=0.8u w=0.42u l=0.13u
X399 a_3717_5423# _243_.CLK VDD VDD sg13_lv_pmos ad=0.4088p pd=2.97u as=1.42082p ps=9.125u w=1.12u l=0.13u
X400 a_9130_13945# a_9573_13701# a_9513_14113# VDD sg13_lv_pmos ad=79.8f pd=0.8u as=63f ps=0.72u w=0.42u l=0.13u
X401 GND.t441 VDD GND.t897 GND.t896 sg13_lv_nmos ad=79.8f pd=0.8u as=0 ps=0 w=0.42u l=1u
X402 _243_.CLK a_3956_6888# VDD VDD sg13_lv_pmos ad=0.2128p pd=1.5u as=0.2128p ps=1.5u w=1.12u l=0.13u
X403 GND.t876 VDD GND.t247 GND.t877 sg13_lv_nmos ad=79.8f pd=0.8u as=0 ps=0 w=0.42u l=1u
X404 VDD _124_.S a_2171_6204# VDD sg13_lv_pmos ad=0.253p pd=1.53u as=0.2856p ps=2.36u w=0.84u l=0.13u
X405 _182_.Y _181_.Y a_8595_10996# VDD sg13_lv_pmos ad=0.2408p pd=1.55u as=0.1428p ps=1.375u w=1.12u l=0.13u
X406 VDD GND.t904 VDD VDD sg13_lv_pmos ad=0.34p pd=2.68u as=0 ps=0 w=1u l=1u
X407 a_10020_9504# a_9994_9409# GND.t170 GND.t21 sg13_lv_nmos ad=0.2516p pd=2.16u as=0.1626p ps=1.415u w=0.74u l=0.13u
X408 GND.t519 VDD GND.t1108 GND.t1145 sg13_lv_nmos ad=0.1428p pd=1.52u as=0 ps=0 w=0.42u l=1u
X409 GND.t221 VDD GND.t221 GND.t847 sg13_lv_nmos ad=0.1428p pd=1.52u as=0 ps=0 w=0.42u l=1u
X410 VDD GND.t100 VDD VDD sg13_lv_pmos ad=0.19p pd=1.38u as=0 ps=0 w=1u l=1u
X411 VDD _210_.A a_6060_4166# VDD sg13_lv_pmos ad=0.4536p pd=2.76u as=0.1596p ps=1.22u w=0.84u l=0.13u
X412 VDD _124_.S a_2558_9972# VDD sg13_lv_pmos ad=0.253p pd=1.53u as=0.3325p ps=1.665u w=1u l=0.13u
X413 GND.t1006 VDD GND.t1000 GND.t1041 sg13_lv_nmos ad=0.1428p pd=1.52u as=0 ps=0 w=0.42u l=1u
X414 _119_.A0 a_4074_12972# GND.t180 GND.t46 sg13_lv_nmos ad=0.2516p pd=2.16u as=0.1406p ps=1.12u w=0.74u l=0.13u
X415 VDD a_10672_12430# a_10617_12525# VDD sg13_lv_pmos ad=1.42082p pd=9.125u as=93.45f ps=0.865u w=0.42u l=0.13u
X416 VDD GND.t359 VDD VDD sg13_lv_pmos ad=0.34p pd=2.68u as=0 ps=0 w=1u l=1u
X417 VDD a_3956_6888# _243_.CLK VDD sg13_lv_pmos ad=0.2128p pd=1.5u as=0.2128p ps=1.5u w=1.12u l=0.13u
X418 _178_.Y _173_.Y a_6483_9212# GND.t21 sg13_lv_nmos ad=0.1406p pd=1.12u as=0.1406p ps=1.12u w=0.74u l=0.13u
X419 VDD _120_.A0 a_5468_12508# VDD sg13_lv_pmos ad=0.2128p pd=1.5u as=0.3808p ps=2.92u w=1.12u l=0.13u
X420 a_7727_4727# a_6885_4629# a_6468_4968# VDD sg13_lv_pmos ad=0.2048p pd=1.63u as=0.34p ps=2.68u w=1u l=0.13u
X421 VDD GND.t718 VDD VDD sg13_lv_pmos ad=0.19p pd=1.38u as=0 ps=0 w=1u l=1u
X422 a_15012_12223# a_14724_12528# a_14950_12223# GND.t8 sg13_lv_nmos ad=0.1428p pd=1.52u as=37.8f ps=0.6u w=0.42u l=0.13u
X423 VDD GND.t131 VDD VDD sg13_lv_pmos ad=0.19p pd=1.38u as=0 ps=0 w=1u l=1u
X424 VDD GND.t949 VDD VDD sg13_lv_pmos ad=0.34p pd=2.68u as=0 ps=0 w=1u l=1u
X425 a_13883_11460# _126_.B1 VDD VDD sg13_lv_pmos ad=0.3808p pd=2.92u as=0.2128p ps=1.5u w=1.12u l=0.13u
X426 GND.t37 _145_.B1 a_8557_4248# GND.t36 sg13_lv_nmos ad=0.3811p pd=2.51u as=0.1406p ps=1.12u w=0.74u l=0.13u
X427 VDD GND.t337 VDD VDD sg13_lv_pmos ad=0.34p pd=2.68u as=0 ps=0 w=1u l=1u
X428 a_12358_12223# _261_.RESET_B GND.t146 GND.t145 sg13_lv_nmos ad=37.8f pd=0.6u as=0.1701p ps=1.65u w=0.42u l=0.13u
X429 GND.t188 _124_.S a_2620_7678# GND.t187 sg13_lv_nmos ad=0.18945p pd=1.27u as=0.13135p ps=1.095u w=0.74u l=0.13u
X430 a_9734_9186# a_10539_9308# a_9994_9409# VDD sg13_lv_pmos ad=0.1428p pd=1.52u as=79.8f ps=0.8u w=0.42u l=0.13u
X431 VDD _236_.Y a_14534_11898# VDD sg13_lv_pmos ad=0.36237p pd=2.605u as=79.8f ps=0.8u w=0.42u l=0.13u
X432 VDD GND.t1202 VDD VDD sg13_lv_pmos ad=0.19p pd=1.38u as=0 ps=0 w=1u l=1u
X433 _164_.B1 a_12215_7664# VDD VDD sg13_lv_pmos ad=0.2128p pd=1.5u as=0.3808p ps=2.92u w=1.12u l=0.13u
X434 VDD _189_.X a_6048_13011# VDD sg13_lv_pmos ad=0.2891p pd=1.695u as=0.1596p ps=1.22u w=0.84u l=0.13u
X435 VDD GND.t803 VDD VDD sg13_lv_pmos ad=0.34p pd=2.68u as=0 ps=0 w=1u l=1u
X436 a_4755_17508# _118_.A0 VDD VDD sg13_lv_pmos ad=0.1428p pd=1.375u as=0.2891p ps=1.695u w=1.12u l=0.13u
X437 GND.t169 _160_.X a_12110_8784# GND.t340 sg13_lv_nmos ad=0.2176p pd=1.96u as=81.6f ps=0.895u w=0.64u l=0.13u
X438 GND.t697 VDD GND.t697 GND.t696 sg13_lv_nmos ad=0.1428p pd=1.52u as=0 ps=0 w=0.42u l=1u
X439 GND.t108 _131_.A2 a_13366_13350# GND.t107 sg13_lv_nmos ad=0.1406p pd=1.12u as=0.2516p ps=2.16u w=0.74u l=0.15u
X440 a_15012_5837# a_15243_5423# a_14698_5380# GND.t621 sg13_lv_nmos ad=0.2373p pd=1.97u as=79.8f ps=0.8u w=0.42u l=0.13u
X441 GND.t569 a_3956_6888# _243_.CLK GND.t571 sg13_lv_nmos ad=0.1406p pd=1.12u as=0.1406p ps=1.12u w=0.74u l=0.13u
X442 GND.t55 _236_.Y a_14628_11898# GND.t364 sg13_lv_nmos ad=0.1626p pd=1.415u as=60.89999f ps=0.71u w=0.42u l=0.13u
X443 VDD _145_.X a_13403_8436# VDD sg13_lv_pmos ad=0.2128p pd=1.5u as=0.2128p ps=1.5u w=1.12u l=0.13u
X444 GND.t901 VDD GND.t901 GND.t934 sg13_lv_nmos ad=79.8f pd=0.8u as=0 ps=0 w=0.42u l=1u
X445 VDD _215_.A _221_.Y VDD sg13_lv_pmos ad=0.3808p pd=2.92u as=0.3808p ps=2.92u w=1.12u l=0.13u
X446 a_2298_11830# a_2232_11722# GND.t122 GND.t189 sg13_lv_nmos ad=0.3367p pd=1.65u as=0.148p ps=1.14u w=0.74u l=0.13u
X447 GND.t718 VDD GND.t718 GND.t158 sg13_lv_nmos ad=0.1428p pd=1.52u as=0 ps=0 w=0.42u l=1u
X448 GND.t495 VDD GND.t819 GND.t818 sg13_lv_nmos ad=0.1428p pd=1.52u as=0 ps=0 w=0.42u l=1u
X449 a_3014_5850# _244_.D VDD VDD sg13_lv_pmos ad=79.8f pd=0.8u as=0.1428p ps=1.52u w=0.42u l=0.13u
X450 VDD a_3695_9263# a_4362_9484# VDD sg13_lv_pmos ad=0.2128p pd=1.5u as=0.3864p ps=2.93u w=1.12u l=0.13u
X451 VDD GND.t136 VDD VDD sg13_lv_pmos ad=0.19p pd=1.38u as=0 ps=0 w=1u l=1u
X452 a_14698_5380# a_15141_5423# a_15081_5459# VDD sg13_lv_pmos ad=79.8f pd=0.8u as=63f ps=0.72u w=0.42u l=0.13u
X453 a_7451_14484# _191_.Y _202_.Y VDD sg13_lv_pmos ad=0.2128p pd=1.5u as=0.3808p ps=2.92u w=1.12u l=0.13u
X454 GND.t171 _225_.A.t4 _228_.Y GND.t1080 sg13_lv_nmos ad=0.2516p pd=2.16u as=0.2516p ps=2.16u w=0.74u l=0.13u
X455 _143_.A _210_.A VDD VDD sg13_lv_pmos ad=0.2128p pd=1.5u as=0.2198p ps=1.53u w=1.12u l=0.13u
X456 GND.t718 VDD GND.t718 GND.t712 sg13_lv_nmos ad=0.1428p pd=1.52u as=0 ps=0 w=0.42u l=1u
X457 VDD GND.t1025 VDD VDD sg13_lv_pmos ad=0.34p pd=2.68u as=0 ps=0 w=1u l=1u
X458 a_9167_16357# a_8325_16007# a_7908_16000# VDD sg13_lv_pmos ad=0.2048p pd=1.63u as=0.34p ps=2.68u w=1u l=0.13u
X459 a_2244_12528# a_2763_12332# a_3503_12287# GND.t1439 sg13_lv_nmos ad=0.3473p pd=2.71u as=0.12665p ps=1.145u w=0.74u l=0.13u
X460 a_9765_4629# _251_.CLK VDD VDD sg13_lv_pmos ad=0.4088p pd=2.97u as=1.42082p ps=9.125u w=1.12u l=0.13u
X461 VDD a_7984_4870# a_7929_4965# VDD sg13_lv_pmos ad=1.48542p pd=9.54u as=93.45f ps=0.865u w=0.42u l=0.13u
X462 a_10938_5412# _139_.X _144_.B VDD sg13_lv_pmos ad=0.1428p pd=1.375u as=0.2408p ps=1.55u w=1.12u l=0.13u
X463 _184_.Y _173_.Y a_7064_9194# GND.t21 sg13_lv_nmos ad=0.2516p pd=2.16u as=0.1406p ps=1.12u w=0.74u l=0.13u
X464 VDD _241_.Y a_11338_16969# VDD sg13_lv_pmos ad=0.1563p pd=1.22u as=0.147p ps=1.54u w=0.42u l=0.13u
X465 GND.t770 VDD GND.t764 GND.t14 sg13_lv_nmos ad=79.8f pd=0.8u as=0 ps=0 w=0.42u l=1u
X466 a_15108_11885# a_14820_11464# a_15046_11885# GND.t134 sg13_lv_nmos ad=0.1428p pd=1.52u as=37.8f ps=0.6u w=0.42u l=0.13u
X467 VDD GND.t121 VDD VDD sg13_lv_pmos ad=0.19p pd=1.38u as=0 ps=0 w=1u l=1u
X468 GND.t726 VDD GND.t726 GND.t712 sg13_lv_nmos ad=0.1428p pd=1.52u as=0 ps=0 w=0.42u l=1u
X469 VDD GND.t697 VDD VDD sg13_lv_pmos ad=0.19p pd=1.38u as=0 ps=0 w=1u l=1u
X470 VDD GND.t794 VDD VDD sg13_lv_pmos ad=0.34p pd=2.68u as=0 ps=0 w=1u l=1u
X471 GND.t65 _210_.A a_6516_4248# GND.t87 sg13_lv_nmos ad=0.2272p pd=1.99u as=78.39999f ps=0.885u w=0.64u l=0.13u
X472 VDD GND.t703 VDD VDD sg13_lv_pmos ad=0.19p pd=1.38u as=0 ps=0 w=1u l=1u
X473 GND.t1152 VDD GND.t1152 GND.t1153 sg13_lv_nmos ad=79.8f pd=0.8u as=0 ps=0 w=0.42u l=1u
X474 GND.t519 VDD GND.t519 GND.t1110 sg13_lv_nmos ad=0.1428p pd=1.52u as=0 ps=0 w=0.42u l=1u
X475 a_9156_12528# a_9130_12433# GND.t404 GND.t437 sg13_lv_nmos ad=0.2516p pd=2.16u as=0.1626p ps=1.415u w=0.74u l=0.13u
X476 VDD GND.t181 VDD VDD sg13_lv_pmos ad=0.19p pd=1.38u as=0 ps=0 w=1u l=1u
X477 a_2410_8404# a_2853_8447# a_2150_8874# GND.t435 sg13_lv_nmos ad=79.8f pd=0.8u as=0.1296p ps=1.52u w=0.42u l=0.13u
X478 GND.t788 VDD GND.t790 GND.t789 sg13_lv_nmos ad=79.8f pd=0.8u as=0 ps=0 w=0.42u l=1u
X479 a_14628_15247# a_14859_15356# a_14314_15457# GND.t60 sg13_lv_nmos ad=0.2373p pd=1.97u as=79.8f ps=0.8u w=0.42u l=0.13u
X480 _247_.CLK a_3380_13690# VDD VDD sg13_lv_pmos ad=0.2128p pd=1.5u as=0.2128p ps=1.5u w=1.12u l=0.13u
X481 VDD _261_.RESET_B a_12106_12433# VDD sg13_lv_pmos ad=0.1563p pd=1.22u as=0.147p ps=1.54u w=0.42u l=0.13u
X482 VDD a_3664_16238# a_3609_16119# VDD sg13_lv_pmos ad=1.6291p pd=10.53u as=93.45f ps=0.865u w=0.42u l=0.13u
X483 a_3274_4873# a_3717_4629# a_3657_5041# VDD sg13_lv_pmos ad=79.8f pd=0.8u as=63f ps=0.72u w=0.42u l=0.13u
X484 VDD _178_.B1 a_6124_9945# VDD sg13_lv_pmos ad=0.36195p pd=1.84u as=0.1596p ps=1.22u w=0.84u l=0.13u
X485 VDD GND.t800 VDD VDD sg13_lv_pmos ad=0.34p pd=2.68u as=0 ps=0 w=1u l=1u
X486 a_3664_13214# _221_.Y VDD VDD sg13_lv_pmos ad=79.8f pd=0.8u as=1.42082p ps=9.125u w=0.42u l=0.13u
X487 _148_.X _148_.B a_12666_4666# GND.t1547 sg13_lv_nmos ad=0.1628p pd=1.18u as=88.8f ps=0.98u w=0.74u l=0.13u
X488 VDD GND.t65 VDD VDD sg13_lv_pmos ad=0.34p pd=2.68u as=0 ps=0 w=1u l=1u
X489 VDD GND.t100 VDD VDD sg13_lv_pmos ad=0.19p pd=1.38u as=0 ps=0 w=1u l=1u
X490 _235_.Y _236_.A GND.t55 GND.t669 sg13_lv_nmos ad=0.2516p pd=2.16u as=0.2516p ps=2.16u w=0.74u l=0.13u
X491 a_15599_15311# a_14757_15213# a_14340_15552# VDD sg13_lv_pmos ad=0.2048p pd=1.63u as=0.34p ps=2.68u w=1u l=0.13u
X492 GND.t171 VDD GND.t171 GND.t1080 sg13_lv_nmos ad=0.1428p pd=1.52u as=0 ps=0 w=0.42u l=1u
X493 a_6771_8436# _168_.A VDD VDD sg13_lv_pmos ad=0.1428p pd=1.375u as=0.2891p ps=1.695u w=1.12u l=0.13u
X494 a_8146_4650# _224_.Y GND.t65 GND.t426 sg13_lv_nmos ad=37.8f pd=0.6u as=79.8f ps=0.8u w=0.42u l=0.13u
X495 GND.t65 _136_.A a_6810_3863# GND.t613 sg13_lv_nmos ad=0.374p pd=2.46u as=0.17462p ps=1.185u w=0.55u l=0.13u
X496 VDD GND.t1206 VDD VDD sg13_lv_pmos ad=0.19p pd=1.38u as=0 ps=0 w=1u l=1u
X497 a_13527_11460# _263_.CLK a_13413_11460# VDD sg13_lv_pmos ad=0.2128p pd=1.5u as=0.2464p ps=1.56u w=1.12u l=0.13u
X498 VDD a_8709_16725# a_8811_16868# VDD sg13_lv_pmos ad=1.30717p pd=8.395u as=0.3864p ps=2.93u w=1.12u l=0.13u
X499 a_15767_17137# _238_.Y VDD VDD sg13_lv_pmos ad=79.8f pd=0.8u as=0.36237p ps=2.605u w=0.42u l=0.13u
X500 a_15856_15454# a_15599_15311# a_16018_15234# GND.t473 sg13_lv_nmos ad=0.1428p pd=1.52u as=37.8f ps=0.6u w=0.42u l=0.13u
X501 a_10799_5782# _147_.A1 GND.t1182 GND.t5 sg13_lv_nmos ad=0.2516p pd=2.16u as=0.1898p ps=1.36u w=0.74u l=0.13u
X502 GND.t229 _138_.Y a_8538_5375# GND.t5 sg13_lv_nmos ad=0.374p pd=2.46u as=0.17462p ps=1.185u w=0.55u l=0.13u
X503 GND.t1027 a_3886_10702# clkbuf_1_0__f_sclk.A GND.t1446 sg13_lv_nmos ad=0.1406p pd=1.12u as=0.1406p ps=1.12u w=0.74u l=0.13u
X504 GND.t1186 VDD GND.t1187 GND.t5 sg13_lv_nmos ad=79.8f pd=0.8u as=0 ps=0 w=0.42u l=1u
X505 a_8021_5782# _145_.A2 GND.t223 GND.t5 sg13_lv_nmos ad=0.1406p pd=1.12u as=0.1898p ps=1.36u w=0.74u l=0.13u
X506 GND.t812 VDD GND.t815 GND.t858 sg13_lv_nmos ad=79.8f pd=0.8u as=0 ps=0 w=0.42u l=1u
X507 a_9574_4663# _252_.RESET_B GND.t37 GND.t527 sg13_lv_nmos ad=37.8f pd=0.6u as=0.1701p ps=1.65u w=0.42u l=0.13u
X508 VDD GND.t1230 VDD VDD sg13_lv_pmos ad=0.34p pd=2.68u as=0 ps=0 w=1u l=1u
X509 GND.t182 VDD GND.t1194 GND.t5 sg13_lv_nmos ad=79.8f pd=0.8u as=0 ps=0 w=0.42u l=1u
X510 a_12572_4948# _148_.B VDD VDD sg13_lv_pmos ad=0.2128p pd=1.5u as=0.2128p ps=1.5u w=1.12u l=0.13u
X511 VDD _243_.Q a_10940_3900# VDD sg13_lv_pmos ad=0.2128p pd=1.5u as=0.3808p ps=2.92u w=1.12u l=0.13u
X512 GND.t1307 VDD GND.t1309 GND.t1308 sg13_lv_nmos ad=79.8f pd=0.8u as=0 ps=0 w=0.42u l=1u
X513 VDD GND.t625 VDD VDD sg13_lv_pmos ad=0.34p pd=2.68u as=0 ps=0 w=1u l=1u
X514 GND.t198 VDD GND.t198 GND.t1022 sg13_lv_nmos ad=79.8f pd=0.8u as=0 ps=0 w=0.42u l=1u
X515 a_16402_12210# _235_.Y GND.t9 GND.t241 sg13_lv_nmos ad=37.8f pd=0.6u as=79.8f ps=0.8u w=0.42u l=0.13u
X516 _185_.Y _178_.Y a_7157_9948# VDD sg13_lv_pmos ad=0.3808p pd=2.92u as=0.2128p ps=1.5u w=1.12u l=0.13u
X517 a_8292_17064# a_8811_16868# a_9551_16823# GND.t19 sg13_lv_nmos ad=0.3473p pd=2.71u as=0.12665p ps=1.145u w=0.74u l=0.13u
X518 VDD a_14063_16357# a_14320_16238# VDD sg13_lv_pmos ad=1.6291p pd=10.53u as=79.8f ps=0.8u w=0.42u l=0.13u
X519 a_4913_13330# _148_.B a_4881_12972# VDD sg13_lv_pmos ad=0.34p pd=2.68u as=0.1225p ps=1.245u w=1u l=0.13u
X520 a_12652_6924# _162_.B _162_.Y VDD sg13_lv_pmos ad=0.1176p pd=1.33u as=0.3808p ps=2.92u w=1.12u l=0.13u
X521 GND.t644 VDD GND.t644 GND.t1243 sg13_lv_nmos ad=0.1428p pd=1.52u as=0 ps=0 w=0.42u l=1u
X522 VDD GND.t469 VDD VDD sg13_lv_pmos ad=0.34p pd=2.68u as=0 ps=0 w=1u l=1u
X523 GND.t359 _215_.A _221_.Y GND.t358 sg13_lv_nmos ad=0.2516p pd=2.16u as=0.2516p ps=2.16u w=0.74u l=0.13u
X524 a_14534_9186# a_15339_9308# a_14794_9409# VDD sg13_lv_pmos ad=0.1428p pd=1.52u as=79.8f ps=0.8u w=0.42u l=0.13u
X525 a_2148_17064# a_2122_16969# VDD VDD sg13_lv_pmos ad=0.34p pd=2.68u as=0.36237p ps=2.605u w=1u l=0.13u
X526 a_3956_6888# clkbuf_1_0__f_sclk.A VDD VDD sg13_lv_pmos ad=0.2128p pd=1.5u as=0.2128p ps=1.5u w=1.12u l=0.13u
X527 GND.t33 _136_.A a_7985_7728# GND.t610 sg13_lv_nmos ad=0.15245p pd=1.17u as=0.17462p ps=1.185u w=0.55u l=0.13u
X528 a_2436_8440# a_2410_8404# GND.t356 GND.t393 sg13_lv_nmos ad=0.2516p pd=2.16u as=0.1626p ps=1.415u w=0.74u l=0.13u
X529 VDD a_3886_10702# clkbuf_1_0__f_sclk.A VDD sg13_lv_pmos ad=0.2128p pd=1.5u as=0.2128p ps=1.5u w=1.12u l=0.13u
X530 GND.t890 VDD GND.t108 GND.t928 sg13_lv_nmos ad=0.1428p pd=1.52u as=0 ps=0 w=0.42u l=1u
X531 GND.t1027 a_3886_10702# clkbuf_1_0__f_sclk.A GND.t1442 sg13_lv_nmos ad=0.1406p pd=1.12u as=0.1406p ps=1.12u w=0.74u l=0.13u
X532 a_4978_4650# _242_.RESET_B GND.t7 GND.t300 sg13_lv_nmos ad=37.8f pd=0.6u as=79.8f ps=0.8u w=0.42u l=0.13u
X533 VDD GND.t797 VDD VDD sg13_lv_pmos ad=0.19p pd=1.38u as=0 ps=0 w=1u l=1u
X534 GND.t59 a_14063_16357# a_14730_15996# GND.t58 sg13_lv_nmos ad=0.1406p pd=1.12u as=0.2516p ps=2.16u w=0.74u l=0.13u
X535 a_6106_13726# _189_.X GND.t447 GND.t46 sg13_lv_nmos ad=0.1406p pd=1.12u as=0.2516p ps=2.16u w=0.74u l=0.13u
X536 VDD _154_.X a_10752_7989# VDD sg13_lv_pmos ad=0.2891p pd=1.695u as=0.1596p ps=1.22u w=0.84u l=0.13u
X537 GND.t716 VDD GND.t718 GND.t158 sg13_lv_nmos ad=79.8f pd=0.8u as=0 ps=0 w=0.42u l=1u
X538 GND.t1247 _148_.B a_12401_4704# GND.t1545 sg13_lv_nmos ad=0.15245p pd=1.17u as=0.17462p ps=1.185u w=0.55u l=0.13u
X539 _174_.Y _168_.A a_6106_9190# GND.t21 sg13_lv_nmos ad=0.2516p pd=2.16u as=0.1406p ps=1.12u w=0.74u l=0.13u
X540 GND.t1006 VDD GND.t1006 GND.t1043 sg13_lv_nmos ad=0.1428p pd=1.52u as=0 ps=0 w=0.42u l=1u
X541 GND.t973 VDD GND.t131 GND.t974 sg13_lv_nmos ad=79.8f pd=0.8u as=0 ps=0 w=0.42u l=1u
X542 GND.t1294 VDD GND.t1292 GND.t1293 sg13_lv_nmos ad=79.8f pd=0.8u as=0 ps=0 w=0.42u l=1u
X543 _129_.Y _129_.B1 GND.t106 GND.t653 sg13_lv_nmos ad=0.1406p pd=1.12u as=0.2516p ps=2.16u w=0.74u l=0.13u
X544 a_2148_16000# a_2122_15964# GND.t144 GND.t143 sg13_lv_nmos ad=0.2516p pd=2.16u as=0.1626p ps=1.415u w=0.74u l=0.13u
X545 GND.t133 _124_.S a_2620_13726# GND.t199 sg13_lv_nmos ad=0.18945p pd=1.27u as=0.13135p ps=1.095u w=0.74u l=0.13u
X546 VDD a_9424_16238# a_9369_16119# VDD sg13_lv_pmos ad=1.6291p pd=10.53u as=93.45f ps=0.865u w=0.42u l=0.13u
X547 VDD a_15856_15454# a_15801_15549# VDD sg13_lv_pmos ad=1.6291p pd=10.53u as=93.45f ps=0.865u w=0.42u l=0.13u
X548 a_15177_11507# a_14820_11464# VDD VDD sg13_lv_pmos ad=63f pd=0.72u as=0.1563p ps=1.22u w=0.42u l=0.13u
X549 a_3952_8678# _218_.Y VDD VDD sg13_lv_pmos ad=79.8f pd=0.8u as=2.75005p ps=18.05u w=0.42u l=0.13u
X550 GND.t59 _238_.Y a_14666_16746# GND.t209 sg13_lv_nmos ad=79.8f pd=0.8u as=37.8f ps=0.6u w=0.42u l=0.13u
X551 VDD GND.t413 VDD VDD sg13_lv_pmos ad=0.34p pd=2.68u as=0 ps=0 w=1u l=1u
X552 GND.t1156 VDD GND.t1157 GND.t5 sg13_lv_nmos ad=79.8f pd=0.8u as=0 ps=0 w=0.42u l=1u
X553 GND.t26 VDD GND.t26 GND.t679 sg13_lv_nmos ad=0.1428p pd=1.52u as=0 ps=0 w=0.42u l=1u
X554 VDD a_3664_16966# a_3609_17061# VDD sg13_lv_pmos ad=1.30717p pd=8.395u as=93.45f ps=0.865u w=0.42u l=0.13u
X555 a_2126_7864# _122_.A0 a_2298_7678# GND.t31 sg13_lv_nmos ad=0.1628p pd=1.18u as=0.3367p ps=1.65u w=0.74u l=0.13u
X556 GND.t77 VDD GND.t77 GND.t1049 sg13_lv_nmos ad=0.1428p pd=1.52u as=0 ps=0 w=0.42u l=1u
X557 VDD a_3886_10702# clkbuf_1_0__f_sclk.A VDD sg13_lv_pmos ad=0.2128p pd=1.5u as=0.2128p ps=1.5u w=1.12u l=0.13u
X558 a_9551_16823# a_8709_16725# a_9457_16823# GND.t19 sg13_lv_nmos ad=0.12665p pd=1.145u as=0.1428p ps=1.52u w=0.42u l=0.13u
X559 VDD _136_.A a_11661_4696# VDD sg13_lv_pmos ad=0.1918p pd=1.5u as=0.1596p ps=1.22u w=0.84u l=0.13u
X560 VDD a_13100_13686# _148_.B VDD sg13_lv_pmos ad=0.2114p pd=1.54u as=0.42p ps=2.99u w=1.12u l=0.13u
X561 VDD GND.t198 VDD VDD sg13_lv_pmos ad=0.34p pd=2.68u as=0 ps=0 w=1u l=1u
X562 GND.t815 VDD GND.t815 GND.t816 sg13_lv_nmos ad=79.8f pd=0.8u as=0 ps=0 w=0.42u l=1u
X563 VDD GND.t441 VDD VDD sg13_lv_pmos ad=0.34p pd=2.68u as=0 ps=0 w=1u l=1u
X564 GND.t1025 sclk a_3886_10702# GND.t1427 sg13_lv_nmos ad=0.1406p pd=1.12u as=0.1406p ps=1.12u w=0.74u l=0.13u
X565 VDD GND.t726 VDD VDD sg13_lv_pmos ad=0.19p pd=1.38u as=0 ps=0 w=1u l=1u
X566 a_13073_5770# _157_.B a_13041_5412# VDD sg13_lv_pmos ad=0.34p pd=2.68u as=0.1225p ps=1.245u w=1u l=0.13u
X567 _235_.Y _236_.A VDD VDD sg13_lv_pmos ad=0.3808p pd=2.92u as=0.3808p ps=2.92u w=1.12u l=0.13u
X568 VDD GND.t264 VDD VDD sg13_lv_pmos ad=0.34p pd=2.68u as=0 ps=0 w=1u l=1u
X569 a_9808_16966# _259_.RESET_B VDD VDD sg13_lv_pmos ad=79.8f pd=0.8u as=1.30717p ps=8.395u w=0.42u l=0.13u
X570 a_2793_9577# a_2436_9504# VDD VDD sg13_lv_pmos ad=63f pd=0.72u as=0.1563p ps=1.22u w=0.42u l=0.13u
X571 VDD _145_.A2 a_8386_3900# VDD sg13_lv_pmos ad=0.19p pd=1.38u as=0.34p ps=2.68u w=1u l=0.13u
X572 a_10415_13799# a_9573_13701# a_10321_13799# GND.t1537 sg13_lv_nmos ad=0.12665p pd=1.145u as=0.1428p ps=1.52u w=0.42u l=0.13u
X573 GND.t697 VDD GND.t697 GND.t699 sg13_lv_nmos ad=0.1428p pd=1.52u as=0 ps=0 w=0.42u l=1u
X574 a_4144_4142# a_3887_4261# a_4306_4338# GND.t166 sg13_lv_nmos ad=0.1428p pd=1.52u as=37.8f ps=0.6u w=0.42u l=0.13u
X575 VDD GND.t809 VDD VDD sg13_lv_pmos ad=0.19p pd=1.38u as=0 ps=0 w=1u l=1u
X576 GND.t97 _192_.B a_6881_13320# GND.t46 sg13_lv_nmos ad=0.2516p pd=2.16u as=0.1406p ps=1.12u w=0.74u l=0.13u
X577 GND.t39 a_13073_5770# _151_.B GND.t5 sg13_lv_nmos ad=0.3108p pd=2.32u as=0.1628p ps=1.18u w=0.74u l=0.13u
X578 GND.t136 VDD GND.t136 GND.t1034 sg13_lv_nmos ad=79.8f pd=0.8u as=0 ps=0 w=0.42u l=1u
X579 GND.t307 VDD GND.t890 GND.t889 sg13_lv_nmos ad=79.8f pd=0.8u as=0 ps=0 w=0.42u l=1u
X580 a_2150_8874# a_2955_8447# a_2410_8404# VDD sg13_lv_pmos ad=0.1428p pd=1.52u as=79.8f ps=0.8u w=0.42u l=0.13u
X581 a_3695_9263# a_2853_9165# a_2436_9504# VDD sg13_lv_pmos ad=0.2048p pd=1.63u as=0.34p ps=2.68u w=1u l=0.13u
X582 a_14628_15247# a_14340_15552# a_14566_15247# GND.t632 sg13_lv_nmos ad=0.1428p pd=1.52u as=37.8f ps=0.6u w=0.42u l=0.13u
X583 a_6468_4968# a_6442_4873# GND.t65 GND.t149 sg13_lv_nmos ad=0.2516p pd=2.16u as=0.1626p ps=1.415u w=0.74u l=0.13u
X584 a_8156_9928# _183_.Y _186_.Y VDD sg13_lv_pmos ad=0.2128p pd=1.5u as=0.2128p ps=1.5u w=1.12u l=0.15u
X585 VDD sclk a_3886_10702# VDD sg13_lv_pmos ad=0.2128p pd=1.5u as=0.2128p ps=1.5u w=1.12u l=0.13u
X586 GND.t968 VDD GND.t967 GND.t966 sg13_lv_nmos ad=0.1428p pd=1.52u as=0 ps=0 w=0.42u l=1u
X587 a_15983_5773# a_15141_5423# a_14724_5416# VDD sg13_lv_pmos ad=0.2048p pd=1.63u as=0.34p ps=2.68u w=1u l=0.13u
X588 _210_.A a_5226_4948# VDD VDD sg13_lv_pmos ad=0.3808p pd=2.92u as=0.2128p ps=1.5u w=1.12u l=0.13u
X589 _151_.X a_13649_4704# a_13820_4948# VDD sg13_lv_pmos ad=0.3808p pd=2.92u as=0.2128p ps=1.5u w=1.12u l=0.13u
X590 GND.t1194 VDD GND.t1197 GND.t1196 sg13_lv_nmos ad=79.8f pd=0.8u as=0 ps=0 w=0.42u l=1u
X591 a_2232_13916# _124_.S GND.t133 GND.t193 sg13_lv_nmos ad=0.187p pd=1.78u as=0.18945p ps=1.27u w=0.55u l=0.13u
X592 VDD GND.t897 VDD VDD sg13_lv_pmos ad=0.34p pd=2.68u as=0 ps=0 w=1u l=1u
X593 VDD GND.t26 VDD VDD sg13_lv_pmos ad=0.19p pd=1.38u as=0 ps=0 w=1u l=1u
X594 GND.t510 VDD GND.t708 GND.t707 sg13_lv_nmos ad=0.1428p pd=1.52u as=0 ps=0 w=0.42u l=1u
X595 GND.t100 a_2126_10214# _246_.D GND.t639 sg13_lv_nmos ad=0.148p pd=1.14u as=0.4033p ps=2.57u w=0.74u l=0.13u
X596 VDD _131_.A2 a_13883_11460# VDD sg13_lv_pmos ad=0.2128p pd=1.5u as=0.2128p ps=1.5u w=1.12u l=0.13u
X597 a_7008_16035# _201_.Y VDD VDD sg13_lv_pmos ad=0.1596p pd=1.22u as=0.4536p ps=2.76u w=0.84u l=0.13u
X598 GND.t1277 VDD GND.t1279 GND.t1278 sg13_lv_nmos ad=79.8f pd=0.8u as=0 ps=0 w=0.42u l=1u
X599 GND.t697 VDD GND.t697 GND.t742 sg13_lv_nmos ad=79.8f pd=0.8u as=0 ps=0 w=0.42u l=1u
X600 a_2218_12433# a_2661_12189# a_2601_12601# VDD sg13_lv_pmos ad=79.8f pd=0.8u as=63f ps=0.72u w=0.42u l=0.13u
X601 a_14950_12223# _235_.Y GND.t55 GND.t242 sg13_lv_nmos ad=37.8f pd=0.6u as=0.1701p ps=1.65u w=0.42u l=0.13u
X602 GND.t256 VDD GND.t256 GND.t938 sg13_lv_nmos ad=0.1428p pd=1.52u as=0 ps=0 w=0.42u l=1u
X603 VDD a_3956_6888# _243_.CLK VDD sg13_lv_pmos ad=0.2128p pd=1.5u as=0.2128p ps=1.5u w=1.12u l=0.13u
X604 a_7716_16434# _258_.D a_7622_16434# GND.t14 sg13_lv_nmos ad=60.89999f pd=0.71u as=0.1428p ps=1.52u w=0.42u l=0.13u
X605 VDD _170_.B _170_.Y VDD sg13_lv_pmos ad=0.2128p pd=1.5u as=0.2128p ps=1.5u w=1.12u l=0.13u
X606 a_3897_9501# a_2955_9308# a_3695_9263# VDD sg13_lv_pmos ad=93.45f pd=0.865u as=0.2048p ps=1.63u w=0.42u l=0.13u
X607 VDD GND.t920 VDD VDD sg13_lv_pmos ad=0.19p pd=1.38u as=0 ps=0 w=1u l=1u
X608 a_7835_5760# _143_.A GND.t226 GND.t5 sg13_lv_nmos ad=78.39999f pd=0.885u as=0.2272p ps=1.99u w=0.64u l=0.13u
X609 VDD a_8352_11013# _182_.Y VDD sg13_lv_pmos ad=0.3808p pd=2.92u as=0.2408p ps=1.55u w=1.12u l=0.13u
X610 a_8580_16759# a_8292_17064# a_8518_16759# GND.t172 sg13_lv_nmos ad=0.1428p pd=1.52u as=37.8f ps=0.6u w=0.42u l=0.13u
X611 GND.t826 VDD GND.t439 GND.t827 sg13_lv_nmos ad=79.8f pd=0.8u as=0 ps=0 w=0.42u l=1u
X612 GND.t57 VDD GND.t57 GND.t1113 sg13_lv_nmos ad=79.8f pd=0.8u as=0 ps=0 w=0.42u l=1u
X613 a_2244_9186# _246_.D a_2150_9186# GND.t217 sg13_lv_nmos ad=60.89999f pd=0.71u as=0.1428p ps=1.52u w=0.42u l=0.13u
X614 GND.t1297 VDD GND.t1299 GND.t1298 sg13_lv_nmos ad=79.8f pd=0.8u as=0 ps=0 w=0.42u l=1u
X615 GND.t177 a_12880_16966# a_12529_16823# GND.t301 sg13_lv_nmos ad=79.8f pd=0.8u as=0.1428p ps=1.52u w=0.42u l=0.13u
X616 a_4684_15996# a_4462_16052# VDD VDD sg13_lv_pmos ad=0.1176p pd=1.33u as=0.2618p ps=1.63u w=1.12u l=0.13u
X617 VDD GND.t305 VDD VDD sg13_lv_pmos ad=0.19p pd=1.38u as=0 ps=0 w=1u l=1u
X618 VDD GND.t404 VDD VDD sg13_lv_pmos ad=0.19p pd=1.38u as=0 ps=0 w=1u l=1u
X619 a_11781_16725# _214_.A GND.t14 GND.t1393 sg13_lv_nmos ad=0.2516p pd=2.16u as=2.85425p ps=18.015u w=0.74u l=0.13u
X620 a_8156_7972# _136_.A VDD VDD sg13_lv_pmos ad=0.2128p pd=1.5u as=0.2128p ps=1.5u w=1.12u l=0.13u
X621 GND.t307 VDD GND.t307 GND.t924 sg13_lv_nmos ad=0.1428p pd=1.52u as=0 ps=0 w=0.42u l=1u
X622 a_6442_4873# a_6885_4629# a_6182_4650# GND.t1560 sg13_lv_nmos ad=79.8f pd=0.8u as=0.1296p ps=1.52u w=0.42u l=0.13u
X623 VDD a_15237_8447# a_15339_8447# VDD sg13_lv_pmos ad=2.75005p pd=18.05u as=0.3864p ps=2.93u w=1.12u l=0.13u
X624 GND.t797 VDD GND.t797 GND.t834 sg13_lv_nmos ad=79.8f pd=0.8u as=0 ps=0 w=0.42u l=1u
X625 VDD GND.t400 VDD VDD sg13_lv_pmos ad=0.19p pd=1.38u as=0 ps=0 w=1u l=1u
X626 VDD _124_.S a_2558_7972# VDD sg13_lv_pmos ad=0.253p pd=1.53u as=0.3325p ps=1.665u w=1u l=0.13u
X627 _260_.RESET_B _225_.A GND.t77 GND.t586 sg13_lv_nmos ad=0.2516p pd=2.16u as=0.2516p ps=2.16u w=0.74u l=0.13u
X628 a_6276_4650# _210_.Y a_6182_4650# GND.t593 sg13_lv_nmos ad=60.89999f pd=0.71u as=0.1428p ps=1.52u w=0.42u l=0.13u
X629 VDD _148_.B a_12237_5760# VDD sg13_lv_pmos ad=0.1918p pd=1.5u as=0.1596p ps=1.22u w=0.84u l=0.13u
X630 _144_.B a_10764_5678# VDD VDD sg13_lv_pmos ad=0.2408p pd=1.55u as=0.3808p ps=2.92u w=1.12u l=0.13u
X631 _247_.CLK a_3380_13690# VDD VDD sg13_lv_pmos ad=0.2128p pd=1.5u as=0.2128p ps=1.5u w=1.12u l=0.13u
X632 a_9573_13701# fanout7.A VDD VDD sg13_lv_pmos ad=0.4088p pd=2.97u as=5.15485p ps=34.14u w=1.12u l=0.13u
X633 a_2565_16007# _247_.CLK GND.t14 GND.t477 sg13_lv_nmos ad=0.2516p pd=2.16u as=2.6164p ps=16.515u w=0.74u l=0.13u
X634 GND.t136 VDD GND.t136 GND.t996 sg13_lv_nmos ad=0.1428p pd=1.52u as=0 ps=0 w=0.42u l=1u
X635 VDD GND.t1178 VDD VDD sg13_lv_pmos ad=0.34p pd=2.68u as=0 ps=0 w=1u l=1u
X636 GND.t1323 VDD GND.t1325 GND.t1324 sg13_lv_nmos ad=79.8f pd=0.8u as=0 ps=0 w=0.42u l=1u
X637 VDD GND.t264 VDD VDD sg13_lv_pmos ad=0.34p pd=2.68u as=0 ps=0 w=1u l=1u
X638 a_10020_17512# a_9994_17476# GND.t510 GND.t509 sg13_lv_nmos ad=0.2516p pd=2.16u as=0.1626p ps=1.415u w=0.74u l=0.13u
X639 _264_.Q a_14730_15996# VDD VDD sg13_lv_pmos ad=0.3808p pd=2.92u as=0.2128p ps=1.5u w=1.12u l=0.13u
X640 GND.t815 VDD GND.t668 GND.t860 sg13_lv_nmos ad=79.8f pd=0.8u as=0 ps=0 w=0.42u l=1u
X641 VDD GND.t77 VDD VDD sg13_lv_pmos ad=0.19p pd=1.38u as=0 ps=0 w=1u l=1u
X642 a_15046_11885# _236_.Y GND.t55 GND.t365 sg13_lv_nmos ad=37.8f pd=0.6u as=0.1701p ps=1.65u w=0.42u l=0.13u
X643 a_11364_17064# a_11338_16969# GND.t515 GND.t19 sg13_lv_nmos ad=0.2516p pd=2.16u as=0.1626p ps=1.415u w=0.74u l=0.13u
X644 VDD _224_.Y a_6442_4873# VDD sg13_lv_pmos ad=0.1563p pd=1.22u as=0.147p ps=1.54u w=0.42u l=0.13u
X645 VDD _235_.Y a_14698_12433# VDD sg13_lv_pmos ad=0.1563p pd=1.22u as=0.147p ps=1.54u w=0.42u l=0.13u
X646 VDD a_6885_4629# a_6987_4772# VDD sg13_lv_pmos ad=1.48542p pd=9.54u as=0.3864p ps=2.93u w=1.12u l=0.13u
X647 VDD GND.t136 VDD VDD sg13_lv_pmos ad=0.19p pd=1.38u as=0 ps=0 w=1u l=1u
X648 GND.t510 _240_.Y a_9828_17946# GND.t553 sg13_lv_nmos ad=0.1626p pd=1.415u as=60.89999f ps=0.71u w=0.42u l=0.13u
X649 a_2232_13916# _124_.S VDD VDD sg13_lv_pmos ad=0.2856p pd=2.36u as=0.253p ps=1.53u w=0.84u l=0.13u
X650 _247_.CLK a_3380_13690# GND.t369 GND.t46 sg13_lv_nmos ad=0.1406p pd=1.12u as=0.1406p ps=1.12u w=0.74u l=0.13u
X651 a_13184_7183# _160_.B VDD VDD sg13_lv_pmos ad=0.1596p pd=1.22u as=0.1918p ps=1.5u w=0.84u l=0.13u
X652 a_10020_9504# a_10539_9308# a_11279_9263# GND.t416 sg13_lv_nmos ad=0.3473p pd=2.71u as=0.12665p ps=1.145u w=0.74u l=0.13u
X653 a_10437_9165# _251_.CLK VDD VDD sg13_lv_pmos ad=0.4088p pd=2.97u as=1.94845p ps=12.685u w=1.12u l=0.13u
X654 GND.t1240 VDD GND.t37 GND.t1239 sg13_lv_nmos ad=0.1428p pd=1.52u as=0 ps=0 w=0.42u l=1u
X655 a_2620_15238# _119_.A0 a_2126_15424# GND.t1417 sg13_lv_nmos ad=0.13135p pd=1.095u as=0.1628p ps=1.18u w=0.74u l=0.13u
X656 GND.t897 VDD GND.t897 GND.t898 sg13_lv_nmos ad=0.1428p pd=1.52u as=0 ps=0 w=0.42u l=1u
X657 GND.t65 _210_.B a_6095_4270# GND.t520 sg13_lv_nmos ad=0.1898p pd=1.36u as=0.1406p ps=1.12u w=0.74u l=0.13u
X658 GND.t781 VDD GND.t780 GND.t779 sg13_lv_nmos ad=0.1428p pd=1.52u as=0 ps=0 w=0.42u l=1u
X659 GND.t85 VDD GND.t85 GND.t5 sg13_lv_nmos ad=0.1428p pd=1.52u as=0 ps=0 w=0.42u l=1u
X660 VDD GND.t345 VDD VDD sg13_lv_pmos ad=0.34p pd=2.68u as=0 ps=0 w=1u l=1u
X661 GND.t198 VDD GND.t198 GND.t988 sg13_lv_nmos ad=79.8f pd=0.8u as=0 ps=0 w=0.42u l=1u
X662 VDD a_3887_4261# a_4554_3900# VDD sg13_lv_pmos ad=0.2128p pd=1.5u as=0.3864p ps=2.93u w=1.12u l=0.13u
X663 GND.t1282 VDD GND.t1284 GND.t1283 sg13_lv_nmos ad=79.8f pd=0.8u as=0 ps=0 w=0.42u l=1u
X664 a_3407_16357# a_2565_16007# a_3313_16357# GND.t14 sg13_lv_nmos ad=0.12665p pd=1.145u as=0.1428p ps=1.52u w=0.42u l=0.13u
X665 VDD a_3380_13690# _247_.CLK VDD sg13_lv_pmos ad=0.2128p pd=1.5u as=0.2128p ps=1.5u w=1.12u l=0.13u
X666 _225_.A a_9352_17508# GND.t510 GND.t1380 sg13_lv_nmos ad=0.2886p pd=2.26u as=0.14875p ps=1.16u w=0.74u l=0.13u
X667 VDD GND.t1108 VDD VDD sg13_lv_pmos ad=0.34p pd=2.68u as=0 ps=0 w=1u l=1u
X668 GND.t413 VDD GND.t413 GND.t954 sg13_lv_nmos ad=0.1428p pd=1.52u as=0 ps=0 w=0.42u l=1u
X669 a_13130_4948# _147_.Y VDD VDD sg13_lv_pmos ad=0.1176p pd=1.33u as=0.4032p ps=2.96u w=1.12u l=0.13u
X670 GND.t671 VDD GND.t671 GND.t1014 sg13_lv_nmos ad=0.1428p pd=1.52u as=0 ps=0 w=0.42u l=1u
X671 _147_.A1 a_11274_4948# VDD VDD sg13_lv_pmos ad=0.3808p pd=2.92u as=0.2128p ps=1.5u w=1.12u l=0.13u
X672 a_2505_17137# a_2148_17064# VDD VDD sg13_lv_pmos ad=63f pd=0.72u as=0.1563p ps=1.22u w=0.42u l=0.13u
X673 GND.t1224 VDD GND.t1224 GND.t1225 sg13_lv_nmos ad=0.1428p pd=1.52u as=0 ps=0 w=0.42u l=1u
X674 GND.t726 VDD GND.t726 GND.t158 sg13_lv_nmos ad=79.8f pd=0.8u as=0 ps=0 w=0.42u l=1u
X675 GND.t26 VDD GND.t26 GND.t681 sg13_lv_nmos ad=0.1428p pd=1.52u as=0 ps=0 w=0.42u l=1u
X676 VDD GND.t1194 VDD VDD sg13_lv_pmos ad=0.34p pd=2.68u as=0 ps=0 w=1u l=1u
X677 VDD a_3380_13690# _247_.CLK VDD sg13_lv_pmos ad=0.2128p pd=1.5u as=0.2128p ps=1.5u w=1.12u l=0.13u
X678 VDD GND.t1006 VDD VDD sg13_lv_pmos ad=0.19p pd=1.38u as=0 ps=0 w=1u l=1u
X679 GND.t152 _148_.B a_8488_8436# GND.t21 sg13_lv_nmos ad=0.14875p pd=1.16u as=0.187p ps=1.78u w=0.55u l=0.13u
X680 GND.t108 _148_.B a_12886_13350# GND.t1542 sg13_lv_nmos ad=0.1406p pd=1.12u as=0.2516p ps=2.16u w=0.74u l=0.15u
X681 _126_.Y _126_.B1 GND.t106 GND.t444 sg13_lv_nmos ad=0.1406p pd=1.12u as=0.2516p ps=2.16u w=0.74u l=0.13u
X682 GND.t121 VDD GND.t121 GND.t711 sg13_lv_nmos ad=79.8f pd=0.8u as=0 ps=0 w=0.42u l=1u
X683 GND.t689 VDD GND.t687 GND.t688 sg13_lv_nmos ad=0.1428p pd=1.52u as=0 ps=0 w=0.42u l=1u
X684 a_2126_10214# _173_.A a_2298_10318# GND.t1412 sg13_lv_nmos ad=0.1628p pd=1.18u as=0.3367p ps=1.65u w=0.74u l=0.13u
X685 a_13810_12210# _261_.RESET_B GND.t106 GND.t147 sg13_lv_nmos ad=37.8f pd=0.6u as=79.8f ps=0.8u w=0.42u l=0.13u
X686 VDD _138_.Y a_8990_5412# VDD sg13_lv_pmos ad=0.36p pd=2.72u as=0.1225p ps=1.245u w=1u l=0.13u
X687 a_6963_17044# _205_.Y VDD VDD sg13_lv_pmos ad=0.1428p pd=1.375u as=0.2891p ps=1.695u w=1.12u l=0.13u
X688 _145_.B1 _138_.Y GND.t37 GND.t227 sg13_lv_nmos ad=0.1406p pd=1.12u as=0.2516p ps=2.16u w=0.74u l=0.13u
X689 a_9120_9501# _164_.Y VDD VDD sg13_lv_pmos ad=0.1596p pd=1.22u as=0.4536p ps=2.76u w=0.84u l=0.13u
X690 GND.t1159 VDD GND.t1158 GND.t5 sg13_lv_nmos ad=0.1428p pd=1.52u as=0 ps=0 w=0.42u l=1u
X691 GND.t47 clkbuf_1_0__f_sclk.A a_3380_13690# GND.t46 sg13_lv_nmos ad=0.1406p pd=1.12u as=0.1406p ps=1.12u w=0.74u l=0.13u
X692 a_2298_11484# a_2232_11722# VDD VDD sg13_lv_pmos ad=0.2975p pd=1.595u as=0.2198p ps=1.52u w=1u l=0.13u
X693 VDD a_6528_8475# _168_.Y VDD sg13_lv_pmos ad=0.3808p pd=2.92u as=0.2408p ps=1.55u w=1.12u l=0.13u
X694 a_7739_9484# _168_.Y _171_.A VDD sg13_lv_pmos ad=0.2128p pd=1.5u as=0.3808p ps=2.92u w=1.12u l=0.13u
X695 a_14940_16710# a_15071_17016# a_14359_16710# VDD sg13_lv_pmos ad=0.34p pd=2.68u as=0.2048p ps=1.63u w=1u l=0.13u
X696 _238_.Y _225_.A GND.t59 GND.t58 sg13_lv_nmos ad=0.2516p pd=2.16u as=0.2516p ps=2.16u w=0.74u l=0.13u
X697 a_9156_14040# a_9675_13844# a_10415_13799# GND.t175 sg13_lv_nmos ad=0.3473p pd=2.71u as=0.12665p ps=1.145u w=0.74u l=0.13u
X698 VDD GND.t901 VDD VDD sg13_lv_pmos ad=0.19p pd=1.38u as=0 ps=0 w=1u l=1u
X699 a_14820_11464# a_14794_11428# VDD VDD sg13_lv_pmos ad=0.34p pd=2.68u as=0.36237p ps=2.605u w=1u l=0.13u
X700 VDD GND.t404 VDD VDD sg13_lv_pmos ad=0.34p pd=2.68u as=0 ps=0 w=1u l=1u
X701 GND.t5 _244_.RESET_B a_3108_5850# GND.t1464 sg13_lv_nmos ad=0.1626p pd=1.415u as=60.89999f ps=0.71u w=0.42u l=0.13u
X702 VDD _187_.Y a_6779_12972# VDD sg13_lv_pmos ad=0.2128p pd=1.5u as=0.2128p ps=1.5u w=1.12u l=0.13u
X703 a_14240_16921# a_14359_16710# GND.t59 GND.t209 sg13_lv_nmos ad=0.2516p pd=2.16u as=0.1406p ps=1.12u w=0.74u l=0.13u
X704 GND.t697 VDD GND.t701 GND.t744 sg13_lv_nmos ad=79.8f pd=0.8u as=0 ps=0 w=0.42u l=1u
X705 a_3664_16238# a_3407_16357# a_3826_16434# GND.t14 sg13_lv_nmos ad=0.1428p pd=1.52u as=37.8f ps=0.6u w=0.42u l=0.13u
X706 a_9167_16357# a_8325_16007# a_9073_16357# GND.t29 sg13_lv_nmos ad=0.12665p pd=1.145u as=0.1428p ps=1.52u w=0.42u l=0.13u
X707 a_2470_12223# _220_.Y GND.t122 GND.t62 sg13_lv_nmos ad=37.8f pd=0.6u as=0.1701p ps=1.65u w=0.42u l=0.13u
X708 a_10864_4870# a_10607_4727# a_11026_4650# GND.t1575 sg13_lv_nmos ad=0.1428p pd=1.52u as=37.8f ps=0.6u w=0.42u l=0.13u
X709 GND.t519 a_15980_7638# _251_.CLK GND.t518 sg13_lv_nmos ad=0.14875p pd=1.16u as=0.2886p ps=2.26u w=0.74u l=0.13u
X710 VDD a_11536_17750# a_11481_17631# VDD sg13_lv_pmos ad=1.30717p pd=8.395u as=93.45f ps=0.865u w=0.42u l=0.13u
X711 VDD a_11279_17869# a_11946_17508# VDD sg13_lv_pmos ad=0.2128p pd=1.5u as=0.3864p ps=2.93u w=1.12u l=0.13u
X712 a_3407_16823# a_2565_16725# a_3313_16823# GND.t14 sg13_lv_nmos ad=0.12665p pd=1.145u as=0.1428p ps=1.52u w=0.42u l=0.13u
X713 a_9424_16238# _258_.RESET_B VDD VDD sg13_lv_pmos ad=79.8f pd=0.8u as=1.6291p ps=10.53u w=0.42u l=0.13u
X714 GND.t1368 VDD GND.t1370 GND.t1369 sg13_lv_nmos ad=79.8f pd=0.8u as=0 ps=0 w=0.42u l=1u
X715 VDD GND.t967 VDD VDD sg13_lv_pmos ad=0.34p pd=2.68u as=0 ps=0 w=1u l=1u
X716 VDD GND.t1269 VDD VDD sg13_lv_pmos ad=0.19p pd=1.38u as=0 ps=0 w=1u l=1u
X717 VDD GND.t671 VDD VDD sg13_lv_pmos ad=0.19p pd=1.38u as=0 ps=0 w=1u l=1u
X718 VDD GND.t693 VDD VDD sg13_lv_pmos ad=0.19p pd=1.38u as=0 ps=0 w=1u l=1u
X719 a_16079_11821# a_15237_11471# a_14820_11464# VDD sg13_lv_pmos ad=0.2048p pd=1.63u as=0.34p ps=2.68u w=1u l=0.13u
X720 GND.t307 a_10415_13799# a_11082_14020# GND.t1384 sg13_lv_nmos ad=0.1406p pd=1.12u as=0.2516p ps=2.16u w=0.74u l=0.13u
X721 a_12880_16966# _241_.Y VDD VDD sg13_lv_pmos ad=79.8f pd=0.8u as=1.30717p ps=8.395u w=0.42u l=0.13u
X722 GND.t1 a_4144_4142# a_3793_4261# GND.t0 sg13_lv_nmos ad=79.8f pd=0.8u as=0.1428p ps=1.52u w=0.42u l=0.13u
X723 a_15963_17137# a_15071_17016# a_15861_16904# VDD sg13_lv_pmos ad=63f pd=0.72u as=79.8f ps=0.8u w=0.42u l=0.13u
X724 GND.t1287 VDD GND.t1289 GND.t1288 sg13_lv_nmos ad=79.8f pd=0.8u as=0 ps=0 w=0.42u l=1u
X725 GND.t625 a_7985_13776# _194_.X GND.t46 sg13_lv_nmos ad=0.3108p pd=2.32u as=0.1628p ps=1.18u w=0.74u l=0.13u
X726 a_2436_9504# a_2410_9409# GND.t356 GND.t393 sg13_lv_nmos ad=0.2516p pd=2.16u as=0.1626p ps=1.415u w=0.74u l=0.13u
X727 VDD GND.t1010 VDD VDD sg13_lv_pmos ad=0.19p pd=1.38u as=0 ps=0 w=1u l=1u
X728 VDD _260_.CLK a_12923_11460# VDD sg13_lv_pmos ad=0.2128p pd=1.5u as=0.2128p ps=1.5u w=1.12u l=0.13u
X729 VDD GND.t1149 VDD VDD sg13_lv_pmos ad=0.34p pd=2.68u as=0 ps=0 w=1u l=1u
X730 a_14820_9504# a_15339_9308# a_16079_9263# GND.t72 sg13_lv_nmos ad=0.3473p pd=2.71u as=0.12665p ps=1.145u w=0.74u l=0.13u
X731 GND.t918 VDD GND.t917 GND.t916 sg13_lv_nmos ad=0.1428p pd=1.52u as=0 ps=0 w=0.42u l=1u
X732 a_14438_12210# _129_.Y VDD VDD sg13_lv_pmos ad=79.8f pd=0.8u as=0.1428p ps=1.52u w=0.42u l=0.13u
X733 GND.t448 _190_.A a_6197_13342# GND.t46 sg13_lv_nmos ad=0.1898p pd=1.36u as=0.2516p ps=2.16u w=0.74u l=0.13u
X734 a_13973_7678# _158_.Y GND.t264 GND.t659 sg13_lv_nmos ad=0.1406p pd=1.12u as=0.1898p ps=1.36u w=0.74u l=0.13u
X735 a_11381_3900# _147_.A1 VDD VDD sg13_lv_pmos ad=0.2128p pd=1.5u as=0.2128p ps=1.5u w=1.12u l=0.13u
X736 GND.t345 VDD GND.t345 GND.t1098 sg13_lv_nmos ad=0.1428p pd=1.52u as=0 ps=0 w=0.42u l=1u
X737 a_11279_17869# a_10437_17519# a_11185_17869# GND.t158 sg13_lv_nmos ad=0.12665p pd=1.145u as=0.1428p ps=1.52u w=0.42u l=0.13u
X738 a_2122_15964# a_2565_16007# a_2505_16043# VDD sg13_lv_pmos ad=79.8f pd=0.8u as=63f ps=0.72u w=0.42u l=0.13u
X739 VDD GND.t310 VDD VDD sg13_lv_pmos ad=0.19p pd=1.38u as=0 ps=0 w=1u l=1u
X740 GND.t1272 VDD GND.t1274 GND.t1273 sg13_lv_nmos ad=79.8f pd=0.8u as=0 ps=0 w=0.42u l=1u
X741 VDD GND.t1181 VDD VDD sg13_lv_pmos ad=0.19p pd=1.38u as=0 ps=0 w=1u l=1u
X742 GND.t303 a_16336_8678# a_15985_8797# GND.t72 sg13_lv_nmos ad=79.8f pd=0.8u as=0.1428p ps=1.52u w=0.42u l=0.13u
X743 VDD GND.t77 VDD VDD sg13_lv_pmos ad=0.19p pd=1.38u as=0 ps=0 w=1u l=1u
X744 GND.t815 VDD GND.t815 GND.t859 sg13_lv_nmos ad=0.1428p pd=1.52u as=0 ps=0 w=0.42u l=1u
X745 VDD a_4559_4727# a_4816_4870# VDD sg13_lv_pmos ad=1.48542p pd=9.54u as=79.8f ps=0.8u w=0.42u l=0.13u
X746 _133_.Y _126_.B1 GND.t106 GND.t442 sg13_lv_nmos ad=0.1694p pd=1.21u as=0.2618p ps=2.22u w=0.77u l=0.13u
X747 GND.t1302 VDD GND.t1301 GND.t1300 sg13_lv_nmos ad=0.1428p pd=1.52u as=0 ps=0 w=0.42u l=1u
X748 GND.t188 VDD GND.t188 GND.t1114 sg13_lv_nmos ad=0.1428p pd=1.52u as=0 ps=0 w=0.42u l=1u
X749 GND.t1108 VDD GND.t1108 GND.t1107 sg13_lv_nmos ad=0.1428p pd=1.52u as=0 ps=0 w=0.42u l=1u
X750 GND.t198 VDD GND.t198 GND.t1023 sg13_lv_nmos ad=0.1428p pd=1.52u as=0 ps=0 w=0.42u l=1u
X751 VDD _220_.Y a_2218_12433# VDD sg13_lv_pmos ad=0.1563p pd=1.22u as=0.147p ps=1.54u w=0.42u l=0.13u
X752 GND.t42 VDD GND.t139 GND.t993 sg13_lv_nmos ad=79.8f pd=0.8u as=0 ps=0 w=0.42u l=1u
X753 a_9424_16238# a_9167_16357# a_9586_16434# GND.t386 sg13_lv_nmos ad=0.1428p pd=1.52u as=37.8f ps=0.6u w=0.42u l=0.13u
X754 VDD GND.t956 VDD VDD sg13_lv_pmos ad=0.34p pd=2.68u as=0 ps=0 w=1u l=1u
X755 a_14054_15234# _135_.A VDD VDD sg13_lv_pmos ad=79.8f pd=0.8u as=0.1428p ps=1.52u w=0.42u l=0.13u
X756 GND.t79 _136_.A a_11755_4696# GND.t612 sg13_lv_nmos ad=0.1331p pd=1.12u as=0.1216p ps=1.02u w=0.64u l=0.13u
X757 VDD GND.t812 VDD VDD sg13_lv_pmos ad=0.34p pd=2.68u as=0 ps=0 w=1u l=1u
X758 GND.t369 a_3664_13214# a_3313_13333# GND.t46 sg13_lv_nmos ad=79.8f pd=0.8u as=0.1428p ps=1.52u w=0.42u l=0.13u
X759 a_6677_8806# _168_.B GND.t40 GND.t21 sg13_lv_nmos ad=0.1406p pd=1.12u as=0.1898p ps=1.36u w=0.74u l=0.13u
X760 VDD GND.t26 VDD VDD sg13_lv_pmos ad=0.19p pd=1.38u as=0 ps=0 w=1u l=1u
X761 GND.t13 a_12623_16823# a_13290_17044# GND.t12 sg13_lv_nmos ad=0.1406p pd=1.12u as=0.2516p ps=2.16u w=0.74u l=0.13u
X762 a_12549_12189# _263_.CLK GND.t249 GND.t1509 sg13_lv_nmos ad=0.2516p pd=2.16u as=3.25075p ps=21.2u w=0.74u l=0.13u
X763 _165_.Y _122_.A0 a_7258_8806# GND.t21 sg13_lv_nmos ad=0.2516p pd=2.16u as=0.1406p ps=1.12u w=0.74u l=0.13u
X764 a_15801_15549# a_14859_15356# a_15599_15311# VDD sg13_lv_pmos ad=93.45f pd=0.865u as=0.2048p ps=1.63u w=0.42u l=0.13u
X765 GND.t1249 VDD GND.t292 GND.t1250 sg13_lv_nmos ad=79.8f pd=0.8u as=0 ps=0 w=0.42u l=1u
X766 a_5372_9484# _136_.A VDD VDD sg13_lv_pmos ad=0.2128p pd=1.5u as=0.2128p ps=1.5u w=1.12u l=0.13u
X767 _138_.Y _136_.B a_8042_3900# VDD sg13_lv_pmos ad=0.3808p pd=2.92u as=0.1176p ps=1.33u w=1.12u l=0.13u
X768 a_4661_17878# fanout6.A GND.t689 GND.t1409 sg13_lv_nmos ad=0.1406p pd=1.12u as=0.1898p ps=1.36u w=0.74u l=0.13u
X769 GND.t1373 VDD GND.t1375 GND.t1374 sg13_lv_nmos ad=79.8f pd=0.8u as=0 ps=0 w=0.42u l=1u
X770 GND.t510 VDD GND.t510 GND.t709 sg13_lv_nmos ad=79.8f pd=0.8u as=0 ps=0 w=0.42u l=1u
X771 GND.t5 VDD GND.t1152 GND.t1151 sg13_lv_nmos ad=0.1428p pd=1.52u as=0 ps=0 w=0.42u l=1u
X772 a_2558_17532# _250_.Q a_2126_17774# VDD sg13_lv_pmos ad=0.3325p pd=1.665u as=0.2225p ps=1.445u w=1u l=0.13u
X773 _205_.Y _199_.Y GND.t116 GND.t115 sg13_lv_nmos ad=0.2516p pd=2.16u as=0.1406p ps=1.12u w=0.74u l=0.13u
X774 VDD GND.t39 VDD VDD sg13_lv_pmos ad=0.34p pd=2.68u as=0 ps=0 w=1u l=1u
X775 a_10809_4965# a_9867_4772# a_10607_4727# VDD sg13_lv_pmos ad=93.45f pd=0.865u as=0.2048p ps=1.63u w=0.42u l=0.13u
X776 a_2410_9409# a_2853_9165# a_2793_9577# VDD sg13_lv_pmos ad=79.8f pd=0.8u as=63f ps=0.72u w=0.42u l=0.13u
X777 GND.t14 a_11781_16725# a_11883_16868# GND.t1393 sg13_lv_nmos ad=2.85425p pd=18.015u as=0.2516p ps=2.16u w=0.74u l=0.13u
X778 VDD a_11536_9406# a_11481_9501# VDD sg13_lv_pmos ad=1.94845p pd=12.685u as=93.45f ps=0.865u w=0.42u l=0.13u
X779 GND.t1205 VDD GND.t1204 GND.t1203 sg13_lv_nmos ad=0.1428p pd=1.52u as=0 ps=0 w=0.42u l=1u
X780 a_11974_8436# _164_.B1 a_11731_8698# VDD sg13_lv_pmos ad=0.2125p pd=1.425u as=0.35p ps=2.7u w=1u l=0.13u
X781 VDD _147_.A1 a_10938_5412# VDD sg13_lv_pmos ad=0.2891p pd=1.695u as=0.1428p ps=1.375u w=1.12u l=0.13u
X782 GND.t607 _136_.A a_5201_9240# GND.t21 sg13_lv_nmos ad=0.15245p pd=1.17u as=0.17462p ps=1.185u w=0.55u l=0.13u
X783 _118_.A0 a_4074_17044# VDD VDD sg13_lv_pmos ad=0.3808p pd=2.92u as=0.2128p ps=1.5u w=1.12u l=0.13u
X784 a_11536_17750# a_11279_17869# a_11698_17946# GND.t158 sg13_lv_nmos ad=0.1428p pd=1.52u as=37.8f ps=0.6u w=0.42u l=0.13u
X785 VDD GND.t726 VDD VDD sg13_lv_pmos ad=0.34p pd=2.68u as=0 ps=0 w=1u l=1u
X786 a_7882_15964# a_8325_16007# a_8265_16043# VDD sg13_lv_pmos ad=79.8f pd=0.8u as=63f ps=0.72u w=0.42u l=0.13u
X787 VDD GND.t666 VDD VDD sg13_lv_pmos ad=0.19p pd=1.38u as=0 ps=0 w=1u l=1u
X788 VDD a_9573_13701# a_9675_13844# VDD sg13_lv_pmos ad=5.15485p pd=34.14u as=0.3864p ps=2.93u w=1.12u l=0.13u
X789 GND.t689 VDD GND.t689 GND.t691 sg13_lv_nmos ad=0.1428p pd=1.52u as=0 ps=0 w=0.42u l=1u
X790 VDD a_10437_17519# a_10539_17519# VDD sg13_lv_pmos ad=1.30717p pd=8.395u as=0.3864p ps=2.93u w=1.12u l=0.13u
X791 GND.t100 VDD GND.t100 GND.t983 sg13_lv_nmos ad=0.1428p pd=1.52u as=0 ps=0 w=0.42u l=1u
X792 a_11781_16725# _214_.A VDD VDD sg13_lv_pmos ad=0.4088p pd=2.97u as=1.30717p ps=8.395u w=1.12u l=0.13u
X793 VDD GND.t229 VDD VDD sg13_lv_pmos ad=0.34p pd=2.68u as=0 ps=0 w=1u l=1u
X794 GND.t668 VDD GND.t815 GND.t817 sg13_lv_nmos ad=0.1428p pd=1.52u as=0 ps=0 w=0.42u l=1u
X795 GND.t371 a_3380_13690# _247_.CLK GND.t46 sg13_lv_nmos ad=0.1406p pd=1.12u as=0.1406p ps=1.12u w=0.74u l=0.13u
X796 GND.t1318 VDD GND.t1320 GND.t1319 sg13_lv_nmos ad=79.8f pd=0.8u as=0 ps=0 w=0.42u l=1u
X797 VDD GND.t809 VDD VDD sg13_lv_pmos ad=0.34p pd=2.68u as=0 ps=0 w=1u l=1u
X798 GND.t136 VDD GND.t136 GND.t1035 sg13_lv_nmos ad=0.1428p pd=1.52u as=0 ps=0 w=0.42u l=1u
X799 GND.t404 VDD GND.t404 GND.t960 sg13_lv_nmos ad=0.1428p pd=1.52u as=0 ps=0 w=0.42u l=1u
X800 GND.t35 VDD GND.t33 GND.t1126 sg13_lv_nmos ad=79.8f pd=0.8u as=0 ps=0 w=0.42u l=1u
X801 VDD _219_.Y a_2150_9186# VDD sg13_lv_pmos ad=0.36237p pd=2.605u as=79.8f ps=0.8u w=0.42u l=0.13u
X802 VDD GND.t356 VDD VDD sg13_lv_pmos ad=0.19p pd=1.38u as=0 ps=0 w=1u l=1u
X803 GND.t718 VDD GND.t718 GND.t712 sg13_lv_nmos ad=79.8f pd=0.8u as=0 ps=0 w=0.42u l=1u
X804 VDD GND.t1340 VDD VDD sg13_lv_pmos ad=0.19p pd=1.38u as=0 ps=0 w=1u l=1u
X805 GND.t1307 VDD GND.t1306 GND.t1305 sg13_lv_nmos ad=0.1428p pd=1.52u as=0 ps=0 w=0.42u l=1u
X806 GND.t517 a_4816_5654# a_4465_5773# GND.t5 sg13_lv_nmos ad=79.8f pd=0.8u as=0.1428p ps=1.52u w=0.42u l=0.13u
X807 a_3588_5837# a_3300_5416# a_3526_5837# GND.t457 sg13_lv_nmos ad=0.1428p pd=1.52u as=37.8f ps=0.6u w=0.42u l=0.13u
X808 GND.t151 _171_.A _171_.Y GND.t21 sg13_lv_nmos ad=0.2516p pd=2.16u as=0.1406p ps=1.12u w=0.74u l=0.13u
X809 VDD _131_.A2 _128_.B1 VDD sg13_lv_pmos ad=0.3808p pd=2.92u as=0.2128p ps=1.5u w=1.12u l=0.13u
X810 _166_.A a_16746_8436# GND.t222 GND.t72 sg13_lv_nmos ad=0.2516p pd=2.16u as=0.1406p ps=1.12u w=0.74u l=0.13u
X811 a_4881_12972# _119_.A0 VDD VDD sg13_lv_pmos ad=0.1225p pd=1.245u as=0.36p ps=2.72u w=1u l=0.13u
X812 VDD GND.t693 VDD VDD sg13_lv_pmos ad=0.19p pd=1.38u as=0 ps=0 w=1u l=1u
X813 GND.t367 a_3380_13690# _247_.CLK GND.t46 sg13_lv_nmos ad=0.1406p pd=1.12u as=0.1406p ps=1.12u w=0.74u l=0.13u
X814 a_9994_17476# a_10437_17519# a_10377_17555# VDD sg13_lv_pmos ad=79.8f pd=0.8u as=63f ps=0.72u w=0.42u l=0.13u
X815 a_6008_15242# _196_.Y a_5906_15242# GND.t1582 sg13_lv_nmos ad=0.1406p pd=1.12u as=0.1406p ps=1.12u w=0.74u l=0.13u
X816 VDD a_10607_4727# a_10864_4870# VDD sg13_lv_pmos ad=1.48542p pd=9.54u as=79.8f ps=0.8u w=0.42u l=0.13u
X817 a_9290_3900# _138_.Y VDD VDD sg13_lv_pmos ad=0.1176p pd=1.33u as=0.4032p ps=2.96u w=1.12u l=0.13u
X818 GND.t1186 VDD GND.t1185 GND.t5 sg13_lv_nmos ad=0.1428p pd=1.52u as=0 ps=0 w=0.42u l=1u
X819 a_14196_5760# _148_.X a_13740_5678# GND.t5 sg13_lv_nmos ad=78.39999f pd=0.885u as=0.2176p ps=1.96u w=0.64u l=0.13u
X820 GND.t1252 VDD GND.t333 GND.t1253 sg13_lv_nmos ad=79.8f pd=0.8u as=0 ps=0 w=0.42u l=1u
X821 a_15237_11471# _263_.CLK VDD VDD sg13_lv_pmos ad=0.4088p pd=2.97u as=5.15485p ps=34.14u w=1.12u l=0.13u
X822 GND.t122 a_2126_11726# _120_.X GND.t189 sg13_lv_nmos ad=0.148p pd=1.14u as=0.4033p ps=2.57u w=0.74u l=0.13u
X823 _152_.X a_12237_5760# GND.t419 GND.t5 sg13_lv_nmos ad=0.2516p pd=2.16u as=0.1331p ps=1.12u w=0.74u l=0.13u
X824 GND.t59 a_14320_16238# a_13969_16357# GND.t58 sg13_lv_nmos ad=79.8f pd=0.8u as=0.1428p ps=1.52u w=0.42u l=0.13u
X825 a_16336_11702# _236_.Y VDD VDD sg13_lv_pmos ad=79.8f pd=0.8u as=5.15485p ps=34.14u w=0.42u l=0.13u
X826 a_10437_17519# freq_in GND.t157 GND.t1476 sg13_lv_nmos ad=0.2516p pd=2.16u as=13.15737p ps=85.385u w=0.74u l=0.13u
X827 GND.t20 a_9551_16823# a_10218_17044# GND.t19 sg13_lv_nmos ad=0.1406p pd=1.12u as=0.2516p ps=2.16u w=0.74u l=0.13u
X828 VDD GND.t812 VDD VDD sg13_lv_pmos ad=0.19p pd=1.38u as=0 ps=0 w=1u l=1u
X829 a_9062_4650# _252_.D VDD VDD sg13_lv_pmos ad=79.8f pd=0.8u as=0.1428p ps=1.52u w=0.42u l=0.13u
X830 VDD GND.t718 VDD VDD sg13_lv_pmos ad=0.34p pd=2.68u as=0 ps=0 w=1u l=1u
X831 _207_.A1 a_9834_15996# GND.t94 GND.t101 sg13_lv_nmos ad=0.2516p pd=2.16u as=0.1406p ps=1.12u w=0.74u l=0.13u
X832 a_14628_8874# _159_.Y a_14534_8874# GND.t44 sg13_lv_nmos ad=60.89999f pd=0.71u as=0.1428p ps=1.52u w=0.42u l=0.13u
X833 GND.t671 VDD GND.t671 GND.t1053 sg13_lv_nmos ad=0.1428p pd=1.52u as=0 ps=0 w=0.42u l=1u
X834 a_14628_11898# _131_.Y a_14534_11898# GND.t16 sg13_lv_nmos ad=60.89999f pd=0.71u as=0.1428p ps=1.52u w=0.42u l=0.13u
X835 GND.t879 VDD GND.t821 GND.t880 sg13_lv_nmos ad=79.8f pd=0.8u as=0 ps=0 w=0.42u l=1u
X836 GND.t1343 VDD GND.t1345 GND.t1344 sg13_lv_nmos ad=79.8f pd=0.8u as=0 ps=0 w=0.42u l=1u
X837 _168_.Y _168_.B a_6771_8436# VDD sg13_lv_pmos ad=0.2408p pd=1.55u as=0.1428p ps=1.375u w=1.12u l=0.13u
X838 a_9130_12433# a_9573_12189# a_9513_12601# VDD sg13_lv_pmos ad=79.8f pd=0.8u as=63f ps=0.72u w=0.42u l=0.13u
X839 GND.t1027 a_3886_10702# clkbuf_1_0__f_sclk.A GND.t1454 sg13_lv_nmos ad=0.1406p pd=1.12u as=0.1406p ps=1.12u w=0.74u l=0.13u
X840 a_1958_12210# _120_.X VDD VDD sg13_lv_pmos ad=79.8f pd=0.8u as=0.1428p ps=1.52u w=0.42u l=0.13u
X841 VDD GND.t1193 VDD VDD sg13_lv_pmos ad=0.34p pd=2.68u as=0 ps=0 w=1u l=1u
X842 a_4913_13330# _119_.A0 GND.t379 GND.t46 sg13_lv_nmos ad=0.17462p pd=1.185u as=0.374p ps=2.46u w=0.55u l=0.13u
X843 VDD _260_.CLK a_14651_10996# VDD sg13_lv_pmos ad=0.2128p pd=1.5u as=0.2128p ps=1.5u w=1.12u l=0.13u
X844 a_10672_13942# _230_.Y VDD VDD sg13_lv_pmos ad=79.8f pd=0.8u as=5.15485p ps=34.14u w=0.42u l=0.13u
X845 VDD GND.t198 VDD VDD sg13_lv_pmos ad=0.19p pd=1.38u as=0 ps=0 w=1u l=1u
X846 a_4512_17547# _118_.A0 VDD VDD sg13_lv_pmos ad=0.1596p pd=1.22u as=0.4536p ps=2.76u w=0.84u l=0.13u
X847 _196_.Y _189_.X VDD VDD sg13_lv_pmos ad=0.2128p pd=1.5u as=0.3808p ps=2.92u w=1.12u l=0.13u
X848 VDD GND.t1271 VDD VDD sg13_lv_pmos ad=0.34p pd=2.68u as=0 ps=0 w=1u l=1u
X849 a_13161_16043# a_12804_16000# VDD VDD sg13_lv_pmos ad=63f pd=0.72u as=0.1563p ps=1.22u w=0.42u l=0.13u
X850 _162_.Y _162_.B GND.t264 GND.t268 sg13_lv_nmos ad=0.1406p pd=1.12u as=0.2516p ps=2.16u w=0.74u l=0.13u
X851 _171_.A _168_.Y GND.t622 GND.t21 sg13_lv_nmos ad=0.1406p pd=1.12u as=0.2516p ps=2.16u w=0.74u l=0.13u
X852 a_7616_15437# _201_.Y VDD VDD sg13_lv_pmos ad=0.1596p pd=1.22u as=0.1918p ps=1.5u w=0.84u l=0.13u
X853 a_3826_16434# _250_.RESET_B GND.t446 GND.t14 sg13_lv_nmos ad=37.8f pd=0.6u as=79.8f ps=0.8u w=0.42u l=0.13u
X854 VDD _266_.CLK _212_.Y VDD sg13_lv_pmos ad=0.3808p pd=2.92u as=0.3808p ps=2.92u w=1.12u l=0.13u
X855 VDD _124_.S a_2558_14020# VDD sg13_lv_pmos ad=0.253p pd=1.53u as=0.3325p ps=1.665u w=1u l=0.13u
X856 a_3380_13690# clkbuf_1_0__f_sclk.A GND.t47 GND.t46 sg13_lv_nmos ad=0.1406p pd=1.12u as=0.1406p ps=1.12u w=0.74u l=0.13u
X857 VDD _168_.B a_6528_8475# VDD sg13_lv_pmos ad=0.2891p pd=1.695u as=0.1596p ps=1.22u w=0.84u l=0.13u
X858 VDD GND.t1233 VDD VDD sg13_lv_pmos ad=0.34p pd=2.68u as=0 ps=0 w=1u l=1u
X859 GND.t1292 VDD GND.t1291 GND.t1290 sg13_lv_nmos ad=0.1428p pd=1.52u as=0 ps=0 w=0.42u l=1u
X860 fanout7.A a_16746_9484# GND.t222 GND.t72 sg13_lv_nmos ad=0.2516p pd=2.16u as=0.1406p ps=1.12u w=0.74u l=0.13u
X861 GND.t862 VDD GND.t668 GND.t861 sg13_lv_nmos ad=0.1428p pd=1.52u as=0 ps=0 w=0.42u l=1u
X862 VDD a_3886_10702# clkbuf_1_0__f_sclk.A VDD sg13_lv_pmos ad=0.2128p pd=1.5u as=0.2128p ps=1.5u w=1.12u l=0.13u
X863 GND.t794 VDD GND.t797 GND.t796 sg13_lv_nmos ad=79.8f pd=0.8u as=0 ps=0 w=0.42u l=1u
X864 GND.t356 _218_.Y a_2244_8874# GND.t451 sg13_lv_nmos ad=0.1626p pd=1.415u as=60.89999f ps=0.71u w=0.42u l=0.13u
X865 GND.t26 VDD GND.t26 GND.t734 sg13_lv_nmos ad=79.8f pd=0.8u as=0 ps=0 w=0.42u l=1u
X866 GND.t42 VDD GND.t42 GND.t992 sg13_lv_nmos ad=0.1428p pd=1.52u as=0 ps=0 w=0.42u l=1u
X867 VDD GND.t1000 VDD VDD sg13_lv_pmos ad=0.34p pd=2.68u as=0 ps=0 w=1u l=1u
X868 a_16118_16759# a_14940_16710# a_15722_16904# GND.t288 sg13_lv_nmos ad=37.8f pd=0.6u as=0.1428p ps=1.52u w=0.42u l=0.13u
X869 VDD a_16336_9406# a_16281_9501# VDD sg13_lv_pmos ad=1.94845p pd=12.685u as=93.45f ps=0.865u w=0.42u l=0.13u
X870 GND.t108 VDD GND.t108 GND.t891 sg13_lv_nmos ad=0.1428p pd=1.52u as=0 ps=0 w=0.42u l=1u
X871 VDD GND.t806 VDD VDD sg13_lv_pmos ad=0.34p pd=2.68u as=0 ps=0 w=1u l=1u
X872 _131_.B1 _131_.A2 a_14451_13320# GND.t109 sg13_lv_nmos ad=0.1406p pd=1.12u as=0.1406p ps=1.12u w=0.74u l=0.13u
X873 a_13041_5412# _147_.Y VDD VDD sg13_lv_pmos ad=0.1225p pd=1.245u as=0.36p ps=2.72u w=1u l=0.13u
X874 a_7985_7728# _136_.A a_7953_7996# VDD sg13_lv_pmos ad=0.34p pd=2.68u as=0.1225p ps=1.245u w=1u l=0.13u
X875 VDD GND.t321 VDD VDD sg13_lv_pmos ad=0.34p pd=2.68u as=0 ps=0 w=1u l=1u
X876 a_3380_13690# clkbuf_1_0__f_sclk.A GND.t272 GND.t46 sg13_lv_nmos ad=0.1406p pd=1.12u as=0.1406p ps=1.12u w=0.74u l=0.13u
X877 a_6756_4663# a_6468_4968# a_6694_4663# GND.t1548 sg13_lv_nmos ad=0.1428p pd=1.52u as=37.8f ps=0.6u w=0.42u l=0.13u
X878 GND.t1277 VDD GND.t1276 GND.t1275 sg13_lv_nmos ad=0.1428p pd=1.52u as=0 ps=0 w=0.42u l=1u
X879 a_10020_17512# a_9994_17476# VDD VDD sg13_lv_pmos ad=0.34p pd=2.68u as=0.36237p ps=2.605u w=1u l=0.13u
X880 VDD a_15983_5773# a_16650_5412# VDD sg13_lv_pmos ad=0.2128p pd=1.5u as=0.3864p ps=2.93u w=1.12u l=0.13u
X881 a_2232_7868# _124_.S VDD VDD sg13_lv_pmos ad=0.2856p pd=2.36u as=0.253p ps=1.53u w=0.84u l=0.13u
X882 VDD GND.t77 VDD VDD sg13_lv_pmos ad=0.34p pd=2.68u as=0 ps=0 w=1u l=1u
X883 GND.t1000 VDD GND.t1000 GND.t1040 sg13_lv_nmos ad=79.8f pd=0.8u as=0 ps=0 w=0.42u l=1u
X884 a_12401_4704# _148_.B a_12369_4972# VDD sg13_lv_pmos ad=0.34p pd=2.68u as=0.1225p ps=1.245u w=1u l=0.13u
X885 a_7157_16366# _202_.Y GND.t219 GND.t14 sg13_lv_nmos ad=0.1406p pd=1.12u as=0.1898p ps=1.36u w=0.74u l=0.13u
X886 a_3274_4873# a_3717_4629# a_3014_4650# GND.t349 sg13_lv_nmos ad=79.8f pd=0.8u as=0.1296p ps=1.52u w=0.42u l=0.13u
X887 a_5050_15238# _119_.A0 _195_.Y GND.t1418 sg13_lv_nmos ad=0.1406p pd=1.12u as=0.2516p ps=2.16u w=0.74u l=0.13u
X888 a_4816_5654# a_4559_5773# a_4978_5850# GND.t5 sg13_lv_nmos ad=0.1428p pd=1.52u as=37.8f ps=0.6u w=0.42u l=0.13u
X889 VDD _176_.A _192_.B VDD sg13_lv_pmos ad=0.3808p pd=2.92u as=0.2128p ps=1.5u w=1.12u l=0.13u
X890 GND.t1073 VDD GND.t1074 GND.t21 sg13_lv_nmos ad=79.8f pd=0.8u as=0 ps=0 w=0.42u l=1u
X891 a_11846_12210# _126_.Y VDD VDD sg13_lv_pmos ad=79.8f pd=0.8u as=0.1428p ps=1.52u w=0.42u l=0.13u
X892 VDD _158_.Y a_13824_7989# VDD sg13_lv_pmos ad=0.2891p pd=1.695u as=0.1596p ps=1.22u w=0.84u l=0.13u
X893 VDD GND.t949 VDD VDD sg13_lv_pmos ad=0.19p pd=1.38u as=0 ps=0 w=1u l=1u
X894 a_6182_4650# a_6987_4772# a_6442_4873# VDD sg13_lv_pmos ad=0.1428p pd=1.52u as=79.8f ps=0.8u w=0.42u l=0.13u
X895 GND.t100 VDD GND.t100 GND.t983 sg13_lv_nmos ad=0.1428p pd=1.52u as=0 ps=0 w=0.42u l=1u
X896 GND.t726 VDD GND.t726 GND.t158 sg13_lv_nmos ad=0.1428p pd=1.52u as=0 ps=0 w=0.42u l=1u
X897 GND.t491 _199_.B1 _199_.Y GND.t490 sg13_lv_nmos ad=0.2516p pd=2.16u as=0.1406p ps=1.12u w=0.74u l=0.13u
X898 GND.t21 a_10437_9165# a_10539_9308# GND.t1503 sg13_lv_nmos ad=4.0443p pd=25.39u as=0.2516p ps=2.16u w=0.74u l=0.13u
X899 GND.t356 VDD GND.t356 GND.t217 sg13_lv_nmos ad=79.8f pd=0.8u as=0 ps=0 w=0.42u l=1u
X900 a_4144_4142# _243_.RESET_B VDD VDD sg13_lv_pmos ad=79.8f pd=0.8u as=5.15485p ps=34.14u w=0.42u l=0.13u
X901 GND.t1184 _147_.A1 a_11220_5760# GND.t5 sg13_lv_nmos ad=0.2272p pd=1.99u as=78.39999f ps=0.885u w=0.64u l=0.13u
X902 a_6482_12218# _192_.C GND.t256 GND.t484 sg13_lv_nmos ad=0.1406p pd=1.12u as=0.2886p ps=2.26u w=0.74u l=0.13u
X903 a_6720_17061# _205_.Y VDD VDD sg13_lv_pmos ad=0.1596p pd=1.22u as=0.4536p ps=2.76u w=0.84u l=0.13u
X904 GND.t1348 VDD GND.t1350 GND.t1349 sg13_lv_nmos ad=79.8f pd=0.8u as=0 ps=0 w=0.42u l=1u
X905 a_15141_12189# _263_.CLK GND.t249 GND.t1511 sg13_lv_nmos ad=0.2516p pd=2.16u as=3.25075p ps=21.2u w=0.74u l=0.13u
X906 VDD _242_.RESET_B a_3014_4650# VDD sg13_lv_pmos ad=0.36237p pd=2.605u as=79.8f ps=0.8u w=0.42u l=0.13u
X907 a_11974_8436# _160_.X VDD VDD sg13_lv_pmos ad=0.34p pd=2.68u as=0.19p ps=1.38u w=1u l=0.13u
X908 a_6579_11460# _176_.A VDD VDD sg13_lv_pmos ad=0.1428p pd=1.375u as=0.2891p ps=1.695u w=1.12u l=0.13u
X909 GND.t55 a_13391_12287# a_14058_12508# GND.t552 sg13_lv_nmos ad=0.1406p pd=1.12u as=0.2516p ps=2.16u w=0.74u l=0.13u
X910 _145_.A2 a_8538_5375# GND.t470 GND.t5 sg13_lv_nmos ad=0.1628p pd=1.18u as=0.3108p ps=2.32u w=0.74u l=0.13u
X911 a_2122_12940# a_2565_12983# a_2505_13019# VDD sg13_lv_pmos ad=79.8f pd=0.8u as=63f ps=0.72u w=0.42u l=0.13u
X912 GND.t1094 VDD GND.t1094 GND.t1122 sg13_lv_nmos ad=79.8f pd=0.8u as=0 ps=0 w=0.42u l=1u
X913 a_12685_7700# _157_.Y a_12215_7664# GND.t1467 sg13_lv_nmos ad=94.35f pd=0.995u as=0.1406p ps=1.12u w=0.74u l=0.13u
X914 a_8006_16746# _209_.Y VDD VDD sg13_lv_pmos ad=79.8f pd=0.8u as=0.1428p ps=1.52u w=0.42u l=0.13u
X915 a_4858_12214# _120_.A0 _187_.Y GND.t409 sg13_lv_nmos ad=0.1406p pd=1.12u as=0.2516p ps=2.16u w=0.74u l=0.13u
X916 VDD GND.t671 VDD VDD sg13_lv_pmos ad=0.19p pd=1.38u as=0 ps=0 w=1u l=1u
X917 GND.t718 VDD GND.t718 GND.t712 sg13_lv_nmos ad=79.8f pd=0.8u as=0 ps=0 w=0.42u l=1u
X918 _266_.CLK a_13290_17044# GND.t13 GND.t453 sg13_lv_nmos ad=0.2516p pd=2.16u as=0.1406p ps=1.12u w=0.74u l=0.13u
X919 GND.t1227 VDD GND.t1224 GND.t1260 sg13_lv_nmos ad=0.1428p pd=1.52u as=0 ps=0 w=0.42u l=1u
X920 a_11481_17631# a_10539_17519# a_11279_17869# VDD sg13_lv_pmos ad=93.45f pd=0.865u as=0.2048p ps=1.63u w=0.42u l=0.13u
X921 GND.t689 VDD GND.t693 GND.t738 sg13_lv_nmos ad=79.8f pd=0.8u as=0 ps=0 w=0.42u l=1u
X922 a_2126_11726# _120_.A0 a_2298_11830# GND.t189 sg13_lv_nmos ad=0.1628p pd=1.18u as=0.3367p ps=1.65u w=0.74u l=0.13u
X923 _243_.CLK a_3956_6888# GND.t557 GND.t565 sg13_lv_nmos ad=0.1406p pd=1.12u as=0.1406p ps=1.12u w=0.74u l=0.13u
X924 GND.t1363 VDD GND.t1362 GND.t1361 sg13_lv_nmos ad=0.1428p pd=1.52u as=0 ps=0 w=0.42u l=1u
X925 GND.t726 VDD GND.t726 GND.t712 sg13_lv_nmos ad=79.8f pd=0.8u as=0 ps=0 w=0.42u l=1u
X926 a_2436_16759# a_2667_16868# a_2122_16969# GND.t615 sg13_lv_nmos ad=0.2373p pd=1.97u as=79.8f ps=0.8u w=0.42u l=0.13u
X927 VDD GND.t763 VDD VDD sg13_lv_pmos ad=0.34p pd=2.68u as=0 ps=0 w=1u l=1u
X928 VDD GND.t794 VDD VDD sg13_lv_pmos ad=0.19p pd=1.38u as=0 ps=0 w=1u l=1u
X929 a_2436_9504# a_2955_9308# a_3695_9263# GND.t21 sg13_lv_nmos ad=0.3473p pd=2.71u as=0.12665p ps=1.145u w=0.74u l=0.13u
X930 VDD GND.t697 VDD VDD sg13_lv_pmos ad=0.34p pd=2.68u as=0 ps=0 w=1u l=1u
X931 GND.t1323 VDD GND.t1322 GND.t1321 sg13_lv_nmos ad=0.1428p pd=1.52u as=0 ps=0 w=0.42u l=1u
X932 a_2853_9165# _243_.CLK VDD VDD sg13_lv_pmos ad=0.4088p pd=2.97u as=1.94845p ps=12.685u w=1.12u l=0.13u
X933 VDD _243_.RESET_B a_2342_4338# VDD sg13_lv_pmos ad=0.36237p pd=2.605u as=79.8f ps=0.8u w=0.42u l=0.13u
X934 GND.t1282 VDD GND.t1281 GND.t1280 sg13_lv_nmos ad=0.1428p pd=1.52u as=0 ps=0 w=0.42u l=1u
X935 VDD _186_.Y a_8156_14020# VDD sg13_lv_pmos ad=0.2128p pd=1.5u as=0.3808p ps=2.92u w=1.12u l=0.13u
X936 GND.t904 VDD GND.t904 GND.t935 sg13_lv_nmos ad=0.1428p pd=1.52u as=0 ps=0 w=0.42u l=1u
X937 a_3922_12210# _220_.Y GND.t125 GND.t124 sg13_lv_nmos ad=37.8f pd=0.6u as=79.8f ps=0.8u w=0.42u l=0.13u
X938 GND.t557 a_3956_6888# _243_.CLK GND.t562 sg13_lv_nmos ad=0.1406p pd=1.12u as=0.1406p ps=1.12u w=0.74u l=0.13u
X939 a_7953_7996# _122_.A0 VDD VDD sg13_lv_pmos ad=0.1225p pd=1.245u as=0.36p ps=2.72u w=1u l=0.13u
X940 VDD GND.t77 VDD VDD sg13_lv_pmos ad=0.34p pd=2.68u as=0 ps=0 w=1u l=1u
X941 a_6234_3900# _210_.B _210_.Y VDD sg13_lv_pmos ad=0.1428p pd=1.375u as=0.2408p ps=1.55u w=1.12u l=0.13u
X942 GND.t1333 VDD GND.t1335 GND.t1334 sg13_lv_nmos ad=79.8f pd=0.8u as=0 ps=0 w=0.42u l=1u
X943 VDD GND.t703 VDD VDD sg13_lv_pmos ad=0.19p pd=1.38u as=0 ps=0 w=1u l=1u
X944 VDD GND.t800 VDD VDD sg13_lv_pmos ad=0.19p pd=1.38u as=0 ps=0 w=1u l=1u
X945 a_2232_10210# _124_.S VDD VDD sg13_lv_pmos ad=0.2856p pd=2.36u as=0.253p ps=1.53u w=0.84u l=0.13u
X946 _247_.CLK a_3380_13690# VDD VDD sg13_lv_pmos ad=0.2128p pd=1.5u as=0.2128p ps=1.5u w=1.12u l=0.13u
X947 a_9269_9190# _171_.Y GND.t90 GND.t21 sg13_lv_nmos ad=0.1406p pd=1.12u as=0.1898p ps=1.36u w=0.74u l=0.13u
X948 VDD GND.t718 VDD VDD sg13_lv_pmos ad=0.34p pd=2.68u as=0 ps=0 w=1u l=1u
X949 VDD GND.t79 VDD VDD sg13_lv_pmos ad=0.34p pd=2.68u as=0 ps=0 w=1u l=1u
X950 _258_.RESET_B _222_.A VDD VDD sg13_lv_pmos ad=0.3808p pd=2.92u as=0.3808p ps=2.92u w=1.12u l=0.13u
X951 a_9382_12223# _256_.RESET_B GND.t402 GND.t401 sg13_lv_nmos ad=37.8f pd=0.6u as=0.1701p ps=1.65u w=0.42u l=0.13u
X952 a_11475_4248# _139_.X GND.t79 GND.t1401 sg13_lv_nmos ad=0.1406p pd=1.12u as=0.2516p ps=2.16u w=0.74u l=0.13u
X953 GND.t450 a_3952_8678# a_3601_8797# GND.t21 sg13_lv_nmos ad=79.8f pd=0.8u as=0.1428p ps=1.52u w=0.42u l=0.13u
X954 a_3588_5837# a_3819_5423# a_3274_5380# GND.t537 sg13_lv_nmos ad=0.2373p pd=1.97u as=79.8f ps=0.8u w=0.42u l=0.13u
X955 a_2436_9504# a_2410_9409# VDD VDD sg13_lv_pmos ad=0.34p pd=2.68u as=0.36237p ps=2.605u w=1u l=0.13u
X956 a_10220_18222# _225_.A VDD VDD sg13_lv_pmos ad=0.2856p pd=2.36u as=0.2114p ps=1.54u w=0.84u l=0.13u
X957 a_14724_5416# a_15243_5423# a_15983_5773# GND.t82 sg13_lv_nmos ad=0.3473p pd=2.71u as=0.12665p ps=1.145u w=0.74u l=0.13u
X958 GND.t247 VDD GND.t821 GND.t820 sg13_lv_nmos ad=0.1428p pd=1.52u as=0 ps=0 w=0.42u l=1u
X959 a_14830_17061# a_14572_16746# VDD VDD sg13_lv_pmos ad=93.45f pd=0.865u as=1.30717p ps=8.395u w=0.42u l=0.13u
X960 VDD GND.t901 VDD VDD sg13_lv_pmos ad=0.34p pd=2.68u as=0 ps=0 w=1u l=1u
X961 a_7985_7728# _122_.A0 GND.t35 GND.t34 sg13_lv_nmos ad=0.17462p pd=1.185u as=0.374p ps=2.46u w=0.55u l=0.13u
X962 _222_.Y _222_.A GND.t768 GND.t601 sg13_lv_nmos ad=0.2516p pd=2.16u as=0.2516p ps=2.16u w=0.74u l=0.13u
X963 VDD GND.t726 VDD VDD sg13_lv_pmos ad=0.34p pd=2.68u as=0 ps=0 w=1u l=1u
X964 VDD GND.t1006 VDD VDD sg13_lv_pmos ad=0.34p pd=2.68u as=0 ps=0 w=1u l=1u
X965 VDD a_11781_16725# a_11883_16868# VDD sg13_lv_pmos ad=1.30717p pd=8.395u as=0.3864p ps=2.93u w=1.12u l=0.13u
X966 GND.t1221 VDD GND.t333 GND.t1254 sg13_lv_nmos ad=0.1428p pd=1.52u as=0 ps=0 w=0.42u l=1u
X967 a_3274_5380# a_3717_5423# a_3657_5459# VDD sg13_lv_pmos ad=79.8f pd=0.8u as=63f ps=0.72u w=0.42u l=0.13u
X968 a_2558_15532# _118_.A0 a_2126_15424# VDD sg13_lv_pmos ad=0.3325p pd=1.665u as=0.2225p ps=1.445u w=1u l=0.13u
X969 a_7985_13776# _193_.Y a_7953_14044# VDD sg13_lv_pmos ad=0.34p pd=2.68u as=0.1225p ps=1.245u w=1u l=0.13u
X970 VDD a_4559_5773# a_5226_5412# VDD sg13_lv_pmos ad=0.2128p pd=1.5u as=0.3864p ps=2.93u w=1.12u l=0.13u
X971 VDD GND.t13 VDD VDD sg13_lv_pmos ad=0.34p pd=2.68u as=0 ps=0 w=1u l=1u
X972 a_14724_5416# a_14698_5380# GND.t1194 GND.t1563 sg13_lv_nmos ad=0.2516p pd=2.16u as=0.1626p ps=1.415u w=0.74u l=0.13u
X973 VDD _147_.Y a_13244_5412# VDD sg13_lv_pmos ad=0.2128p pd=1.5u as=0.3808p ps=2.92u w=1.12u l=0.13u
X974 a_15983_12287# a_15141_12189# a_14724_12528# VDD sg13_lv_pmos ad=0.2048p pd=1.63u as=0.34p ps=2.68u w=1u l=0.13u
X975 GND.t1348 VDD GND.t1347 GND.t1346 sg13_lv_nmos ad=0.1428p pd=1.52u as=0 ps=0 w=0.42u l=1u
X976 a_8325_16007# fanout7.A VDD VDD sg13_lv_pmos ad=0.4088p pd=2.97u as=1.6291p ps=10.53u w=1.12u l=0.13u
X977 a_11364_17064# a_11883_16868# a_12623_16823# GND.t237 sg13_lv_nmos ad=0.3473p pd=2.71u as=0.12665p ps=1.145u w=0.74u l=0.13u
X978 a_6970_12214# _176_.B GND.t253 GND.t252 sg13_lv_nmos ad=0.1406p pd=1.12u as=0.2516p ps=2.16u w=0.74u l=0.13u
X979 a_3657_5041# a_3300_4968# VDD VDD sg13_lv_pmos ad=63f pd=0.72u as=0.1563p ps=1.22u w=0.42u l=0.13u
X980 _226_.Y _225_.A.t1 GND.t342 GND.t341 sg13_lv_nmos ad=0.2516p pd=2.16u as=0.2516p ps=2.16u w=0.74u l=0.13u
X981 GND.t21 a_15237_9165# a_15339_9308# GND.t71 sg13_lv_nmos ad=4.0443p pd=25.39u as=0.2516p ps=2.16u w=0.74u l=0.13u
X982 GND.t139 VDD GND.t139 GND.t994 sg13_lv_nmos ad=0.1428p pd=1.52u as=0 ps=0 w=0.42u l=1u
X983 VDD GND.t356 VDD VDD sg13_lv_pmos ad=0.19p pd=1.38u as=0 ps=0 w=1u l=1u
X984 GND.t446 a_3664_16966# a_3313_16823# GND.t14 sg13_lv_nmos ad=79.8f pd=0.8u as=0.1428p ps=1.52u w=0.42u l=0.13u
X985 GND.t310 VDD GND.t871 GND.t873 sg13_lv_nmos ad=0.1428p pd=1.52u as=0 ps=0 w=0.42u l=1u
X986 GND.t1267 VDD GND.t1266 GND.t1265 sg13_lv_nmos ad=0.1428p pd=1.52u as=0 ps=0 w=0.42u l=1u
X987 VDD GND.t26 VDD VDD sg13_lv_pmos ad=0.34p pd=2.68u as=0 ps=0 w=1u l=1u
X988 a_13184_7183# _151_.B a_13321_7272# GND.t431 sg13_lv_nmos ad=0.2176p pd=1.96u as=0.1216p ps=1.02u w=0.64u l=0.13u
X989 GND.t321 VDD GND.t321 GND.t913 sg13_lv_nmos ad=0.1428p pd=1.52u as=0 ps=0 w=0.42u l=1u
X990 a_16240_5654# _226_.Y VDD VDD sg13_lv_pmos ad=79.8f pd=0.8u as=1.48542p ps=9.54u w=0.42u l=0.13u
X991 GND.t55 _235_.Y a_14532_12210# GND.t243 sg13_lv_nmos ad=0.1626p pd=1.415u as=60.89999f ps=0.71u w=0.42u l=0.13u
X992 a_12880_16966# a_12623_16823# a_13042_16746# GND.t11 sg13_lv_nmos ad=0.1428p pd=1.52u as=37.8f ps=0.6u w=0.42u l=0.13u
X993 VDD _200_.Y a_6286_15276# VDD sg13_lv_pmos ad=0.2618p pd=1.63u as=0.2856p ps=2.36u w=0.84u l=0.13u
X994 GND.t136 VDD GND.t136 GND.t1036 sg13_lv_nmos ad=79.8f pd=0.8u as=0 ps=0 w=0.42u l=1u
X995 VDD _126_.B1 a_14357_12972# VDD sg13_lv_pmos ad=0.2128p pd=1.5u as=0.3808p ps=2.92u w=1.12u l=0.13u
X996 GND.t234 a_3045_3911# a_3147_3911# GND.t506 sg13_lv_nmos ad=4.7917p pd=31.625u as=0.2516p ps=2.16u w=0.74u l=0.13u
X997 VDD GND.t57 VDD VDD sg13_lv_pmos ad=0.34p pd=2.68u as=0 ps=0 w=1u l=1u
X998 a_9970_16746# _259_.RESET_B GND.t94 GND.t19 sg13_lv_nmos ad=37.8f pd=0.6u as=79.8f ps=0.8u w=0.42u l=0.13u
X999 a_6862_15532# _205_.B1 a_7074_15532# VDD sg13_lv_pmos ad=0.2128p pd=1.5u as=0.3808p ps=2.92u w=1.12u l=0.13u
X1000 GND.t901 VDD GND.t901 GND.t900 sg13_lv_nmos ad=0.1428p pd=1.52u as=0 ps=0 w=0.42u l=1u
X1001 GND.t947 VDD GND.t949 GND.t948 sg13_lv_nmos ad=79.8f pd=0.8u as=0 ps=0 w=0.42u l=1u
X1002 VDD GND.t519 VDD VDD sg13_lv_pmos ad=0.19p pd=1.38u as=0 ps=0 w=1u l=1u
X1003 a_2126_17774# _118_.A0 a_2298_17532# VDD sg13_lv_pmos ad=0.2225p pd=1.445u as=0.2975p ps=1.595u w=1u l=0.13u
X1004 GND.t1368 VDD GND.t1367 GND.t1366 sg13_lv_nmos ad=0.1428p pd=1.52u as=0 ps=0 w=0.42u l=1u
X1005 GND.t348 _166_.A a_10901_7678# GND.t638 sg13_lv_nmos ad=0.1898p pd=1.36u as=0.2516p ps=2.16u w=0.74u l=0.13u
X1006 a_5525_16750# _207_.A2 GND.t214 GND.t14 sg13_lv_nmos ad=0.1406p pd=1.12u as=0.1898p ps=1.36u w=0.74u l=0.13u
X1007 a_14753_10724# _260_.CLK _131_.Y GND.t543 sg13_lv_nmos ad=0.1406p pd=1.12u as=0.1406p ps=1.12u w=0.74u l=0.13u
X1008 VDD clkbuf_1_0__f_sclk.A a_3380_13690# VDD sg13_lv_pmos ad=0.2128p pd=1.5u as=0.2128p ps=1.5u w=1.12u l=0.13u
X1009 GND.t465 VDD GND.t678 GND.t677 sg13_lv_nmos ad=79.8f pd=0.8u as=0 ps=0 w=0.42u l=1u
X1010 GND.t1000 VDD GND.t1000 GND.t1002 sg13_lv_nmos ad=79.8f pd=0.8u as=0 ps=0 w=0.42u l=1u
X1011 VDD a_10415_13799# a_10672_13942# VDD sg13_lv_pmos ad=5.15485p pd=34.14u as=79.8f ps=0.8u w=0.42u l=0.13u
X1012 a_12106_12433# a_12549_12189# a_12489_12601# VDD sg13_lv_pmos ad=79.8f pd=0.8u as=63f ps=0.72u w=0.42u l=0.13u
X1013 VDD GND.t1000 VDD VDD sg13_lv_pmos ad=0.34p pd=2.68u as=0 ps=0 w=1u l=1u
X1014 a_14438_12210# a_15243_12332# a_14698_12433# VDD sg13_lv_pmos ad=0.1428p pd=1.52u as=79.8f ps=0.8u w=0.42u l=0.13u
X1015 VDD GND.t718 VDD VDD sg13_lv_pmos ad=0.34p pd=2.68u as=0 ps=0 w=1u l=1u
X1016 a_13100_13686# fanout6.A VDD VDD sg13_lv_pmos ad=0.2856p pd=2.36u as=0.2114p ps=1.54u w=0.84u l=0.13u
X1017 a_10764_5678# _139_.X VDD VDD sg13_lv_pmos ad=0.1596p pd=1.22u as=0.2891p ps=1.695u w=0.84u l=0.13u
X1018 GND.t348 VDD GND.t348 GND.t1134 sg13_lv_nmos ad=79.8f pd=0.8u as=0 ps=0 w=0.42u l=1u
X1019 a_14534_9186# _213_.Y VDD VDD sg13_lv_pmos ad=79.8f pd=0.8u as=0.1428p ps=1.52u w=0.42u l=0.13u
X1020 VDD en a_1192_11460# VDD sg13_lv_pmos ad=0.2114p pd=1.54u as=0.2856p ps=2.36u w=0.84u l=0.13u
X1021 VDD GND.t979 VDD VDD sg13_lv_pmos ad=0.34p pd=2.68u as=0 ps=0 w=1u l=1u
X1022 GND.t65 VDD GND.t65 GND.t613 sg13_lv_nmos ad=0.1428p pd=1.52u as=0 ps=0 w=0.42u l=1u
X1023 VDD a_16240_12430# a_16185_12525# VDD sg13_lv_pmos ad=1.42082p pd=9.125u as=93.45f ps=0.865u w=0.42u l=0.13u
X1024 VDD GND.t264 VDD VDD sg13_lv_pmos ad=0.19p pd=1.38u as=0 ps=0 w=1u l=1u
X1025 a_9828_17946# _214_.Y a_9734_17946# GND.t496 sg13_lv_nmos ad=60.89999f pd=0.71u as=0.1428p ps=1.52u w=0.42u l=0.13u
X1026 a_2661_12189# _247_.CLK GND.t249 GND.t480 sg13_lv_nmos ad=0.2516p pd=2.16u as=3.6571p ps=23.85u w=0.74u l=0.13u
X1027 _165_.Y _136_.A VDD VDD sg13_lv_pmos ad=0.2128p pd=1.5u as=0.3808p ps=2.92u w=1.12u l=0.13u
X1028 VDD GND.t901 VDD VDD sg13_lv_pmos ad=0.19p pd=1.38u as=0 ps=0 w=1u l=1u
X1029 a_5619_17044# _207_.A1 VDD VDD sg13_lv_pmos ad=0.1428p pd=1.375u as=0.2891p ps=1.695u w=1.12u l=0.13u
X1030 GND.t897 VDD GND.t897 GND.t931 sg13_lv_nmos ad=0.1428p pd=1.52u as=0 ps=0 w=0.42u l=1u
X1031 GND.t169 a_11279_9263# a_11946_9484# GND.t297 sg13_lv_nmos ad=0.1406p pd=1.12u as=0.2516p ps=2.16u w=0.74u l=0.13u
X1032 clkbuf_1_0__f_sclk.A a_3886_10702# GND.t1027 GND.t1451 sg13_lv_nmos ad=0.1406p pd=1.12u as=0.1406p ps=1.12u w=0.74u l=0.13u
X1033 GND.t5 VDD GND.t5 GND.t83 sg13_lv_nmos ad=79.8f pd=0.8u as=0 ps=0 w=0.42u l=1u
X1034 VDD _136_.A _173_.Y VDD sg13_lv_pmos ad=0.3808p pd=2.92u as=0.2128p ps=1.5u w=1.12u l=0.13u
X1035 GND.t121 VDD GND.t121 GND.t712 sg13_lv_nmos ad=79.8f pd=0.8u as=0 ps=0 w=0.42u l=1u
X1036 _201_.Y _199_.Y a_6508_15532# VDD sg13_lv_pmos ad=0.3808p pd=2.92u as=0.1176p ps=1.33u w=1.12u l=0.13u
X1037 VDD GND.t897 VDD VDD sg13_lv_pmos ad=0.19p pd=1.38u as=0 ps=0 w=1u l=1u
X1038 VDD GND.t26 VDD VDD sg13_lv_pmos ad=0.34p pd=2.68u as=0 ps=0 w=1u l=1u
X1039 VDD _226_.Y a_14438_5850# VDD sg13_lv_pmos ad=0.36237p pd=2.605u as=79.8f ps=0.8u w=0.42u l=0.13u
X1040 GND.t5 a_2171_6204# a_2608_6166# GND.t83 sg13_lv_nmos ad=0.148p pd=1.14u as=0.3367p ps=1.65u w=0.74u l=0.13u
X1041 GND.t836 VDD GND.t838 GND.t837 sg13_lv_nmos ad=79.8f pd=0.8u as=0 ps=0 w=0.42u l=1u
X1042 VDD GND.t1332 VDD VDD sg13_lv_pmos ad=0.34p pd=2.68u as=0 ps=0 w=1u l=1u
X1043 _182_.Y a_8352_11013# a_8501_10702# GND.t434 sg13_lv_nmos ad=0.2516p pd=2.16u as=0.1406p ps=1.12u w=0.74u l=0.13u
X1044 GND.t356 VDD GND.t1057 GND.t217 sg13_lv_nmos ad=0.1428p pd=1.52u as=0 ps=0 w=0.42u l=1u
X1045 GND.t1353 VDD GND.t1352 GND.t1351 sg13_lv_nmos ad=0.1428p pd=1.52u as=0 ps=0 w=0.42u l=1u
X1046 a_8564_5412# a_8538_5375# _145_.A2 VDD sg13_lv_pmos ad=0.2128p pd=1.5u as=0.3808p ps=2.92u w=1.12u l=0.13u
X1047 GND.t136 VDD GND.t136 GND.t998 sg13_lv_nmos ad=0.1428p pd=1.52u as=0 ps=0 w=0.42u l=1u
X1048 _258_.D a_7008_16035# a_7157_16366# GND.t14 sg13_lv_nmos ad=0.2516p pd=2.16u as=0.1406p ps=1.12u w=0.74u l=0.13u
X1049 a_9573_12189# _251_.CLK VDD VDD sg13_lv_pmos ad=0.4088p pd=2.97u as=1.42082p ps=9.125u w=1.12u l=0.13u
X1050 VDD _124_.S a_2075_5468# VDD sg13_lv_pmos ad=0.253p pd=1.53u as=0.2856p ps=2.36u w=0.84u l=0.13u
X1051 clkbuf_1_0__f_sclk.A a_3886_10702# VDD VDD sg13_lv_pmos ad=0.2128p pd=1.5u as=0.2128p ps=1.5u w=1.12u l=0.13u
X1052 GND.t1392 _214_.A _214_.Y GND.t1391 sg13_lv_nmos ad=0.2516p pd=2.16u as=0.2516p ps=2.16u w=0.74u l=0.13u
X1053 GND.t221 _193_.Y a_7553_14832# GND.t318 sg13_lv_nmos ad=0.2516p pd=2.16u as=0.1406p ps=1.12u w=0.74u l=0.13u
X1054 clkbuf_1_0__f_sclk.A a_3886_10702# GND.t1027 GND.t1447 sg13_lv_nmos ad=0.1406p pd=1.12u as=0.1406p ps=1.12u w=0.74u l=0.13u
X1055 a_3886_10702# sclk GND.t198 GND.t1424 sg13_lv_nmos ad=0.1406p pd=1.12u as=0.2516p ps=2.16u w=0.74u l=0.13u
X1056 GND.t845 VDD GND.t116 GND.t846 sg13_lv_nmos ad=79.8f pd=0.8u as=0 ps=0 w=0.42u l=1u
X1057 a_13617_4972# _145_.X VDD VDD sg13_lv_pmos ad=0.1225p pd=1.245u as=0.36p ps=2.72u w=1u l=0.13u
X1058 a_15237_8447# _251_.CLK GND.t21 GND.t539 sg13_lv_nmos ad=0.2516p pd=2.16u as=3.59495p ps=22.57u w=0.74u l=0.13u
X1059 GND.t1249 VDD GND.t1247 GND.t1248 sg13_lv_nmos ad=0.1428p pd=1.52u as=0 ps=0 w=0.42u l=1u
X1060 GND.t21 _260_.RESET_B a_14628_9186# GND.t467 sg13_lv_nmos ad=0.1626p pd=1.415u as=60.89999f ps=0.71u w=0.42u l=0.13u
X1061 GND.t703 VDD GND.t703 GND.t746 sg13_lv_nmos ad=79.8f pd=0.8u as=0 ps=0 w=0.42u l=1u
X1062 a_1862_13410# _119_.X VDD VDD sg13_lv_pmos ad=79.8f pd=0.8u as=0.1428p ps=1.52u w=0.42u l=0.13u
X1063 GND.t42 _178_.B1 a_6320_10296# GND.t41 sg13_lv_nmos ad=0.1371p pd=1.12u as=0.1216p ps=1.02u w=0.64u l=0.13u
X1064 GND.t592 a_15983_12287# a_16650_12508# GND.t591 sg13_lv_nmos ad=0.1406p pd=1.12u as=0.2516p ps=2.16u w=0.74u l=0.13u
X1065 VDD GND.t671 VDD VDD sg13_lv_pmos ad=0.34p pd=2.68u as=0 ps=0 w=1u l=1u
X1066 a_11652_16759# a_11364_17064# a_11590_16759# GND.t19 sg13_lv_nmos ad=0.1428p pd=1.52u as=37.8f ps=0.6u w=0.42u l=0.13u
X1067 _195_.Y _119_.A0 VDD VDD sg13_lv_pmos ad=0.2128p pd=1.5u as=0.3808p ps=2.92u w=1.12u l=0.13u
X1068 GND.t114 _199_.Y _201_.Y GND.t113 sg13_lv_nmos ad=0.2516p pd=2.16u as=0.1406p ps=1.12u w=0.74u l=0.13u
X1069 a_3300_4968# a_3274_4873# VDD VDD sg13_lv_pmos ad=0.34p pd=2.68u as=0.36237p ps=2.605u w=1u l=0.13u
X1070 GND.t63 en a_1192_11460# GND.t62 sg13_lv_nmos ad=0.14875p pd=1.16u as=0.187p ps=1.78u w=0.55u l=0.13u
X1071 a_7872_5451# _143_.A VDD VDD sg13_lv_pmos ad=0.1596p pd=1.22u as=0.4536p ps=2.76u w=0.84u l=0.13u
X1072 VDD GND.t315 VDD VDD sg13_lv_pmos ad=0.19p pd=1.38u as=0 ps=0 w=1u l=1u
X1073 GND.t871 VDD GND.t871 GND.t872 sg13_lv_nmos ad=79.8f pd=0.8u as=0 ps=0 w=0.42u l=1u
X1074 a_14724_12528# a_14698_12433# VDD VDD sg13_lv_pmos ad=0.34p pd=2.68u as=0.36237p ps=2.605u w=1u l=0.13u
X1075 _160_.B _162_.B a_13338_7690# GND.t267 sg13_lv_nmos ad=0.1628p pd=1.18u as=88.8f ps=0.98u w=0.74u l=0.13u
X1076 VDD GND.t708 VDD VDD sg13_lv_pmos ad=0.34p pd=2.68u as=0 ps=0 w=1u l=1u
X1077 _136_.A a_8488_8436# VDD VDD sg13_lv_pmos ad=0.42p pd=2.99u as=0.2114p ps=1.54u w=1.12u l=0.13u
X1078 a_2620_13726# _120_.A0 a_2126_13912# GND.t408 sg13_lv_nmos ad=0.13135p pd=1.095u as=0.1628p ps=1.18u w=0.74u l=0.13u
X1079 GND.t911 VDD GND.t321 GND.t46 sg13_lv_nmos ad=79.8f pd=0.8u as=0 ps=0 w=0.42u l=1u
X1080 VDD a_4559_5773# a_4816_5654# VDD sg13_lv_pmos ad=1.48542p pd=9.54u as=79.8f ps=0.8u w=0.42u l=0.13u
X1081 a_3300_5416# a_3274_5380# GND.t5 GND.t1495 sg13_lv_nmos ad=0.2516p pd=2.16u as=0.1626p ps=1.415u w=0.74u l=0.13u
X1082 clkbuf_1_0__f_sclk.A a_3886_10702# VDD VDD sg13_lv_pmos ad=0.2128p pd=1.5u as=0.2128p ps=1.5u w=1.12u l=0.13u
X1083 a_3886_10702# sclk VDD VDD sg13_lv_pmos ad=0.2128p pd=1.5u as=0.3808p ps=2.92u w=1.12u l=0.13u
X1084 a_13221_16007# _266_.CLK GND.t14 GND.t599 sg13_lv_nmos ad=0.2516p pd=2.16u as=2.6164p ps=16.515u w=0.74u l=0.13u
X1085 GND.t1221 a_13649_4704# _151_.X GND.t1422 sg13_lv_nmos ad=0.3108p pd=2.32u as=0.1628p ps=1.18u w=0.74u l=0.13u
X1086 _243_.CLK a_3956_6888# VDD VDD sg13_lv_pmos ad=0.2128p pd=1.5u as=0.2128p ps=1.5u w=1.12u l=0.13u
X1087 a_15861_16904# a_14919_16964# a_15722_16904# GND.t1513 sg13_lv_nmos ad=79.8f pd=0.8u as=0.2373p ps=1.97u w=0.42u l=0.13u
X1088 a_6890_9948# _177_.X VDD VDD sg13_lv_pmos ad=0.1176p pd=1.33u as=0.4032p ps=2.96u w=1.12u l=0.13u
X1089 GND.t315 _200_.Y a_6286_15276# GND.t336 sg13_lv_nmos ad=0.17255p pd=1.25u as=0.187p ps=1.78u w=0.55u l=0.13u
X1090 _160_.B a_13073_7728# a_13244_7972# VDD sg13_lv_pmos ad=0.3808p pd=2.92u as=0.2128p ps=1.5u w=1.12u l=0.13u
X1091 a_8236_8436# a_8014_8492# VDD VDD sg13_lv_pmos ad=0.1176p pd=1.33u as=0.2618p ps=1.63u w=1.12u l=0.13u
X1092 GND.t42 _178_.Y _179_.Y GND.t312 sg13_lv_nmos ad=0.2516p pd=2.16u as=0.1406p ps=1.12u w=0.74u l=0.13u
X1093 VDD GND.t307 VDD VDD sg13_lv_pmos ad=0.19p pd=1.38u as=0 ps=0 w=1u l=1u
X1094 a_2436_13397# a_2667_12983# a_2122_12940# GND.t1565 sg13_lv_nmos ad=0.2373p pd=1.97u as=79.8f ps=0.8u w=0.42u l=0.13u
X1095 GND.t1103 VDD GND.t1103 GND.t1136 sg13_lv_nmos ad=79.8f pd=0.8u as=0 ps=0 w=0.42u l=1u
X1096 VDD a_3956_6888# _243_.CLK VDD sg13_lv_pmos ad=0.2128p pd=1.5u as=0.2128p ps=1.5u w=1.12u l=0.13u
X1097 VDD a_3952_9406# a_3897_9501# VDD sg13_lv_pmos ad=1.94845p pd=12.685u as=93.45f ps=0.865u w=0.42u l=0.13u
X1098 VDD _237_.Y a_12518_16434# VDD sg13_lv_pmos ad=0.36237p pd=2.605u as=79.8f ps=0.8u w=0.42u l=0.13u
X1099 GND.t809 VDD GND.t809 GND.t855 sg13_lv_nmos ad=0.1428p pd=1.52u as=0 ps=0 w=0.42u l=1u
X1100 VDD GND.t1108 VDD VDD sg13_lv_pmos ad=0.19p pd=1.38u as=0 ps=0 w=1u l=1u
X1101 a_10901_7678# _154_.X GND.t348 GND.t347 sg13_lv_nmos ad=0.1406p pd=1.12u as=0.1898p ps=1.36u w=0.74u l=0.13u
X1102 VDD _222_.Y a_2122_16969# VDD sg13_lv_pmos ad=0.1563p pd=1.22u as=0.147p ps=1.54u w=0.42u l=0.13u
X1103 VDD _192_.B _192_.Y VDD sg13_lv_pmos ad=0.2128p pd=1.5u as=0.2128p ps=1.5u w=1.12u l=0.13u
X1104 a_5466_9202# _173_.A GND.t607 GND.t21 sg13_lv_nmos ad=88.8f pd=0.98u as=0.15245p ps=1.17u w=0.74u l=0.13u
X1105 VDD _181_.Y a_8352_11013# VDD sg13_lv_pmos ad=0.2891p pd=1.695u as=0.1596p ps=1.22u w=0.84u l=0.13u
X1106 GND.t26 VDD GND.t26 GND.t735 sg13_lv_nmos ad=0.1428p pd=1.52u as=0 ps=0 w=0.42u l=1u
X1107 a_3717_4629# _243_.CLK VDD VDD sg13_lv_pmos ad=0.4088p pd=2.97u as=1.42082p ps=9.125u w=1.12u l=0.13u
X1108 VDD a_2565_16007# a_2667_16007# VDD sg13_lv_pmos ad=1.6291p pd=10.53u as=0.3864p ps=2.93u w=1.12u l=0.13u
X1109 VDD GND.t1337 VDD VDD sg13_lv_pmos ad=0.34p pd=2.68u as=0 ps=0 w=1u l=1u
X1110 GND.t226 VDD GND.t1170 GND.t5 sg13_lv_nmos ad=79.8f pd=0.8u as=0 ps=0 w=0.42u l=1u
X1111 VDD GND.t792 VDD VDD sg13_lv_pmos ad=0.34p pd=2.68u as=0 ps=0 w=1u l=1u
X1112 VDD a_16079_11821# a_16746_11460# VDD sg13_lv_pmos ad=0.2128p pd=1.5u as=0.3864p ps=2.93u w=1.12u l=0.13u
X1113 _205_.Y _191_.Y a_6862_15260# GND.t617 sg13_lv_nmos ad=0.2516p pd=2.16u as=0.1406p ps=1.12u w=0.74u l=0.13u
X1114 GND.t1358 VDD GND.t1357 GND.t1356 sg13_lv_nmos ad=0.1428p pd=1.52u as=0 ps=0 w=0.42u l=1u
X1115 GND.t279 clkbuf_1_0__f_sclk.A a_3956_6888# GND.t280 sg13_lv_nmos ad=0.1406p pd=1.12u as=0.1406p ps=1.12u w=0.74u l=0.13u
X1116 a_2985_3947# a_2628_3904# VDD VDD sg13_lv_pmos ad=63f pd=0.72u as=0.1563p ps=1.22u w=0.42u l=0.13u
X1117 a_9994_9409# a_10437_9165# a_9734_9186# GND.t21 sg13_lv_nmos ad=79.8f pd=0.8u as=0.1296p ps=1.52u w=0.42u l=0.13u
X1118 VDD rst a_1192_17508# VDD sg13_lv_pmos ad=0.2114p pd=1.54u as=0.2856p ps=2.36u w=0.84u l=0.13u
X1119 VDD a_3380_13690# _247_.CLK VDD sg13_lv_pmos ad=0.2128p pd=1.5u as=0.2128p ps=1.5u w=1.12u l=0.13u
X1120 VDD a_1580_12936# _215_.A VDD sg13_lv_pmos ad=0.2114p pd=1.54u as=0.42p ps=2.99u w=1.12u l=0.13u
X1121 VDD a_12215_7664# _164_.B1 VDD sg13_lv_pmos ad=0.3808p pd=2.92u as=0.2128p ps=1.5u w=1.12u l=0.13u
X1122 VDD _196_.Y a_5333_15532# VDD sg13_lv_pmos ad=0.2128p pd=1.5u as=0.3808p ps=2.92u w=1.12u l=0.13u
X1123 GND.t718 VDD GND.t718 GND.t158 sg13_lv_nmos ad=0.1428p pd=1.52u as=0 ps=0 w=0.42u l=1u
X1124 _263_.CLK a_16266_15532# GND.t247 GND.t246 sg13_lv_nmos ad=0.2516p pd=2.16u as=0.1406p ps=1.12u w=0.74u l=0.13u
X1125 GND.t26 VDD GND.t26 GND.t680 sg13_lv_nmos ad=79.8f pd=0.8u as=0 ps=0 w=0.42u l=1u
X1126 _243_.CLK a_3956_6888# GND.t569 GND.t572 sg13_lv_nmos ad=0.1406p pd=1.12u as=0.1406p ps=1.12u w=0.74u l=0.13u
X1127 VDD _202_.Y a_7008_16035# VDD sg13_lv_pmos ad=0.2891p pd=1.695u as=0.1596p ps=1.22u w=0.84u l=0.13u
X1128 VDD GND.t671 VDD VDD sg13_lv_pmos ad=0.34p pd=2.68u as=0 ps=0 w=1u l=1u
X1129 GND.t980 VDD GND.t979 GND.t978 sg13_lv_nmos ad=0.1428p pd=1.52u as=0 ps=0 w=0.42u l=1u
X1130 GND.t812 VDD GND.t809 GND.t811 sg13_lv_nmos ad=0.1428p pd=1.52u as=0 ps=0 w=0.42u l=1u
X1131 VDD _148_.B _187_.Y VDD sg13_lv_pmos ad=0.3808p pd=2.92u as=0.2128p ps=1.5u w=1.12u l=0.13u
X1132 a_10415_12287# a_9573_12189# a_10321_12287# GND.t549 sg13_lv_nmos ad=0.12665p pd=1.145u as=0.1428p ps=1.52u w=0.42u l=0.13u
X1133 GND.t1343 VDD GND.t1342 GND.t1341 sg13_lv_nmos ad=0.1428p pd=1.52u as=0 ps=0 w=0.42u l=1u
X1134 VDD _244_.RESET_B a_3014_5850# VDD sg13_lv_pmos ad=0.36237p pd=2.605u as=79.8f ps=0.8u w=0.42u l=0.13u
X1135 _173_.A a_4362_9484# VDD VDD sg13_lv_pmos ad=0.3808p pd=2.92u as=0.2128p ps=1.5u w=1.12u l=0.13u
X1136 a_2148_12976# a_2667_12983# a_3407_13333# GND.t46 sg13_lv_nmos ad=0.3473p pd=2.71u as=0.12665p ps=1.145u w=0.74u l=0.13u
X1137 a_14438_5850# a_15243_5423# a_14698_5380# VDD sg13_lv_pmos ad=0.1428p pd=1.52u as=79.8f ps=0.8u w=0.42u l=0.13u
X1138 GND.t469 VDD GND.t1207 GND.t1203 sg13_lv_nmos ad=0.1428p pd=1.52u as=0 ps=0 w=0.42u l=1u
X1139 a_6299_11808# _176_.A GND.t256 GND.t1460 sg13_lv_nmos ad=78.39999f pd=0.885u as=0.2272p ps=1.99u w=0.64u l=0.13u
X1140 GND.t26 VDD GND.t687 GND.t686 sg13_lv_nmos ad=79.8f pd=0.8u as=0 ps=0 w=0.42u l=1u
X1141 GND.t569 a_3956_6888# _243_.CLK GND.t568 sg13_lv_nmos ad=0.1406p pd=1.12u as=0.1406p ps=1.12u w=0.74u l=0.13u
X1142 GND.t77 VDD GND.t77 GND.t1012 sg13_lv_nmos ad=79.8f pd=0.8u as=0 ps=0 w=0.42u l=1u
X1143 VDD a_3407_16357# a_4074_15996# VDD sg13_lv_pmos ad=0.2128p pd=1.5u as=0.3864p ps=2.93u w=1.12u l=0.13u
X1144 GND.t261 _258_.RESET_B a_7716_16434# GND.t1406 sg13_lv_nmos ad=0.1626p pd=1.415u as=60.89999f ps=0.71u w=0.42u l=0.13u
X1145 VDD a_3380_13690# _247_.CLK VDD sg13_lv_pmos ad=0.2128p pd=1.5u as=0.2128p ps=1.5u w=1.12u l=0.13u
X1146 a_13391_12287# a_12549_12189# a_12132_12528# VDD sg13_lv_pmos ad=0.2048p pd=1.63u as=0.34p ps=2.68u w=1u l=0.13u
X1147 VDD a_14240_16921# _135_.A VDD sg13_lv_pmos ad=0.2128p pd=1.5u as=0.3808p ps=2.92u w=1.12u l=0.13u
X1148 VDD a_3695_8797# a_4362_8436# VDD sg13_lv_pmos ad=0.2128p pd=1.5u as=0.3864p ps=2.93u w=1.12u l=0.13u
X1149 VDD GND.t726 VDD VDD sg13_lv_pmos ad=0.34p pd=2.68u as=0 ps=0 w=1u l=1u
X1150 GND.t956 VDD GND.t256 GND.t957 sg13_lv_nmos ad=0.1428p pd=1.52u as=0 ps=0 w=0.42u l=1u
X1151 VDD GND.t703 VDD VDD sg13_lv_pmos ad=0.19p pd=1.38u as=0 ps=0 w=1u l=1u
X1152 GND.t1162 VDD GND.t1163 GND.t5 sg13_lv_nmos ad=79.8f pd=0.8u as=0 ps=0 w=0.42u l=1u
X1153 GND.t715 VDD GND.t716 GND.t712 sg13_lv_nmos ad=79.8f pd=0.8u as=0 ps=0 w=0.42u l=1u
X1154 a_13042_16746# _241_.Y GND.t177 GND.t516 sg13_lv_nmos ad=37.8f pd=0.6u as=79.8f ps=0.8u w=0.42u l=0.13u
X1155 VDD GND.t26 VDD VDD sg13_lv_pmos ad=0.34p pd=2.68u as=0 ps=0 w=1u l=1u
X1156 VDD a_8325_16007# a_8427_16007# VDD sg13_lv_pmos ad=1.6291p pd=10.53u as=0.3864p ps=2.93u w=1.12u l=0.13u
X1157 GND.t956 a_5297_12264# _176_.B GND.t1399 sg13_lv_nmos ad=0.3108p pd=2.32u as=0.1628p ps=1.18u w=0.74u l=0.13u
X1158 VDD GND.t253 VDD VDD sg13_lv_pmos ad=0.19p pd=1.38u as=0 ps=0 w=1u l=1u
X1159 a_9363_9484# _164_.Y VDD VDD sg13_lv_pmos ad=0.1428p pd=1.375u as=0.2891p ps=1.695u w=1.12u l=0.13u
X1160 GND.t4 a_16079_11821# a_16746_11460# GND.t3 sg13_lv_nmos ad=0.1406p pd=1.12u as=0.2516p ps=2.16u w=0.74u l=0.13u
X1161 GND.t375 a_3380_13690# _247_.CLK GND.t46 sg13_lv_nmos ad=0.1406p pd=1.12u as=0.1406p ps=1.12u w=0.74u l=0.13u
X1162 a_2724_8861# a_2955_8447# a_2410_8404# GND.t165 sg13_lv_nmos ad=0.2373p pd=1.97u as=79.8f ps=0.8u w=0.42u l=0.13u
X1163 GND.t693 VDD GND.t693 GND.t739 sg13_lv_nmos ad=0.1428p pd=1.52u as=0 ps=0 w=0.42u l=1u
X1164 a_11536_9406# a_11279_9263# a_11698_9186# GND.t296 sg13_lv_nmos ad=0.1428p pd=1.52u as=37.8f ps=0.6u w=0.42u l=0.13u
X1165 a_11078_16746# a_11883_16868# a_11338_16969# VDD sg13_lv_pmos ad=0.1428p pd=1.52u as=79.8f ps=0.8u w=0.42u l=0.13u
X1166 a_8196_16421# a_7908_16000# a_8134_16421# GND.t327 sg13_lv_nmos ad=0.1428p pd=1.52u as=37.8f ps=0.6u w=0.42u l=0.13u
X1167 a_13092_16421# a_13323_16007# a_12778_15964# GND.t236 sg13_lv_nmos ad=0.2373p pd=1.97u as=79.8f ps=0.8u w=0.42u l=0.13u
X1168 a_3014_4650# a_3819_4772# a_3274_4873# VDD sg13_lv_pmos ad=0.1428p pd=1.52u as=79.8f ps=0.8u w=0.42u l=0.13u
X1169 VDD GND.t264 VDD VDD sg13_lv_pmos ad=0.34p pd=2.68u as=0 ps=0 w=1u l=1u
X1170 VDD GND.t557 VDD VDD sg13_lv_pmos ad=0.34p pd=2.68u as=0 ps=0 w=1u l=1u
X1171 GND.t136 _179_.Y a_8506_10318# GND.t137 sg13_lv_nmos ad=0.2516p pd=2.16u as=0.1406p ps=1.12u w=0.74u l=0.13u
X1172 GND.t404 VDD GND.t404 GND.t942 sg13_lv_nmos ad=79.8f pd=0.8u as=0 ps=0 w=0.42u l=1u
X1173 a_9444_13735# a_9156_14040# a_9382_13735# GND.t163 sg13_lv_nmos ad=0.1428p pd=1.52u as=37.8f ps=0.6u w=0.42u l=0.13u
X1174 GND.t46 a_2565_12983# a_2667_12983# GND.t1431 sg13_lv_nmos ad=7.09257p pd=45.595u as=0.2516p ps=2.16u w=0.74u l=0.13u
X1175 VDD GND.t402 VDD VDD sg13_lv_pmos ad=0.19p pd=1.38u as=0 ps=0 w=1u l=1u
X1176 VDD GND.t687 VDD VDD sg13_lv_pmos ad=0.34p pd=2.68u as=0 ps=0 w=1u l=1u
X1177 a_3380_13690# clkbuf_1_0__f_sclk.A VDD VDD sg13_lv_pmos ad=0.2128p pd=1.5u as=0.2128p ps=1.5u w=1.12u l=0.13u
X1178 GND.t1172 VDD GND.t470 GND.t5 sg13_lv_nmos ad=79.8f pd=0.8u as=0 ps=0 w=0.42u l=1u
X1179 GND.t949 a_3503_12287# a_4170_12508# GND.t1487 sg13_lv_nmos ad=0.1406p pd=1.12u as=0.2516p ps=2.16u w=0.74u l=0.13u
X1180 a_11846_12210# a_12651_12332# a_12106_12433# VDD sg13_lv_pmos ad=0.1428p pd=1.52u as=79.8f ps=0.8u w=0.42u l=0.13u
X1181 _227_.Y _225_.A.t3 GND.t21 GND.t73 sg13_lv_nmos ad=0.2516p pd=2.16u as=0.2516p ps=2.16u w=0.74u l=0.13u
X1182 GND.t1328 VDD GND.t1327 GND.t1326 sg13_lv_nmos ad=0.1428p pd=1.52u as=0 ps=0 w=0.42u l=1u
X1183 _209_.Y _208_.X a_6963_17044# VDD sg13_lv_pmos ad=0.2408p pd=1.55u as=0.1428p ps=1.375u w=1.12u l=0.13u
X1184 a_10995_7972# _166_.A VDD VDD sg13_lv_pmos ad=0.1428p pd=1.375u as=0.2891p ps=1.695u w=1.12u l=0.13u
X1185 a_4114_9186# _219_.Y GND.t450 GND.t21 sg13_lv_nmos ad=37.8f pd=0.6u as=79.8f ps=0.8u w=0.42u l=0.13u
X1186 VDD GND.t703 VDD VDD sg13_lv_pmos ad=0.34p pd=2.68u as=0 ps=0 w=1u l=1u
X1187 VDD GND.t716 VDD VDD sg13_lv_pmos ad=0.34p pd=2.68u as=0 ps=0 w=1u l=1u
X1188 a_5249_16344# _207_.A1 _207_.Y GND.t14 sg13_lv_nmos ad=0.1406p pd=1.12u as=0.1406p ps=1.12u w=0.74u l=0.13u
X1189 VDD a_13648_12430# a_13593_12525# VDD sg13_lv_pmos ad=1.42082p pd=9.125u as=93.45f ps=0.865u w=0.42u l=0.13u
X1190 _252_.D a_7872_5451# a_8021_5782# GND.t5 sg13_lv_nmos ad=0.2516p pd=2.16u as=0.1406p ps=1.12u w=0.74u l=0.13u
X1191 GND.t9 a_16336_11702# a_15985_11821# GND.t3 sg13_lv_nmos ad=79.8f pd=0.8u as=0.1428p ps=1.52u w=0.42u l=0.13u
X1192 VDD GND.t307 VDD VDD sg13_lv_pmos ad=0.34p pd=2.68u as=0 ps=0 w=1u l=1u
X1193 GND.t321 VDD GND.t915 GND.t914 sg13_lv_nmos ad=79.8f pd=0.8u as=0 ps=0 w=0.42u l=1u
X1194 _189_.X a_4913_13330# a_5084_12972# VDD sg13_lv_pmos ad=0.3808p pd=2.92u as=0.2128p ps=1.5u w=1.12u l=0.13u
X1195 GND.t79 _136_.A a_10769_4258# GND.t604 sg13_lv_nmos ad=0.15245p pd=1.17u as=0.17462p ps=1.185u w=0.55u l=0.13u
X1196 GND.t15 _205_.Y a_6869_16750# GND.t14 sg13_lv_nmos ad=0.1898p pd=1.36u as=0.2516p ps=2.16u w=0.74u l=0.13u
X1197 _148_.X a_12401_4704# a_12572_4948# VDD sg13_lv_pmos ad=0.3808p pd=2.92u as=0.2128p ps=1.5u w=1.12u l=0.13u
X1198 GND.t794 VDD GND.t792 GND.t831 sg13_lv_nmos ad=0.1428p pd=1.52u as=0 ps=0 w=0.42u l=1u
X1199 VDD GND.t1177 VDD VDD sg13_lv_pmos ad=0.19p pd=1.38u as=0 ps=0 w=1u l=1u
X1200 a_3380_13690# clkbuf_1_0__f_sclk.A VDD VDD sg13_lv_pmos ad=0.2128p pd=1.5u as=0.2128p ps=1.5u w=1.12u l=0.13u
X1201 a_13073_5770# _147_.Y GND.t602 GND.t5 sg13_lv_nmos ad=0.17462p pd=1.185u as=0.374p ps=2.46u w=0.55u l=0.13u
X1202 a_3897_8559# a_2955_8447# a_3695_8797# VDD sg13_lv_pmos ad=93.45f pd=0.865u as=0.2048p ps=1.63u w=0.42u l=0.13u
X1203 VDD GND.t495 VDD VDD sg13_lv_pmos ad=0.34p pd=2.68u as=0 ps=0 w=1u l=1u
X1204 VDD _219_.Y a_2410_9409# VDD sg13_lv_pmos ad=0.1563p pd=1.22u as=0.147p ps=1.54u w=0.42u l=0.13u
X1205 a_10308_17933# a_10020_17512# a_10246_17933# GND.t129 sg13_lv_nmos ad=0.1428p pd=1.52u as=37.8f ps=0.6u w=0.42u l=0.13u
X1206 a_2126_15424# _119_.A0 a_2298_15532# VDD sg13_lv_pmos ad=0.2225p pd=1.445u as=0.2975p ps=1.595u w=1u l=0.13u
X1207 VDD GND.t890 VDD VDD sg13_lv_pmos ad=0.19p pd=1.38u as=0 ps=0 w=1u l=1u
X1208 _258_.D _202_.Y a_7251_15996# VDD sg13_lv_pmos ad=0.2408p pd=1.55u as=0.1428p ps=1.375u w=1.12u l=0.13u
X1209 a_14794_9409# a_15237_9165# a_14534_9186# GND.t70 sg13_lv_nmos ad=79.8f pd=0.8u as=0.1296p ps=1.52u w=0.42u l=0.13u
X1210 _145_.X a_8557_4248# VDD VDD sg13_lv_pmos ad=0.2128p pd=1.5u as=0.3808p ps=2.92u w=1.12u l=0.13u
X1211 GND.t188 VDD GND.t188 GND.t1117 sg13_lv_nmos ad=79.8f pd=0.8u as=0 ps=0 w=0.42u l=1u
X1212 GND.t5 a_3717_5423# a_3819_5423# GND.t53 sg13_lv_nmos ad=7.07497p pd=46.475u as=0.2516p ps=2.16u w=0.74u l=0.13u
X1213 GND.t1094 VDD GND.t1094 GND.t1121 sg13_lv_nmos ad=0.1428p pd=1.52u as=0 ps=0 w=0.42u l=1u
X1214 GND.t1186 VDD GND.t1187 GND.t5 sg13_lv_nmos ad=79.8f pd=0.8u as=0 ps=0 w=0.42u l=1u
X1215 VDD GND.t1152 VDD VDD sg13_lv_pmos ad=0.19p pd=1.38u as=0 ps=0 w=1u l=1u
X1216 a_2298_17878# a_2232_17770# GND.t26 GND.t25 sg13_lv_nmos ad=0.3367p pd=1.65u as=0.148p ps=1.14u w=0.74u l=0.13u
X1217 _247_.CLK a_3380_13690# GND.t377 GND.t46 sg13_lv_nmos ad=0.1406p pd=1.12u as=0.1406p ps=1.12u w=0.74u l=0.13u
X1218 VDD a_4816_4870# a_4761_4965# VDD sg13_lv_pmos ad=1.48542p pd=9.54u as=93.45f ps=0.865u w=0.42u l=0.13u
X1219 _226_.Y _225_.A.t1 VDD VDD sg13_lv_pmos ad=0.3808p pd=2.92u as=0.3808p ps=2.92u w=1.12u l=0.13u
X1220 a_12804_16000# a_13323_16007# a_14063_16357# GND.t58 sg13_lv_nmos ad=0.3473p pd=2.71u as=0.12665p ps=1.145u w=0.74u l=0.13u
X1221 VDD GND.t803 VDD VDD sg13_lv_pmos ad=0.19p pd=1.38u as=0 ps=0 w=1u l=1u
X1222 VDD GND.t146 VDD VDD sg13_lv_pmos ad=0.19p pd=1.38u as=0 ps=0 w=1u l=1u
X1223 GND.t819 VDD GND.t819 GND.t864 sg13_lv_nmos ad=0.1428p pd=1.52u as=0 ps=0 w=0.42u l=1u
X1224 GND.t1165 VDD GND.t1166 GND.t5 sg13_lv_nmos ad=79.8f pd=0.8u as=0 ps=0 w=0.42u l=1u
X1225 VDD a_2171_6204# a_2671_6460# VDD sg13_lv_pmos ad=0.2198p pd=1.52u as=0.2975p ps=1.595u w=1u l=0.13u
X1226 GND.t885 VDD GND.t618 GND.t46 sg13_lv_nmos ad=0.1428p pd=1.52u as=0 ps=0 w=0.42u l=1u
X1227 a_2232_10210# _124_.S GND.t198 GND.t201 sg13_lv_nmos ad=0.187p pd=1.78u as=0.18945p ps=1.27u w=0.55u l=0.13u
X1228 VDD a_9573_12189# a_9675_12332# VDD sg13_lv_pmos ad=1.42082p pd=9.125u as=0.3864p ps=2.93u w=1.12u l=0.13u
X1229 VDD GND.t1027 VDD VDD sg13_lv_pmos ad=0.34p pd=2.68u as=0 ps=0 w=1u l=1u
X1230 GND.t1027 VDD GND.t1027 GND.t1029 sg13_lv_nmos ad=0.1428p pd=1.52u as=0 ps=0 w=0.42u l=1u
X1231 a_3300_4968# a_3819_4772# a_4559_4727# GND.t325 sg13_lv_nmos ad=0.3473p pd=2.71u as=0.12665p ps=1.145u w=0.74u l=0.13u
X1232 a_14054_15234# a_14859_15356# a_14314_15457# VDD sg13_lv_pmos ad=0.1428p pd=1.52u as=79.8f ps=0.8u w=0.42u l=0.13u
X1233 _131_.A2 a_16650_12508# GND.t592 GND.t591 sg13_lv_nmos ad=0.2516p pd=2.16u as=0.1406p ps=1.12u w=0.74u l=0.13u
X1234 GND.t1103 VDD GND.t1103 GND.t1137 sg13_lv_nmos ad=0.1428p pd=1.52u as=0 ps=0 w=0.42u l=1u
X1235 VDD GND.t1108 VDD VDD sg13_lv_pmos ad=0.34p pd=2.68u as=0 ps=0 w=1u l=1u
X1236 GND.t951 VDD GND.t949 GND.t950 sg13_lv_nmos ad=0.1428p pd=1.52u as=0 ps=0 w=0.42u l=1u
X1237 GND.t342 VDD GND.t1224 GND.t1223 sg13_lv_nmos ad=79.8f pd=0.8u as=0 ps=0 w=0.42u l=1u
X1238 GND.t703 VDD GND.t703 GND.t702 sg13_lv_nmos ad=0.1428p pd=1.52u as=0 ps=0 w=0.42u l=1u
X1239 _200_.Y _199_.B1 VDD VDD sg13_lv_pmos ad=0.2128p pd=1.5u as=0.3808p ps=2.92u w=1.12u l=0.13u
X1240 GND.t221 VDD GND.t800 GND.t848 sg13_lv_nmos ad=79.8f pd=0.8u as=0 ps=0 w=0.42u l=1u
X1241 a_9765_4629# _251_.CLK GND.t234 GND.t1469 sg13_lv_nmos ad=0.2516p pd=2.16u as=4.10715p ps=27.105u w=0.74u l=0.13u
X1242 a_8386_3900# _143_.Y VDD VDD sg13_lv_pmos ad=0.2125p pd=1.425u as=0.19p ps=1.38u w=1u l=0.13u
X1243 VDD GND.t1194 VDD VDD sg13_lv_pmos ad=0.19p pd=1.38u as=0 ps=0 w=1u l=1u
X1244 a_10437_17519# freq_in VDD VDD sg13_lv_pmos ad=0.4088p pd=2.97u as=1.30717p ps=8.395u w=1.12u l=0.13u
X1245 a_16185_12525# a_15243_12332# a_15983_12287# VDD sg13_lv_pmos ad=93.45f pd=0.865u as=0.2048p ps=1.63u w=0.42u l=0.13u
X1246 VDD GND.t1309 VDD VDD sg13_lv_pmos ad=0.19p pd=1.38u as=0 ps=0 w=1u l=1u
X1247 a_16336_9406# a_16079_9263# a_16498_9186# GND.t72 sg13_lv_nmos ad=0.1428p pd=1.52u as=37.8f ps=0.6u w=0.42u l=0.13u
X1248 GND.t14 a_13221_16007# a_13323_16007# GND.t581 sg13_lv_nmos ad=2.85425p pd=18.015u as=0.2516p ps=2.16u w=0.74u l=0.13u
X1249 GND.t55 _126_.B1 a_13985_11808# GND.t445 sg13_lv_nmos ad=0.2516p pd=2.16u as=0.1406p ps=1.12u w=0.74u l=0.13u
X1250 a_7251_10296# _184_.Y GND.t42 GND.t594 sg13_lv_nmos ad=0.1406p pd=1.12u as=0.2516p ps=2.16u w=0.74u l=0.13u
X1251 VDD GND.t136 VDD VDD sg13_lv_pmos ad=0.34p pd=2.68u as=0 ps=0 w=1u l=1u
X1252 GND.t391 a_10672_13942# a_10321_13799# GND.t1507 sg13_lv_nmos ad=79.8f pd=0.8u as=0.1428p ps=1.52u w=0.42u l=0.13u
X1253 a_9573_13701# fanout7.A GND.t46 GND.t1521 sg13_lv_nmos ad=0.2516p pd=2.16u as=7.09257p ps=45.595u w=0.74u l=0.13u
X1254 a_10308_9199# a_10020_9504# a_10246_9199# GND.t21 sg13_lv_nmos ad=0.1428p pd=1.52u as=37.8f ps=0.6u w=0.42u l=0.13u
X1255 _207_.A2 fanout6.A a_4755_17508# VDD sg13_lv_pmos ad=0.2408p pd=1.55u as=0.1428p ps=1.375u w=1.12u l=0.13u
X1256 VDD clkbuf_1_0__f_sclk.A a_3956_6888# VDD sg13_lv_pmos ad=0.2128p pd=1.5u as=0.2128p ps=1.5u w=1.12u l=0.13u
X1257 a_2148_17064# a_2122_16969# GND.t144 GND.t143 sg13_lv_nmos ad=0.2516p pd=2.16u as=0.1626p ps=1.415u w=0.74u l=0.13u
X1258 GND.t557 VDD GND.t557 GND.t1085 sg13_lv_nmos ad=0.1428p pd=1.52u as=0 ps=0 w=0.42u l=1u
X1259 GND.t264 _161_.Y a_12685_7700# GND.t1462 sg13_lv_nmos ad=0.2516p pd=2.16u as=94.35f ps=0.995u w=0.74u l=0.13u
X1260 a_11731_8698# _164_.B1 GND.t169 GND.t503 sg13_lv_nmos ad=0.1216p pd=1.02u as=0.15745p ps=1.175u w=0.64u l=0.13u
X1261 _207_.B1 fanout6.A a_4684_15996# VDD sg13_lv_pmos ad=0.3808p pd=2.92u as=0.1176p ps=1.33u w=1.12u l=0.13u
X1262 _192_.Y _187_.Y VDD VDD sg13_lv_pmos ad=0.3808p pd=2.92u as=0.2128p ps=1.5u w=1.12u l=0.13u
X1263 VDD a_13391_12287# a_14058_12508# VDD sg13_lv_pmos ad=0.2128p pd=1.5u as=0.3864p ps=2.93u w=1.12u l=0.13u
X1264 a_10672_13942# a_10415_13799# a_10834_13722# GND.t1383 sg13_lv_nmos ad=0.1428p pd=1.52u as=37.8f ps=0.6u w=0.42u l=0.13u
X1265 a_9156_12528# a_9675_12332# a_10415_12287# GND.t216 sg13_lv_nmos ad=0.3473p pd=2.71u as=0.12665p ps=1.145u w=0.74u l=0.13u
X1266 VDD _256_.RESET_B a_8870_12210# VDD sg13_lv_pmos ad=0.36237p pd=2.605u as=79.8f ps=0.8u w=0.42u l=0.13u
X1267 a_6485_11830# _176_.B GND.t256 GND.t255 sg13_lv_nmos ad=0.1406p pd=1.12u as=0.1898p ps=1.36u w=0.74u l=0.13u
X1268 GND.t253 VDD GND.t253 GND.t959 sg13_lv_nmos ad=79.8f pd=0.8u as=0 ps=0 w=0.42u l=1u
X1269 GND.t767 VDD GND.t766 GND.t10 sg13_lv_nmos ad=0.1428p pd=1.52u as=0 ps=0 w=0.42u l=1u
X1270 VDD GND.t42 VDD VDD sg13_lv_pmos ad=0.19p pd=1.38u as=0 ps=0 w=1u l=1u
X1271 VDD GND.t510 VDD VDD sg13_lv_pmos ad=0.19p pd=1.38u as=0 ps=0 w=1u l=1u
X1272 a_10220_18222# _225_.A GND.t121 GND.t120 sg13_lv_nmos ad=0.187p pd=1.78u as=0.14875p ps=1.16u w=0.55u l=0.13u
X1273 a_8870_13722# a_9675_13844# a_9130_13945# VDD sg13_lv_pmos ad=0.1428p pd=1.52u as=79.8f ps=0.8u w=0.42u l=0.13u
X1274 VDD GND.t923 VDD VDD sg13_lv_pmos ad=0.19p pd=1.38u as=0 ps=0 w=1u l=1u
X1275 a_13740_5678# _148_.X VDD VDD sg13_lv_pmos ad=0.1596p pd=1.22u as=0.2891p ps=1.695u w=0.84u l=0.13u
X1276 _243_.CLK a_3956_6888# VDD VDD sg13_lv_pmos ad=0.2128p pd=1.5u as=0.2128p ps=1.5u w=1.12u l=0.13u
X1277 GND.t715 VDD GND.t121 GND.t712 sg13_lv_nmos ad=0.1428p pd=1.52u as=0 ps=0 w=0.42u l=1u
X1278 VDD a_3045_3911# a_3147_3911# VDD sg13_lv_pmos ad=5.15485p pd=34.14u as=0.3864p ps=2.93u w=1.12u l=0.13u
X1279 VDD GND.t1294 VDD VDD sg13_lv_pmos ad=0.19p pd=1.38u as=0 ps=0 w=1u l=1u
X1280 GND.t829 VDD GND.t792 GND.t830 sg13_lv_nmos ad=79.8f pd=0.8u as=0 ps=0 w=0.42u l=1u
X1281 _170_.Y _165_.Y VDD VDD sg13_lv_pmos ad=0.3808p pd=2.92u as=0.2128p ps=1.5u w=1.12u l=0.13u
X1282 a_7622_16434# _258_.D VDD VDD sg13_lv_pmos ad=79.8f pd=0.8u as=0.1428p ps=1.52u w=0.42u l=0.13u
X1283 VDD a_10864_4870# a_10809_4965# VDD sg13_lv_pmos ad=1.48542p pd=9.54u as=93.45f ps=0.865u w=0.42u l=0.13u
X1284 GND.t1119 VDD GND.t557 GND.t1120 sg13_lv_nmos ad=79.8f pd=0.8u as=0 ps=0 w=0.42u l=1u
X1285 GND.t1312 VDD GND.t1314 GND.t1313 sg13_lv_nmos ad=79.8f pd=0.8u as=0 ps=0 w=0.42u l=1u
X1286 VDD GND.t198 VDD VDD sg13_lv_pmos ad=0.19p pd=1.38u as=0 ps=0 w=1u l=1u
X1287 GND.t418 a_5201_9240# _168_.B GND.t21 sg13_lv_nmos ad=0.3108p pd=2.32u as=0.1628p ps=1.18u w=0.74u l=0.13u
X1288 a_5297_12264# _148_.B a_5265_12532# VDD sg13_lv_pmos ad=0.34p pd=2.68u as=0.1225p ps=1.245u w=1u l=0.13u
X1289 VDD GND.t1157 VDD VDD sg13_lv_pmos ad=0.19p pd=1.38u as=0 ps=0 w=1u l=1u
X1290 a_10672_12430# _256_.RESET_B VDD VDD sg13_lv_pmos ad=79.8f pd=0.8u as=1.42082p ps=9.125u w=0.42u l=0.13u
X1291 GND.t402 VDD GND.t402 GND.t965 sg13_lv_nmos ad=79.8f pd=0.8u as=0 ps=0 w=0.42u l=1u
X1292 a_6836_3900# _136_.A VDD VDD sg13_lv_pmos ad=0.3808p pd=2.92u as=0.2128p ps=1.5u w=1.12u l=0.13u
X1293 _154_.X _136_.A a_8250_7690# GND.t611 sg13_lv_nmos ad=0.1628p pd=1.18u as=88.8f ps=0.98u w=0.74u l=0.13u
X1294 a_7008_16035# _202_.Y a_6971_16344# GND.t14 sg13_lv_nmos ad=0.2176p pd=1.96u as=78.39999f ps=0.885u w=0.64u l=0.13u
X1295 GND.t800 VDD GND.t800 GND.t801 sg13_lv_nmos ad=79.8f pd=0.8u as=0 ps=0 w=0.42u l=1u
X1296 GND.t1163 VDD GND.t1164 GND.t5 sg13_lv_nmos ad=79.8f pd=0.8u as=0 ps=0 w=0.42u l=1u
X1297 a_14148_15234# _135_.A a_14054_15234# GND.t1506 sg13_lv_nmos ad=60.89999f pd=0.71u as=0.1428p ps=1.52u w=0.42u l=0.13u
X1298 GND.t131 a_10415_12287# a_11082_12508# GND.t1567 sg13_lv_nmos ad=0.1406p pd=1.12u as=0.2516p ps=2.16u w=0.74u l=0.13u
X1299 VDD a_3956_6888# _243_.CLK VDD sg13_lv_pmos ad=0.2128p pd=1.5u as=0.2128p ps=1.5u w=1.12u l=0.13u
X1300 a_5468_12508# _148_.B VDD VDD sg13_lv_pmos ad=0.2128p pd=1.5u as=0.2128p ps=1.5u w=1.12u l=0.13u
X1301 a_11034_4258# _243_.Q GND.t79 GND.t645 sg13_lv_nmos ad=88.8f pd=0.98u as=0.15245p ps=1.17u w=0.74u l=0.13u
X1302 a_9348_4968# a_9867_4772# a_10607_4727# GND.t1579 sg13_lv_nmos ad=0.3473p pd=2.71u as=0.12665p ps=1.145u w=0.74u l=0.13u
X1303 VDD GND.t1068 VDD VDD sg13_lv_pmos ad=0.34p pd=2.68u as=0 ps=0 w=1u l=1u
X1304 VDD GND.t764 VDD VDD sg13_lv_pmos ad=0.34p pd=2.68u as=0 ps=0 w=1u l=1u
X1305 _145_.B1 _144_.B a_9290_3900# VDD sg13_lv_pmos ad=0.3808p pd=2.92u as=0.1176p ps=1.33u w=1.12u l=0.13u
X1306 VDD GND.t671 VDD VDD sg13_lv_pmos ad=0.34p pd=2.68u as=0 ps=0 w=1u l=1u
X1307 VDD GND.t689 VDD VDD sg13_lv_pmos ad=0.34p pd=2.68u as=0 ps=0 w=1u l=1u
X1308 _154_.X a_7985_7728# a_8156_7972# VDD sg13_lv_pmos ad=0.3808p pd=2.92u as=0.2128p ps=1.5u w=1.12u l=0.13u
X1309 a_2298_9972# a_2232_10210# VDD VDD sg13_lv_pmos ad=0.2975p pd=1.595u as=0.2198p ps=1.52u w=1u l=0.13u
X1310 a_6756_4663# a_6987_4772# a_6442_4873# GND.t651 sg13_lv_nmos ad=0.2373p pd=1.97u as=79.8f ps=0.8u w=0.42u l=0.13u
X1311 GND.t703 VDD GND.t703 GND.t747 sg13_lv_nmos ad=0.1428p pd=1.52u as=0 ps=0 w=0.42u l=1u
X1312 _152_.X a_12237_5760# VDD VDD sg13_lv_pmos ad=0.3808p pd=2.92u as=0.1918p ps=1.5u w=1.12u l=0.13u
X1313 _164_.Y _164_.B1 GND.t169 GND.t501 sg13_lv_nmos ad=0.1406p pd=1.12u as=0.1406p ps=1.12u w=0.74u l=0.13u
X1314 VDD GND.t885 VDD VDD sg13_lv_pmos ad=0.34p pd=2.68u as=0 ps=0 w=1u l=1u
X1315 VDD GND.t37 VDD VDD sg13_lv_pmos ad=0.34p pd=2.68u as=0 ps=0 w=1u l=1u
X1316 VDD GND.t519 VDD VDD sg13_lv_pmos ad=0.34p pd=2.68u as=0 ps=0 w=1u l=1u
X1317 a_16240_12430# a_15983_12287# a_16402_12210# GND.t241 sg13_lv_nmos ad=0.1428p pd=1.52u as=37.8f ps=0.6u w=0.42u l=0.13u
X1318 GND.t1224 VDD GND.t1227 GND.t1226 sg13_lv_nmos ad=79.8f pd=0.8u as=0 ps=0 w=0.42u l=1u
X1319 GND.t671 VDD GND.t671 GND.t1052 sg13_lv_nmos ad=79.8f pd=0.8u as=0 ps=0 w=0.42u l=1u
X1320 VDD GND.t697 VDD VDD sg13_lv_pmos ad=0.34p pd=2.68u as=0 ps=0 w=1u l=1u
X1321 VDD GND.t718 VDD VDD sg13_lv_pmos ad=0.19p pd=1.38u as=0 ps=0 w=1u l=1u
X1322 VDD GND.t114 VDD VDD sg13_lv_pmos ad=0.34p pd=2.68u as=0 ps=0 w=1u l=1u
X1323 GND.t359 a_1580_12936# _215_.A GND.t358 sg13_lv_nmos ad=0.14875p pd=1.16u as=0.2886p ps=2.26u w=0.74u l=0.13u
X1324 _157_.Y _147_.Y GND.t292 GND.t1474 sg13_lv_nmos ad=0.1406p pd=1.12u as=0.2516p ps=2.16u w=0.74u l=0.13u
X1325 VDD GND.t917 VDD VDD sg13_lv_pmos ad=0.34p pd=2.68u as=0 ps=0 w=1u l=1u
X1326 a_2298_7678# a_2232_7868# GND.t188 GND.t1488 sg13_lv_nmos ad=0.3367p pd=1.65u as=0.148p ps=1.14u w=0.74u l=0.13u
X1327 VDD _218_.Y a_2150_8874# VDD sg13_lv_pmos ad=0.36237p pd=2.605u as=79.8f ps=0.8u w=0.42u l=0.13u
X1328 GND.t1159 VDD GND.t508 GND.t5 sg13_lv_nmos ad=79.8f pd=0.8u as=0 ps=0 w=0.42u l=1u
X1329 _164_.Y _145_.X a_10989_8784# GND.t328 sg13_lv_nmos ad=0.1406p pd=1.12u as=0.1406p ps=1.12u w=0.74u l=0.13u
X1330 VDD GND.t1197 VDD VDD sg13_lv_pmos ad=0.19p pd=1.38u as=0 ps=0 w=1u l=1u
X1331 _125_.A1 a_1192_7712# GND.t57 GND.t56 sg13_lv_nmos ad=0.2886p pd=2.26u as=0.14875p ps=1.16u w=0.74u l=0.13u
X1332 GND.t1006 VDD GND.t1006 GND.t1042 sg13_lv_nmos ad=79.8f pd=0.8u as=0 ps=0 w=0.42u l=1u
X1333 a_8100_16746# _209_.Y a_8006_16746# GND.t14 sg13_lv_nmos ad=60.89999f pd=0.71u as=0.1428p ps=1.52u w=0.42u l=0.13u
X1334 _145_.X a_8557_4248# GND.t37 GND.t74 sg13_lv_nmos ad=0.1406p pd=1.12u as=0.2516p ps=2.16u w=0.74u l=0.13u
X1335 a_5147_15996# _207_.B1 _207_.Y VDD sg13_lv_pmos ad=0.2128p pd=1.5u as=0.3808p ps=2.92u w=1.12u l=0.13u
X1336 VDD GND.t870 VDD VDD sg13_lv_pmos ad=0.34p pd=2.68u as=0 ps=0 w=1u l=1u
X1337 a_2916_4325# a_2628_3904# a_2854_4325# GND.t38 sg13_lv_nmos ad=0.1428p pd=1.52u as=37.8f ps=0.6u w=0.42u l=0.13u
X1338 VDD GND.t1279 VDD VDD sg13_lv_pmos ad=0.19p pd=1.38u as=0 ps=0 w=1u l=1u
X1339 VDD _151_.B a_13184_7183# VDD sg13_lv_pmos ad=0.2856p pd=2.36u as=0.1596p ps=1.22u w=0.84u l=0.13u
X1340 GND.t229 VDD GND.t228 GND.t5 sg13_lv_nmos ad=0.1428p pd=1.52u as=0 ps=0 w=0.42u l=1u
X1341 VDD _186_.Y a_7451_14484# VDD sg13_lv_pmos ad=0.2128p pd=1.5u as=0.2128p ps=1.5u w=1.12u l=0.13u
X1342 VDD GND.t953 VDD VDD sg13_lv_pmos ad=0.19p pd=1.38u as=0 ps=0 w=1u l=1u
X1343 GND.t1180 VDD GND.t1181 GND.t5 sg13_lv_nmos ad=79.8f pd=0.8u as=0 ps=0 w=0.42u l=1u
X1344 GND.t557 VDD GND.t557 GND.t1087 sg13_lv_nmos ad=0.1428p pd=1.52u as=0 ps=0 w=0.42u l=1u
X1345 GND.t77 VDD GND.t77 GND.t1048 sg13_lv_nmos ad=79.8f pd=0.8u as=0 ps=0 w=0.42u l=1u
X1346 GND.t980 VDD GND.t146 GND.t145 sg13_lv_nmos ad=79.8f pd=0.8u as=0 ps=0 w=0.42u l=1u
X1347 _243_.Q a_4554_3900# VDD VDD sg13_lv_pmos ad=0.3808p pd=2.92u as=0.2128p ps=1.5u w=1.12u l=0.13u
X1348 _211_.Y _264_.Q GND.t1438 GND.t58 sg13_lv_nmos ad=0.2516p pd=2.16u as=0.2516p ps=2.16u w=0.74u l=0.13u
X1349 VDD GND.t247 VDD VDD sg13_lv_pmos ad=0.34p pd=2.68u as=0 ps=0 w=1u l=1u
X1350 GND.t42 VDD GND.t42 GND.t991 sg13_lv_nmos ad=79.8f pd=0.8u as=0 ps=0 w=0.42u l=1u
X1351 VDD GND.t1316 VDD VDD sg13_lv_pmos ad=0.34p pd=2.68u as=0 ps=0 w=1u l=1u
X1352 VDD a_3695_9263# a_3952_9406# VDD sg13_lv_pmos ad=1.94845p pd=12.685u as=79.8f ps=0.8u w=0.42u l=0.13u
X1353 VDD GND.t806 VDD VDD sg13_lv_pmos ad=0.19p pd=1.38u as=0 ps=0 w=1u l=1u
X1354 a_15108_9199# a_14820_9504# a_15046_9199# GND.t2 sg13_lv_nmos ad=0.1428p pd=1.52u as=37.8f ps=0.6u w=0.42u l=0.13u
X1355 _120_.A0 a_4170_12508# GND.t949 GND.t1533 sg13_lv_nmos ad=0.2516p pd=2.16u as=0.1406p ps=1.12u w=0.74u l=0.13u
X1356 a_13100_13686# fanout6.A GND.t108 GND.t1411 sg13_lv_nmos ad=0.187p pd=1.78u as=0.14875p ps=1.16u w=0.55u l=0.13u
X1357 VDD _124_.S a_2075_4692# VDD sg13_lv_pmos ad=0.253p pd=1.53u as=0.2856p ps=2.36u w=0.84u l=0.13u
X1358 a_10617_14037# a_9675_13844# a_10415_13799# VDD sg13_lv_pmos ad=93.45f pd=0.865u as=0.2048p ps=1.63u w=0.42u l=0.13u
X1359 VDD a_3407_13333# a_3664_13214# VDD sg13_lv_pmos ad=1.42082p pd=9.125u as=79.8f ps=0.8u w=0.42u l=0.13u
X1360 GND.t37 a_7727_4727# a_8394_4948# GND.t536 sg13_lv_nmos ad=0.1406p pd=1.12u as=0.2516p ps=2.16u w=0.74u l=0.13u
X1361 VDD a_16079_9263# a_16746_9484# VDD sg13_lv_pmos ad=0.2128p pd=1.5u as=0.3864p ps=2.93u w=1.12u l=0.13u
X1362 VDD a_9120_9501# _172_.Y VDD sg13_lv_pmos ad=0.3808p pd=2.92u as=0.2408p ps=1.55u w=1.12u l=0.13u
X1363 a_3407_16357# a_2565_16007# a_2148_16000# VDD sg13_lv_pmos ad=0.2048p pd=1.63u as=0.34p ps=2.68u w=1u l=0.13u
X1364 GND.t703 VDD GND.t703 GND.t706 sg13_lv_nmos ad=79.8f pd=0.8u as=0 ps=0 w=0.42u l=1u
X1365 VDD _225_.A.t4 _228_.Y VDD sg13_lv_pmos ad=0.3808p pd=2.92u as=0.3808p ps=2.92u w=1.12u l=0.13u
X1366 a_10246_17933# _240_.Y GND.t121 GND.t554 sg13_lv_nmos ad=37.8f pd=0.6u as=0.1701p ps=1.65u w=0.42u l=0.13u
X1367 VDD GND.t1227 VDD VDD sg13_lv_pmos ad=0.34p pd=2.68u as=0 ps=0 w=1u l=1u
X1368 VDD _237_.Y a_12778_15964# VDD sg13_lv_pmos ad=0.1563p pd=1.22u as=0.147p ps=1.54u w=0.42u l=0.13u
X1369 a_7753_15280# _201_.Y GND.t221 GND.t220 sg13_lv_nmos ad=0.1216p pd=1.02u as=0.1331p ps=1.12u w=0.64u l=0.13u
X1370 a_14698_12433# a_15141_12189# a_14438_12210# GND.t454 sg13_lv_nmos ad=79.8f pd=0.8u as=0.1296p ps=1.52u w=0.42u l=0.13u
X1371 VDD GND.t1325 VDD VDD sg13_lv_pmos ad=0.19p pd=1.38u as=0 ps=0 w=1u l=1u
X1372 a_13073_7728# _162_.B a_13041_7996# VDD sg13_lv_pmos ad=0.34p pd=2.68u as=0.1225p ps=1.245u w=1u l=0.13u
X1373 GND.t21 a_2853_8447# a_2955_8447# GND.t436 sg13_lv_nmos ad=4.0443p pd=25.39u as=0.2516p ps=2.16u w=0.74u l=0.13u
X1374 GND.t37 _144_.B _145_.B1 GND.t406 sg13_lv_nmos ad=0.2516p pd=2.16u as=0.1406p ps=1.12u w=0.74u l=0.13u
X1375 GND.t188 VDD GND.t188 GND.t1115 sg13_lv_nmos ad=79.8f pd=0.8u as=0 ps=0 w=0.42u l=1u
X1376 VDD _171_.Y a_9120_9501# VDD sg13_lv_pmos ad=0.2891p pd=1.695u as=0.1596p ps=1.22u w=0.84u l=0.13u
X1377 _133_.Y _132_.Y a_13527_11460# VDD sg13_lv_pmos ad=0.3808p pd=2.92u as=0.2128p ps=1.5u w=1.12u l=0.13u
X1378 VDD _211_.Y a_15767_17137# VDD sg13_lv_pmos ad=0.1428p pd=1.52u as=79.8f ps=0.8u w=0.42u l=0.13u
X1379 GND.t726 VDD GND.t726 GND.t712 sg13_lv_nmos ad=79.8f pd=0.8u as=0 ps=0 w=0.42u l=1u
X1380 a_2148_17064# a_2667_16868# a_3407_16823# GND.t14 sg13_lv_nmos ad=0.3473p pd=2.71u as=0.12665p ps=1.145u w=0.74u l=0.13u
X1381 VDD a_14940_16710# a_15963_17137# VDD sg13_lv_pmos ad=0.1563p pd=1.22u as=63f ps=0.72u w=0.42u l=0.13u
X1382 VDD GND.t972 VDD VDD sg13_lv_pmos ad=0.34p pd=2.68u as=0 ps=0 w=1u l=1u
X1383 VDD a_6720_17061# _209_.Y VDD sg13_lv_pmos ad=0.3808p pd=2.92u as=0.2408p ps=1.55u w=1.12u l=0.13u
X1384 a_4559_4727# a_3717_4629# a_4465_4727# GND.t351 sg13_lv_nmos ad=0.12665p pd=1.145u as=0.1428p ps=1.52u w=0.42u l=0.13u
X1385 _143_.Y _143_.A VDD VDD sg13_lv_pmos ad=0.3808p pd=2.92u as=0.3808p ps=2.92u w=1.12u l=0.13u
X1386 VDD a_7616_15437# _205_.B1 VDD sg13_lv_pmos ad=0.1918p pd=1.5u as=0.3808p ps=2.92u w=1.12u l=0.13u
X1387 VDD _165_.Y a_7739_9484# VDD sg13_lv_pmos ad=0.2128p pd=1.5u as=0.2128p ps=1.5u w=1.12u l=0.13u
X1388 a_2126_10214# _122_.A0 a_2298_9972# VDD sg13_lv_pmos ad=0.2225p pd=1.445u as=0.2975p ps=1.595u w=1u l=0.13u
X1389 _200_.Y _195_.Y a_6008_15242# GND.t179 sg13_lv_nmos ad=0.2516p pd=2.16u as=0.1406p ps=1.12u w=0.74u l=0.13u
X1390 VDD GND.t897 VDD VDD sg13_lv_pmos ad=0.19p pd=1.38u as=0 ps=0 w=1u l=1u
X1391 a_5169_9508# _173_.A VDD VDD sg13_lv_pmos ad=0.1225p pd=1.245u as=0.36p ps=2.72u w=1u l=0.13u
X1392 VDD GND.t1284 VDD VDD sg13_lv_pmos ad=0.19p pd=1.38u as=0 ps=0 w=1u l=1u
X1393 GND.t1177 VDD GND.t1176 GND.t5 sg13_lv_nmos ad=0.1428p pd=1.52u as=0 ps=0 w=0.42u l=1u
X1394 VDD GND.t139 VDD VDD sg13_lv_pmos ad=0.19p pd=1.38u as=0 ps=0 w=1u l=1u
X1395 GND.t173 a_3407_16823# a_4074_17044# GND.t14 sg13_lv_nmos ad=0.1406p pd=1.12u as=0.2516p ps=2.16u w=0.74u l=0.13u
X1396 GND.t391 VDD GND.t923 GND.t922 sg13_lv_nmos ad=79.8f pd=0.8u as=0 ps=0 w=0.42u l=1u
X1397 GND.t430 _151_.B a_13505_8784# GND.t429 sg13_lv_nmos ad=0.2516p pd=2.16u as=0.1406p ps=1.12u w=0.74u l=0.13u
X1398 GND.t718 VDD GND.t716 GND.t712 sg13_lv_nmos ad=0.1428p pd=1.52u as=0 ps=0 w=0.42u l=1u
X1399 a_11078_16746# _212_.Y VDD VDD sg13_lv_pmos ad=79.8f pd=0.8u as=0.1428p ps=1.52u w=0.42u l=0.13u
X1400 VDD _136_.A a_7262_3900# VDD sg13_lv_pmos ad=0.36p pd=2.72u as=0.1225p ps=1.245u w=1u l=0.13u
X1401 GND.t1302 VDD GND.t1304 GND.t1303 sg13_lv_nmos ad=79.8f pd=0.8u as=0 ps=0 w=0.42u l=1u
X1402 a_7908_16000# a_7882_15964# VDD VDD sg13_lv_pmos ad=0.34p pd=2.68u as=0.36237p ps=2.605u w=1u l=0.13u
X1403 VDD a_7008_16035# _258_.D VDD sg13_lv_pmos ad=0.3808p pd=2.92u as=0.2408p ps=1.55u w=1.12u l=0.13u
X1404 GND.t1263 VDD GND.t286 GND.t1264 sg13_lv_nmos ad=79.8f pd=0.8u as=0 ps=0 w=0.42u l=1u
X1405 GND.t1183 VDD GND.t1184 GND.t5 sg13_lv_nmos ad=79.8f pd=0.8u as=0 ps=0 w=0.42u l=1u
X1406 clkbuf_1_0__f_sclk.A a_3886_10702# GND.t1027 GND.t1443 sg13_lv_nmos ad=0.1406p pd=1.12u as=0.1406p ps=1.12u w=0.74u l=0.13u
X1407 a_4559_4727# a_3717_4629# a_3300_4968# VDD sg13_lv_pmos ad=0.2048p pd=1.63u as=0.34p ps=2.68u w=1u l=0.13u
X1408 GND.t1233 VDD GND.t119 GND.t1232 sg13_lv_nmos ad=0.1428p pd=1.52u as=0 ps=0 w=0.42u l=1u
X1409 a_10799_5782# a_10764_5678# _144_.B GND.t5 sg13_lv_nmos ad=0.1406p pd=1.12u as=0.2516p ps=2.16u w=0.74u l=0.13u
X1410 VDD GND.t1224 VDD VDD sg13_lv_pmos ad=0.34p pd=2.68u as=0 ps=0 w=1u l=1u
X1411 _196_.Y _190_.A a_6106_13726# GND.t46 sg13_lv_nmos ad=0.2516p pd=2.16u as=0.1406p ps=1.12u w=0.74u l=0.13u
X1412 a_13338_7690# _153_.Y GND.t264 GND.t461 sg13_lv_nmos ad=88.8f pd=0.98u as=0.15245p ps=1.17u w=0.74u l=0.13u
X1413 a_13985_11808# _131_.A2 _129_.Y GND.t110 sg13_lv_nmos ad=0.1406p pd=1.12u as=0.1406p ps=1.12u w=0.74u l=0.13u
X1414 GND.t169 a_11731_8698# _180_.X GND.t648 sg13_lv_nmos ad=0.15745p pd=1.175u as=0.2351p ps=2.16u w=0.74u l=0.13u
X1415 a_15856_15454# _239_.Y VDD VDD sg13_lv_pmos ad=79.8f pd=0.8u as=1.6291p ps=10.53u w=0.42u l=0.13u
X1416 VDD GND.t825 VDD VDD sg13_lv_pmos ad=0.34p pd=2.68u as=0 ps=0 w=1u l=1u
X1417 a_13824_7989# _158_.Y a_13787_7720# GND.t658 sg13_lv_nmos ad=0.2176p pd=1.96u as=78.39999f ps=0.885u w=0.64u l=0.13u
X1418 GND.t14 _266_.CLK a_15071_17016# GND.t210 sg13_lv_nmos ad=2.6164p pd=16.515u as=0.2516p ps=2.16u w=0.74u l=0.13u
X1419 GND.t234 a_6885_4629# a_6987_4772# GND.t1557 sg13_lv_nmos ad=4.7917p pd=31.625u as=0.2516p ps=2.16u w=0.74u l=0.13u
X1420 a_14830_16746# a_14572_16746# GND.t59 GND.t209 sg13_lv_nmos ad=0.1428p pd=1.52u as=79.8f ps=0.8u w=0.42u l=0.13u
X1421 GND.t770 VDD GND.t214 GND.t14 sg13_lv_nmos ad=0.1428p pd=1.52u as=0 ps=0 w=0.42u l=1u
X1422 VDD a_15983_12287# a_16650_12508# VDD sg13_lv_pmos ad=0.2128p pd=1.5u as=0.3864p ps=2.93u w=1.12u l=0.13u
X1423 clkbuf_1_0__f_sclk.A a_3886_10702# VDD VDD sg13_lv_pmos ad=0.2128p pd=1.5u as=0.2128p ps=1.5u w=1.12u l=0.13u
X1424 a_3503_12287# a_2661_12189# a_2244_12528# VDD sg13_lv_pmos ad=0.2048p pd=1.63u as=0.34p ps=2.68u w=1u l=0.13u
X1425 a_13593_12525# a_12651_12332# a_13391_12287# VDD sg13_lv_pmos ad=93.45f pd=0.865u as=0.2048p ps=1.63u w=0.42u l=0.13u
X1426 a_15012_5837# a_14724_5416# a_14950_5837# GND.t383 sg13_lv_nmos ad=0.1428p pd=1.52u as=37.8f ps=0.6u w=0.42u l=0.13u
X1427 a_8870_12210# _182_.Y VDD VDD sg13_lv_pmos ad=79.8f pd=0.8u as=0.1428p ps=1.52u w=0.42u l=0.13u
X1428 a_13914_5412# _148_.X _157_.B VDD sg13_lv_pmos ad=0.1428p pd=1.375u as=0.2408p ps=1.55u w=1.12u l=0.13u
X1429 _258_.RESET_B _222_.A GND.t219 GND.t14 sg13_lv_nmos ad=0.2516p pd=2.16u as=0.2516p ps=2.16u w=0.74u l=0.13u
X1430 _147_.Y _147_.B1 a_11381_3900# VDD sg13_lv_pmos ad=0.3808p pd=2.92u as=0.2128p ps=1.5u w=1.12u l=0.13u
X1431 _159_.Y a_13824_7989# a_13973_7678# GND.t18 sg13_lv_nmos ad=0.2516p pd=2.16u as=0.1406p ps=1.12u w=0.74u l=0.13u
X1432 VDD GND.t1027 VDD VDD sg13_lv_pmos ad=0.34p pd=2.68u as=0 ps=0 w=1u l=1u
X1433 a_3886_10702# sclk GND.t1025 GND.t1428 sg13_lv_nmos ad=0.1406p pd=1.12u as=0.1406p ps=1.12u w=0.74u l=0.13u
X1434 VDD GND.t697 VDD VDD sg13_lv_pmos ad=0.34p pd=2.68u as=0 ps=0 w=1u l=1u
X1435 a_16498_8874# _227_.Y GND.t303 GND.t72 sg13_lv_nmos ad=37.8f pd=0.6u as=79.8f ps=0.8u w=0.42u l=0.13u
X1436 VDD GND.t57 VDD VDD sg13_lv_pmos ad=0.19p pd=1.38u as=0 ps=0 w=1u l=1u
X1437 VDD GND.t292 VDD VDD sg13_lv_pmos ad=0.19p pd=1.38u as=0 ps=0 w=1u l=1u
X1438 GND.t788 VDD GND.t787 GND.t786 sg13_lv_nmos ad=0.1428p pd=1.52u as=0 ps=0 w=0.42u l=1u
X1439 VDD GND.t1158 VDD VDD sg13_lv_pmos ad=0.34p pd=2.68u as=0 ps=0 w=1u l=1u
X1440 VDD GND.t100 VDD VDD sg13_lv_pmos ad=0.34p pd=2.68u as=0 ps=0 w=1u l=1u
X1441 GND.t46 a_9573_13701# a_9675_13844# GND.t1536 sg13_lv_nmos ad=7.09257p pd=45.595u as=0.2516p ps=2.16u w=0.74u l=0.13u
X1442 GND.t951 VDD GND.t953 GND.t952 sg13_lv_nmos ad=79.8f pd=0.8u as=0 ps=0 w=0.42u l=1u
X1443 a_6336_11499# _176_.A VDD VDD sg13_lv_pmos ad=0.1596p pd=1.22u as=0.4536p ps=2.76u w=0.84u l=0.13u
X1444 VDD GND.t726 VDD VDD sg13_lv_pmos ad=0.19p pd=1.38u as=0 ps=0 w=1u l=1u
X1445 _243_.CLK a_3956_6888# GND.t557 GND.t556 sg13_lv_nmos ad=0.1406p pd=1.12u as=0.2516p ps=2.16u w=0.74u l=0.13u
X1446 VDD GND.t100 VDD VDD sg13_lv_pmos ad=0.34p pd=2.68u as=0 ps=0 w=1u l=1u
X1447 a_3886_10702# sclk VDD VDD sg13_lv_pmos ad=0.2128p pd=1.5u as=0.2128p ps=1.5u w=1.12u l=0.13u
X1448 GND.t342 VDD GND.t342 GND.t1257 sg13_lv_nmos ad=79.8f pd=0.8u as=0 ps=0 w=0.42u l=1u
X1449 a_14359_16710# a_14919_16964# a_14830_17061# VDD sg13_lv_pmos ad=0.2048p pd=1.63u as=93.45f ps=0.865u w=0.42u l=0.13u
X1450 VDD a_15599_15311# a_16266_15532# VDD sg13_lv_pmos ad=0.2128p pd=1.5u as=0.3864p ps=2.93u w=1.12u l=0.13u
X1451 VDD _261_.RESET_B a_11846_12210# VDD sg13_lv_pmos ad=0.36237p pd=2.605u as=79.8f ps=0.8u w=0.42u l=0.13u
X1452 VDD a_2075_4692# a_2575_4948# VDD sg13_lv_pmos ad=0.2198p pd=1.52u as=0.2975p ps=1.595u w=1u l=0.13u
X1453 a_11279_17869# a_10437_17519# a_10020_17512# VDD sg13_lv_pmos ad=0.2048p pd=1.63u as=0.34p ps=2.68u w=1u l=0.13u
X1454 VDD GND.t1370 VDD VDD sg13_lv_pmos ad=0.19p pd=1.38u as=0 ps=0 w=1u l=1u
X1455 GND.t792 VDD GND.t792 GND.t791 sg13_lv_nmos ad=0.1428p pd=1.52u as=0 ps=0 w=0.42u l=1u
X1456 GND.t77 VDD GND.t77 GND.t1050 sg13_lv_nmos ad=79.8f pd=0.8u as=0 ps=0 w=0.42u l=1u
X1457 GND.t198 _124_.S a_2620_10318# GND.t197 sg13_lv_nmos ad=0.18945p pd=1.27u as=0.13135p ps=1.095u w=0.74u l=0.13u
X1458 VDD a_4512_17547# _207_.A2 VDD sg13_lv_pmos ad=0.3808p pd=2.92u as=0.2408p ps=1.55u w=1.12u l=0.13u
X1459 _168_.B a_5201_9240# a_5372_9484# VDD sg13_lv_pmos ad=0.3808p pd=2.92u as=0.2128p ps=1.5u w=1.12u l=0.13u
X1460 GND.t904 VDD GND.t901 GND.t903 sg13_lv_nmos ad=0.1428p pd=1.52u as=0 ps=0 w=0.42u l=1u
X1461 a_1958_12210# a_2763_12332# a_2218_12433# VDD sg13_lv_pmos ad=0.1428p pd=1.52u as=79.8f ps=0.8u w=0.42u l=0.13u
X1462 VDD a_10415_12287# a_10672_12430# VDD sg13_lv_pmos ad=1.42082p pd=9.125u as=79.8f ps=0.8u w=0.42u l=0.13u
X1463 a_2854_4325# _243_.RESET_B GND.t119 GND.t423 sg13_lv_nmos ad=37.8f pd=0.6u as=0.1701p ps=1.65u w=0.42u l=0.13u
X1464 VDD GND.t1289 VDD VDD sg13_lv_pmos ad=0.19p pd=1.38u as=0 ps=0 w=1u l=1u
X1465 _238_.Y _225_.A VDD VDD sg13_lv_pmos ad=0.3808p pd=2.92u as=0.3808p ps=2.92u w=1.12u l=0.13u
X1466 _176_.B a_5297_12264# a_5468_12508# VDD sg13_lv_pmos ad=0.3808p pd=2.92u as=0.2128p ps=1.5u w=1.12u l=0.13u
X1467 GND.t1162 VDD GND.t1161 GND.t5 sg13_lv_nmos ad=0.1428p pd=1.52u as=0 ps=0 w=0.42u l=1u
X1468 _164_.B1 a_12215_7664# GND.t23 GND.t22 sg13_lv_nmos ad=0.1406p pd=1.12u as=0.2516p ps=2.16u w=0.74u l=0.13u
X1469 VDD GND.t1199 VDD VDD sg13_lv_pmos ad=0.34p pd=2.68u as=0 ps=0 w=1u l=1u
X1470 VDD a_3760_12430# a_3705_12525# VDD sg13_lv_pmos ad=1.42082p pd=9.125u as=93.45f ps=0.865u w=0.42u l=0.13u
X1471 a_9734_9186# _172_.Y VDD VDD sg13_lv_pmos ad=79.8f pd=0.8u as=0.1428p ps=1.52u w=0.42u l=0.13u
X1472 a_2150_9186# a_2955_9308# a_2410_9409# VDD sg13_lv_pmos ad=0.1428p pd=1.52u as=79.8f ps=0.8u w=0.42u l=0.13u
X1473 VDD GND.t674 VDD VDD sg13_lv_pmos ad=0.19p pd=1.38u as=0 ps=0 w=1u l=1u
X1474 GND.t1000 VDD GND.t1000 GND.t1037 sg13_lv_nmos ad=0.1428p pd=1.52u as=0 ps=0 w=0.42u l=1u
X1475 a_13648_12430# a_13391_12287# a_13810_12210# GND.t551 sg13_lv_nmos ad=0.1428p pd=1.52u as=37.8f ps=0.6u w=0.42u l=0.13u
X1476 a_11536_9406# _228_.Y VDD VDD sg13_lv_pmos ad=79.8f pd=0.8u as=1.94845p ps=12.685u w=0.42u l=0.13u
X1477 GND.t781 VDD GND.t397 GND.t782 sg13_lv_nmos ad=79.8f pd=0.8u as=0 ps=0 w=0.42u l=1u
X1478 GND.t1183 VDD GND.t1182 GND.t5 sg13_lv_nmos ad=0.1428p pd=1.52u as=0 ps=0 w=0.42u l=1u
X1479 a_15237_8447# _251_.CLK VDD VDD sg13_lv_pmos ad=0.4088p pd=2.97u as=2.75005p ps=18.05u w=1.12u l=0.13u
X1480 _242_.RESET_B _215_.A GND.t354 GND.t353 sg13_lv_nmos ad=0.2516p pd=2.16u as=0.2516p ps=2.16u w=0.74u l=0.13u
X1481 a_3657_5459# a_3300_5416# VDD VDD sg13_lv_pmos ad=63f pd=0.72u as=0.1563p ps=1.22u w=0.42u l=0.13u
X1482 GND.t800 VDD GND.t800 GND.t849 sg13_lv_nmos ad=0.1428p pd=1.52u as=0 ps=0 w=0.42u l=1u
X1483 VDD GND.t190 VDD VDD sg13_lv_pmos ad=0.34p pd=2.68u as=0 ps=0 w=1u l=1u
X1484 a_13775_5782# _149_.A GND.t181 GND.t5 sg13_lv_nmos ad=0.2516p pd=2.16u as=0.1898p ps=1.36u w=0.74u l=0.13u
X1485 a_8266_16969# a_8709_16725# a_8649_17137# VDD sg13_lv_pmos ad=79.8f pd=0.8u as=63f ps=0.72u w=0.42u l=0.13u
X1486 VDD a_16336_8678# a_16281_8559# VDD sg13_lv_pmos ad=2.75005p pd=18.05u as=93.45f ps=0.865u w=0.42u l=0.13u
X1487 a_8990_5412# _144_.B a_8538_5375# VDD sg13_lv_pmos ad=0.1225p pd=1.245u as=0.34p ps=2.68u w=1u l=0.13u
X1488 a_14697_15625# a_14340_15552# VDD VDD sg13_lv_pmos ad=63f pd=0.72u as=0.1563p ps=1.22u w=0.42u l=0.13u
X1489 a_10607_4727# a_9765_4629# a_9348_4968# VDD sg13_lv_pmos ad=0.2048p pd=1.63u as=0.34p ps=2.68u w=1u l=0.13u
X1490 GND.t14 a_2565_16725# a_2667_16868# GND.t96 sg13_lv_nmos ad=2.85425p pd=18.015u as=0.2516p ps=2.16u w=0.74u l=0.13u
X1491 GND.t973 VDD GND.t972 GND.t971 sg13_lv_nmos ad=0.1428p pd=1.52u as=0 ps=0 w=0.42u l=1u
X1492 VDD a_3380_13690# _247_.CLK VDD sg13_lv_pmos ad=0.2128p pd=1.5u as=0.2128p ps=1.5u w=1.12u l=0.13u
X1493 a_2232_11722# _124_.S GND.t190 GND.t189 sg13_lv_nmos ad=0.187p pd=1.78u as=0.18945p ps=1.27u w=0.55u l=0.13u
X1494 GND.t345 VDD GND.t345 GND.t1132 sg13_lv_nmos ad=79.8f pd=0.8u as=0 ps=0 w=0.42u l=1u
X1495 a_1956_16434# _250_.D a_1862_16434# GND.t601 sg13_lv_nmos ad=60.89999f pd=0.71u as=0.1428p ps=1.52u w=0.42u l=0.13u
X1496 VDD GND.t1301 VDD VDD sg13_lv_pmos ad=0.34p pd=2.68u as=0 ps=0 w=1u l=1u
X1497 VDD GND.t718 VDD VDD sg13_lv_pmos ad=0.19p pd=1.38u as=0 ps=0 w=1u l=1u
X1498 a_6869_16750# _208_.X GND.t15 GND.t14 sg13_lv_nmos ad=0.1406p pd=1.12u as=0.1898p ps=1.36u w=0.74u l=0.13u
X1499 a_2532_12223# a_2244_12528# a_2470_12223# GND.t62 sg13_lv_nmos ad=0.1428p pd=1.52u as=37.8f ps=0.6u w=0.42u l=0.13u
X1500 VDD GND.t1355 VDD VDD sg13_lv_pmos ad=0.19p pd=1.38u as=0 ps=0 w=1u l=1u
X1501 a_16240_5654# a_15983_5773# a_16402_5850# GND.t82 sg13_lv_nmos ad=0.1428p pd=1.52u as=37.8f ps=0.6u w=0.42u l=0.13u
X1502 VDD GND.t519 VDD VDD sg13_lv_pmos ad=0.19p pd=1.38u as=0 ps=0 w=1u l=1u
X1503 VDD GND.t1187 VDD VDD sg13_lv_pmos ad=0.19p pd=1.38u as=0 ps=0 w=1u l=1u
X1504 a_2298_7972# a_2232_7868# VDD VDD sg13_lv_pmos ad=0.2975p pd=1.595u as=0.2198p ps=1.52u w=1u l=0.13u
X1505 VDD GND.t333 VDD VDD sg13_lv_pmos ad=0.19p pd=1.38u as=0 ps=0 w=1u l=1u
X1506 _213_.Y _251_.CLK VDD VDD sg13_lv_pmos ad=0.3808p pd=2.92u as=0.3808p ps=2.92u w=1.12u l=0.13u
X1507 a_9551_16823# a_8709_16725# a_8292_17064# VDD sg13_lv_pmos ad=0.2048p pd=1.63u as=0.34p ps=2.68u w=1u l=0.13u
X1508 _224_.Y _215_.A GND.t362 GND.t361 sg13_lv_nmos ad=0.2516p pd=2.16u as=0.2516p ps=2.16u w=0.74u l=0.13u
X1509 a_4978_5850# _244_.RESET_B GND.t517 GND.t5 sg13_lv_nmos ad=37.8f pd=0.6u as=79.8f ps=0.8u w=0.42u l=0.13u
X1510 GND.t441 VDD GND.t897 GND.t930 sg13_lv_nmos ad=79.8f pd=0.8u as=0 ps=0 w=0.42u l=1u
X1511 VDD GND.t1274 VDD VDD sg13_lv_pmos ad=0.19p pd=1.38u as=0 ps=0 w=1u l=1u
X1512 a_16079_8797# a_15237_8447# a_15985_8797# GND.t72 sg13_lv_nmos ad=0.12665p pd=1.145u as=0.1428p ps=1.52u w=0.42u l=0.13u
X1513 GND.t170 _228_.Y a_9828_9186# GND.t21 sg13_lv_nmos ad=0.1626p pd=1.415u as=60.89999f ps=0.71u w=0.42u l=0.13u
X1514 _184_.Y _178_.B1 VDD VDD sg13_lv_pmos ad=0.2128p pd=1.5u as=0.3808p ps=2.92u w=1.12u l=0.13u
X1515 GND.t7 a_3887_4261# a_4554_3900# GND.t167 sg13_lv_nmos ad=0.1406p pd=1.12u as=0.2516p ps=2.16u w=0.74u l=0.13u
X1516 _177_.X a_6124_9945# VDD VDD sg13_lv_pmos ad=0.3808p pd=2.92u as=0.36195p ps=1.84u w=1.12u l=0.13u
X1517 _172_.Y _171_.Y a_9363_9484# VDD sg13_lv_pmos ad=0.2408p pd=1.55u as=0.1428p ps=1.375u w=1.12u l=0.13u
X1518 VDD GND.t42 VDD VDD sg13_lv_pmos ad=0.34p pd=2.68u as=0 ps=0 w=1u l=1u
X1519 GND.t1224 VDD GND.t1224 GND.t1259 sg13_lv_nmos ad=79.8f pd=0.8u as=0 ps=0 w=0.42u l=1u
X1520 VDD GND.t108 VDD VDD sg13_lv_pmos ad=0.34p pd=2.68u as=0 ps=0 w=1u l=1u
X1521 VDD GND.t678 VDD VDD sg13_lv_pmos ad=0.19p pd=1.38u as=0 ps=0 w=1u l=1u
X1522 VDD GND.t1375 VDD VDD sg13_lv_pmos ad=0.19p pd=1.38u as=0 ps=0 w=1u l=1u
X1523 GND.t188 VDD GND.t188 GND.t1116 sg13_lv_nmos ad=0.1428p pd=1.52u as=0 ps=0 w=0.42u l=1u
X1524 VDD a_9167_16357# a_9834_15996# VDD sg13_lv_pmos ad=0.2128p pd=1.5u as=0.3864p ps=2.93u w=1.12u l=0.13u
X1525 a_12666_4666# _148_.A GND.t1247 GND.t1587 sg13_lv_nmos ad=88.8f pd=0.98u as=0.15245p ps=1.17u w=0.74u l=0.13u
X1526 a_14794_11428# a_15237_11471# a_14534_11898# GND.t384 sg13_lv_nmos ad=79.8f pd=0.8u as=0.1296p ps=1.52u w=0.42u l=0.13u
X1527 a_12923_11460# _131_.A2 VDD VDD sg13_lv_pmos ad=0.3808p pd=2.92u as=0.2128p ps=1.5u w=1.12u l=0.13u
X1528 GND.t1358 VDD GND.t1360 GND.t1359 sg13_lv_nmos ad=79.8f pd=0.8u as=0 ps=0 w=0.42u l=1u
X1529 GND.t803 VDD GND.t800 GND.t802 sg13_lv_nmos ad=0.1428p pd=1.52u as=0 ps=0 w=0.42u l=1u
X1530 VDD _252_.RESET_B a_9062_4650# VDD sg13_lv_pmos ad=0.36237p pd=2.605u as=79.8f ps=0.8u w=0.42u l=0.13u
X1531 GND.t1165 VDD GND.t1164 GND.t5 sg13_lv_nmos ad=0.1428p pd=1.52u as=0 ps=0 w=0.42u l=1u
X1532 GND.t726 VDD GND.t726 GND.t712 sg13_lv_nmos ad=0.1428p pd=1.52u as=0 ps=0 w=0.42u l=1u
X1533 _208_.X _207_.Y a_4890_16762# GND.t14 sg13_lv_nmos ad=0.1628p pd=1.18u as=88.8f ps=0.98u w=0.74u l=0.13u
X1534 VDD GND.t1204 VDD VDD sg13_lv_pmos ad=0.34p pd=2.68u as=0 ps=0 w=1u l=1u
X1535 VDD GND.t195 VDD VDD sg13_lv_pmos ad=0.34p pd=2.68u as=0 ps=0 w=1u l=1u
X1536 _171_.Y _171_.A a_8236_8436# VDD sg13_lv_pmos ad=0.3808p pd=2.92u as=0.1176p ps=1.33u w=1.12u l=0.13u
X1537 a_14534_8874# _159_.Y VDD VDD sg13_lv_pmos ad=79.8f pd=0.8u as=0.1428p ps=1.52u w=0.42u l=0.13u
X1538 GND.t697 VDD GND.t697 GND.t741 sg13_lv_nmos ad=0.1428p pd=1.52u as=0 ps=0 w=0.42u l=1u
X1539 VDD GND.t1377 VDD VDD sg13_lv_pmos ad=0.34p pd=2.68u as=0 ps=0 w=1u l=1u
X1540 VDD GND.t1286 VDD VDD sg13_lv_pmos ad=0.34p pd=2.68u as=0 ps=0 w=1u l=1u
X1541 GND.t773 VDD GND.t656 GND.t14 sg13_lv_nmos ad=79.8f pd=0.8u as=0 ps=0 w=0.42u l=1u
X1542 VDD a_3503_12287# a_4170_12508# VDD sg13_lv_pmos ad=0.2128p pd=1.5u as=0.3864p ps=2.93u w=1.12u l=0.13u
X1543 VDD _250_.Q a_4796_17044# VDD sg13_lv_pmos ad=0.2128p pd=1.5u as=0.3808p ps=2.92u w=1.12u l=0.13u
X1544 a_11338_16969# a_11781_16725# a_11078_16746# GND.t19 sg13_lv_nmos ad=79.8f pd=0.8u as=0.1296p ps=1.52u w=0.42u l=0.13u
X1545 VDD GND.t671 VDD VDD sg13_lv_pmos ad=0.19p pd=1.38u as=0 ps=0 w=1u l=1u
X1546 a_2436_4338# _243_.D a_2342_4338# GND.t1432 sg13_lv_nmos ad=60.89999f pd=0.71u as=0.1428p ps=1.52u w=0.42u l=0.13u
X1547 VDD GND.t121 VDD VDD sg13_lv_pmos ad=0.19p pd=1.38u as=0 ps=0 w=1u l=1u
X1548 VDD GND.t797 VDD VDD sg13_lv_pmos ad=0.34p pd=2.68u as=0 ps=0 w=1u l=1u
X1549 _192_.B _176_.A a_6970_12214# GND.t1458 sg13_lv_nmos ad=0.2516p pd=2.16u as=0.1406p ps=1.12u w=0.74u l=0.13u
X1550 a_6336_11499# _176_.B a_6299_11808# GND.t254 sg13_lv_nmos ad=0.2176p pd=1.96u as=78.39999f ps=0.885u w=0.64u l=0.13u
X1551 GND.t342 VDD GND.t342 GND.t1222 sg13_lv_nmos ad=0.1428p pd=1.52u as=0 ps=0 w=0.42u l=1u
X1552 GND.t264 _153_.Y _162_.Y GND.t462 sg13_lv_nmos ad=0.2516p pd=2.16u as=0.1406p ps=1.12u w=0.74u l=0.13u
X1553 a_7841_9212# _165_.Y _171_.A GND.t21 sg13_lv_nmos ad=0.1406p pd=1.12u as=0.1406p ps=1.12u w=0.74u l=0.13u
X1554 _247_.CLK a_3380_13690# VDD VDD sg13_lv_pmos ad=0.2128p pd=1.5u as=0.2128p ps=1.5u w=1.12u l=0.13u
X1555 GND.t1186 VDD GND.t1185 GND.t5 sg13_lv_nmos ad=0.1428p pd=1.52u as=0 ps=0 w=0.42u l=1u
X1556 GND.t65 _224_.Y a_6276_4650# GND.t428 sg13_lv_nmos ad=0.1626p pd=1.415u as=60.89999f ps=0.71u w=0.42u l=0.13u
X1557 VDD GND.t1320 VDD VDD sg13_lv_pmos ad=0.19p pd=1.38u as=0 ps=0 w=1u l=1u
X1558 a_6291_12972# _190_.A VDD VDD sg13_lv_pmos ad=0.1428p pd=1.375u as=0.2891p ps=1.695u w=1.12u l=0.13u
X1559 a_13025_11808# _260_.CLK _126_.Y GND.t541 sg13_lv_nmos ad=0.1406p pd=1.12u as=0.1406p ps=1.12u w=0.74u l=0.13u
X1560 GND.t214 _207_.A1 a_5525_16750# GND.t14 sg13_lv_nmos ad=0.1898p pd=1.36u as=0.2516p ps=2.16u w=0.74u l=0.13u
X1561 _179_.Y _178_.Y a_6890_9948# VDD sg13_lv_pmos ad=0.3808p pd=2.92u as=0.1176p ps=1.33u w=1.12u l=0.13u
X1562 a_3300_4968# a_3274_4873# GND.t1 GND.t298 sg13_lv_nmos ad=0.2516p pd=2.16u as=0.1626p ps=1.415u w=0.74u l=0.13u
X1563 a_2148_12976# a_2122_12940# GND.t133 GND.t132 sg13_lv_nmos ad=0.2516p pd=2.16u as=0.1626p ps=1.415u w=0.74u l=0.13u
X1564 a_12730_8806# _162_.B GND.t266 GND.t265 sg13_lv_nmos ad=0.1406p pd=1.12u as=0.2516p ps=2.16u w=0.74u l=0.13u
X1565 VDD GND.t803 VDD VDD sg13_lv_pmos ad=0.34p pd=2.68u as=0 ps=0 w=1u l=1u
X1566 VDD GND.t668 VDD VDD sg13_lv_pmos ad=0.34p pd=2.68u as=0 ps=0 w=1u l=1u
X1567 VDD GND.t1306 VDD VDD sg13_lv_pmos ad=0.34p pd=2.68u as=0 ps=0 w=1u l=1u
X1568 VDD a_4816_5654# a_4761_5535# VDD sg13_lv_pmos ad=1.48542p pd=9.54u as=93.45f ps=0.865u w=0.42u l=0.13u
X1569 a_2558_14020# _119_.A0 a_2126_13912# VDD sg13_lv_pmos ad=0.3325p pd=1.665u as=0.2225p ps=1.445u w=1u l=0.13u
X1570 a_16336_9406# _260_.RESET_B VDD VDD sg13_lv_pmos ad=79.8f pd=0.8u as=1.94845p ps=12.685u w=0.42u l=0.13u
X1571 a_6720_17061# _208_.X a_6683_16792# GND.t14 sg13_lv_nmos ad=0.2176p pd=1.96u as=78.39999f ps=0.885u w=0.64u l=0.13u
X1572 a_11026_4650# _252_.RESET_B GND.t79 GND.t529 sg13_lv_nmos ad=37.8f pd=0.6u as=79.8f ps=0.8u w=0.42u l=0.13u
X1573 GND.t806 VDD GND.t809 GND.t854 sg13_lv_nmos ad=79.8f pd=0.8u as=0 ps=0 w=0.42u l=1u
X1574 GND.t519 VDD GND.t519 GND.t1111 sg13_lv_nmos ad=79.8f pd=0.8u as=0 ps=0 w=0.42u l=1u
X1575 a_2565_16007# _247_.CLK VDD VDD sg13_lv_pmos ad=0.4088p pd=2.97u as=1.6291p ps=10.53u w=1.12u l=0.13u
X1576 a_4625_16800# _207_.Y a_4593_17068# VDD sg13_lv_pmos ad=0.34p pd=2.68u as=0.1225p ps=1.245u w=1u l=0.13u
X1577 a_6779_12972# _192_.B VDD VDD sg13_lv_pmos ad=0.3808p pd=2.92u as=0.2128p ps=1.5u w=1.12u l=0.13u
X1578 _157_.B a_13740_5678# VDD VDD sg13_lv_pmos ad=0.2408p pd=1.55u as=0.3808p ps=2.92u w=1.12u l=0.13u
X1579 GND.t1156 VDD GND.t1155 GND.t1154 sg13_lv_nmos ad=0.1428p pd=1.52u as=0 ps=0 w=0.42u l=1u
X1580 a_2724_9199# a_2436_9504# a_2662_9199# GND.t127 sg13_lv_nmos ad=0.1428p pd=1.52u as=37.8f ps=0.6u w=0.42u l=0.13u
X1581 VDD GND.t188 VDD VDD sg13_lv_pmos ad=0.34p pd=2.68u as=0 ps=0 w=1u l=1u
X1582 a_15108_8861# a_14820_8440# a_15046_8861# GND.t2 sg13_lv_nmos ad=0.1428p pd=1.52u as=37.8f ps=0.6u w=0.42u l=0.13u
X1583 a_11536_17750# _240_.Y VDD VDD sg13_lv_pmos ad=79.8f pd=0.8u as=1.30717p ps=8.395u w=0.42u l=0.13u
X1584 a_3588_4663# a_3819_4772# a_3274_4873# GND.t324 sg13_lv_nmos ad=0.2373p pd=1.97u as=79.8f ps=0.8u w=0.42u l=0.13u
X1585 _214_.A a_11946_17508# VDD VDD sg13_lv_pmos ad=0.3808p pd=2.92u as=0.2128p ps=1.5u w=1.12u l=0.13u
X1586 VDD a_9167_16357# a_9424_16238# VDD sg13_lv_pmos ad=1.6291p pd=10.53u as=79.8f ps=0.8u w=0.42u l=0.13u
X1587 VDD a_14320_16238# a_14265_16119# VDD sg13_lv_pmos ad=1.6291p pd=10.53u as=93.45f ps=0.865u w=0.42u l=0.13u
X1588 a_9705_5041# a_9348_4968# VDD VDD sg13_lv_pmos ad=63f pd=0.72u as=0.1563p ps=1.22u w=0.42u l=0.13u
X1589 GND.t1227 VDD GND.t1227 GND.t1261 sg13_lv_nmos ad=79.8f pd=0.8u as=0 ps=0 w=0.42u l=1u
X1590 a_4559_5773# a_3717_5423# a_4465_5773# GND.t5 sg13_lv_nmos ad=0.12665p pd=1.145u as=0.1428p ps=1.52u w=0.42u l=0.13u
X1591 a_2126_7864# _148_.A a_2298_7972# VDD sg13_lv_pmos ad=0.2225p pd=1.445u as=0.2975p ps=1.595u w=1u l=0.13u
X1592 a_7736_8802# _170_.B a_7634_8802# GND.t21 sg13_lv_nmos ad=0.1406p pd=1.12u as=0.1406p ps=1.12u w=0.74u l=0.13u
X1593 GND.t689 VDD GND.t689 GND.t690 sg13_lv_nmos ad=79.8f pd=0.8u as=0 ps=0 w=0.42u l=1u
X1594 GND.t198 VDD GND.t1025 GND.t1024 sg13_lv_nmos ad=79.8f pd=0.8u as=0 ps=0 w=0.42u l=1u
X1595 VDD a_12623_16823# a_12880_16966# VDD sg13_lv_pmos ad=1.30717p pd=8.395u as=79.8f ps=0.8u w=0.42u l=0.13u
X1596 _190_.A a_11082_14020# GND.t307 GND.t306 sg13_lv_nmos ad=0.2516p pd=2.16u as=0.1406p ps=1.12u w=0.74u l=0.13u
X1597 VDD GND.t1345 VDD VDD sg13_lv_pmos ad=0.19p pd=1.38u as=0 ps=0 w=1u l=1u
X1598 GND.t1312 VDD GND.t1311 GND.t1310 sg13_lv_nmos ad=0.1428p pd=1.52u as=0 ps=0 w=0.42u l=1u
X1599 GND.t1119 VDD GND.t188 GND.t1118 sg13_lv_nmos ad=0.1428p pd=1.52u as=0 ps=0 w=0.42u l=1u
X1600 _131_.A2 a_16650_12508# VDD VDD sg13_lv_pmos ad=0.3808p pd=2.92u as=0.2128p ps=1.5u w=1.12u l=0.13u
X1601 _243_.CLK a_3956_6888# VDD VDD sg13_lv_pmos ad=0.2128p pd=1.5u as=0.3976p ps=2.95u w=1.12u l=0.13u
X1602 GND.t510 fanout8.A a_9352_17508# GND.t1386 sg13_lv_nmos ad=0.14875p pd=1.16u as=0.187p ps=1.78u w=0.55u l=0.13u
X1603 VDD a_3887_4261# a_4144_4142# VDD sg13_lv_pmos ad=5.15485p pd=34.14u as=79.8f ps=0.8u w=0.42u l=0.13u
X1604 GND.t1363 VDD GND.t1365 GND.t1364 sg13_lv_nmos ad=79.8f pd=0.8u as=0 ps=0 w=0.42u l=1u
X1605 GND.t1163 VDD GND.t1162 GND.t5 sg13_lv_nmos ad=0.1428p pd=1.52u as=0 ps=0 w=0.42u l=1u
X1606 GND.t1025 sclk a_3886_10702# GND.t1429 sg13_lv_nmos ad=0.1406p pd=1.12u as=0.1406p ps=1.12u w=0.74u l=0.13u
X1607 GND.t190 VDD GND.t190 GND.t944 sg13_lv_nmos ad=0.1428p pd=1.52u as=0 ps=0 w=0.42u l=1u
X1608 a_5265_12532# _120_.A0 VDD VDD sg13_lv_pmos ad=0.1225p pd=1.245u as=0.36p ps=2.72u w=1u l=0.13u
X1609 a_3108_4650# _242_.D a_3014_4650# GND.t511 sg13_lv_nmos ad=60.89999f pd=0.71u as=0.1428p ps=1.52u w=0.42u l=0.13u
X1610 GND.t697 VDD GND.t697 GND.t698 sg13_lv_nmos ad=79.8f pd=0.8u as=0 ps=0 w=0.42u l=1u
X1611 VDD _235_.Y a_14438_12210# VDD sg13_lv_pmos ad=0.36237p pd=2.605u as=79.8f ps=0.8u w=0.42u l=0.13u
X1612 a_3664_16238# _250_.RESET_B VDD VDD sg13_lv_pmos ad=79.8f pd=0.8u as=1.6291p ps=10.53u w=0.42u l=0.13u
X1613 GND.t345 VDD GND.t345 GND.t1128 sg13_lv_nmos ad=79.8f pd=0.8u as=0 ps=0 w=0.42u l=1u
X1614 GND.t718 VDD GND.t718 GND.t158 sg13_lv_nmos ad=79.8f pd=0.8u as=0 ps=0 w=0.42u l=1u
X1615 a_7953_14044# _186_.Y VDD VDD sg13_lv_pmos ad=0.1225p pd=1.245u as=0.36p ps=2.72u w=1u l=0.13u
X1616 GND.t1221 VDD GND.t1221 GND.t1255 sg13_lv_nmos ad=79.8f pd=0.8u as=0 ps=0 w=0.42u l=1u
X1617 VDD GND.t1291 VDD VDD sg13_lv_pmos ad=0.34p pd=2.68u as=0 ps=0 w=1u l=1u
X1618 GND.t976 VDD GND.t666 GND.t977 sg13_lv_nmos ad=79.8f pd=0.8u as=0 ps=0 w=0.42u l=1u
X1619 GND.t469 a_15983_5773# a_16650_5412# GND.t82 sg13_lv_nmos ad=0.1406p pd=1.12u as=0.2516p ps=2.16u w=0.74u l=0.13u
X1620 VDD _266_.CLK a_15071_17016# VDD sg13_lv_pmos ad=1.30717p pd=8.395u as=0.4088p ps=2.97u w=1.12u l=0.13u
X1621 GND.t809 VDD GND.t809 GND.t810 sg13_lv_nmos ad=79.8f pd=0.8u as=0 ps=0 w=0.42u l=1u
X1622 GND.t26 a_2126_17774# _250_.D GND.t655 sg13_lv_nmos ad=0.148p pd=1.14u as=0.4033p ps=2.57u w=0.74u l=0.13u
X1623 a_8603_9484# _171_.Y VDD VDD sg13_lv_pmos ad=0.3808p pd=2.92u as=0.2128p ps=1.5u w=1.12u l=0.13u
X1624 GND.t718 VDD GND.t718 GND.t712 sg13_lv_nmos ad=79.8f pd=0.8u as=0 ps=0 w=0.42u l=1u
X1625 a_1862_16434# a_2667_16007# a_2122_15964# VDD sg13_lv_pmos ad=0.1428p pd=1.52u as=79.8f ps=0.8u w=0.42u l=0.13u
X1626 VDD sclk a_3886_10702# VDD sg13_lv_pmos ad=0.2128p pd=1.5u as=0.2128p ps=1.5u w=1.12u l=0.13u
X1627 VDD _242_.RESET_B a_3274_4873# VDD sg13_lv_pmos ad=0.1563p pd=1.22u as=0.147p ps=1.54u w=0.42u l=0.13u
X1628 VDD GND.t970 VDD VDD sg13_lv_pmos ad=0.19p pd=1.38u as=0 ps=0 w=1u l=1u
X1629 a_11279_9263# a_10437_9165# a_11185_9263# GND.t1504 sg13_lv_nmos ad=0.12665p pd=1.145u as=0.1428p ps=1.52u w=0.42u l=0.13u
X1630 a_2374_16759# _222_.Y GND.t144 GND.t630 sg13_lv_nmos ad=37.8f pd=0.6u as=0.1701p ps=1.65u w=0.42u l=0.13u
X1631 GND.t1006 VDD GND.t1006 GND.t1005 sg13_lv_nmos ad=0.1428p pd=1.52u as=0 ps=0 w=0.42u l=1u
X1632 GND.t354 VDD GND.t354 GND.t1231 sg13_lv_nmos ad=79.8f pd=0.8u as=0 ps=0 w=0.42u l=1u
X1633 a_8250_7690# _122_.A0 GND.t33 GND.t32 sg13_lv_nmos ad=88.8f pd=0.98u as=0.15245p ps=1.17u w=0.74u l=0.13u
X1634 VDD _221_.Y a_1862_13410# VDD sg13_lv_pmos ad=0.36237p pd=2.605u as=79.8f ps=0.8u w=0.42u l=0.13u
X1635 VDD GND.t897 VDD VDD sg13_lv_pmos ad=0.34p pd=2.68u as=0 ps=0 w=1u l=1u
X1636 VDD GND.t1094 VDD VDD sg13_lv_pmos ad=0.19p pd=1.38u as=0 ps=0 w=1u l=1u
X1637 VDD GND.t225 VDD VDD sg13_lv_pmos ad=0.34p pd=2.68u as=0 ps=0 w=1u l=1u
X1638 VDD GND.t1165 VDD VDD sg13_lv_pmos ad=0.34p pd=2.68u as=0 ps=0 w=1u l=1u
X1639 VDD GND.t726 VDD VDD sg13_lv_pmos ad=0.19p pd=1.38u as=0 ps=0 w=1u l=1u
X1640 VDD GND.t1276 VDD VDD sg13_lv_pmos ad=0.34p pd=2.68u as=0 ps=0 w=1u l=1u
X1641 a_2298_17532# a_2232_17770# VDD VDD sg13_lv_pmos ad=0.2975p pd=1.595u as=0.2198p ps=1.52u w=1u l=0.13u
X1642 GND.t557 a_3956_6888# _243_.CLK GND.t566 sg13_lv_nmos ad=0.1406p pd=1.12u as=0.1406p ps=1.12u w=0.74u l=0.13u
X1643 VDD a_10437_9165# a_10539_9308# VDD sg13_lv_pmos ad=1.94845p pd=12.685u as=0.3864p ps=2.93u w=1.12u l=0.13u
X1644 VDD GND.t352 VDD VDD sg13_lv_pmos ad=0.34p pd=2.68u as=0 ps=0 w=1u l=1u
X1645 GND.t68 a_15861_16904# a_14940_16710# GND.t67 sg13_lv_nmos ad=0.1626p pd=1.415u as=0.2516p ps=2.16u w=0.74u l=0.13u
X1646 VDD _239_.Y a_14054_15234# VDD sg13_lv_pmos ad=0.36237p pd=2.605u as=79.8f ps=0.8u w=0.42u l=0.13u
X1647 VDD GND.t139 VDD VDD sg13_lv_pmos ad=0.34p pd=2.68u as=0 ps=0 w=1u l=1u
X1648 GND.t121 VDD GND.t121 GND.t710 sg13_lv_nmos ad=0.1428p pd=1.52u as=0 ps=0 w=0.42u l=1u
X1649 _191_.Y _192_.C GND.t485 GND.t46 sg13_lv_nmos ad=0.1406p pd=1.12u as=0.2516p ps=2.16u w=0.74u l=0.13u
X1650 VDD GND.t1330 VDD VDD sg13_lv_pmos ad=0.19p pd=1.38u as=0 ps=0 w=1u l=1u
X1651 GND.t57 VDD GND.t57 GND.t1112 sg13_lv_nmos ad=0.1428p pd=1.52u as=0 ps=0 w=0.42u l=1u
X1652 GND.t188 VDD GND.t57 GND.t1082 sg13_lv_nmos ad=0.1428p pd=1.52u as=0 ps=0 w=0.42u l=1u
X1653 GND.t1297 VDD GND.t1296 GND.t1295 sg13_lv_nmos ad=0.1428p pd=1.52u as=0 ps=0 w=0.42u l=1u
X1654 GND.t359 VDD GND.t359 GND.t358 sg13_lv_nmos ad=79.8f pd=0.8u as=0 ps=0 w=0.42u l=1u
X1655 GND.t1180 VDD GND.t1179 GND.t5 sg13_lv_nmos ad=0.1428p pd=1.52u as=0 ps=0 w=0.42u l=1u
X1656 a_2565_12983# _247_.CLK GND.t46 GND.t481 sg13_lv_nmos ad=0.2516p pd=2.16u as=7.09257p ps=45.595u w=0.74u l=0.13u
X1657 _189_.X _148_.B a_5178_13330# GND.t46 sg13_lv_nmos ad=0.1628p pd=1.18u as=88.8f ps=0.98u w=0.74u l=0.13u
X1658 VDD a_3717_5423# a_3819_5423# VDD sg13_lv_pmos ad=1.48542p pd=9.54u as=0.3864p ps=2.93u w=1.12u l=0.13u
X1659 VDD GND.t812 VDD VDD sg13_lv_pmos ad=0.19p pd=1.38u as=0 ps=0 w=1u l=1u
X1660 a_2122_16969# a_2565_16725# a_2505_17137# VDD sg13_lv_pmos ad=79.8f pd=0.8u as=63f ps=0.72u w=0.42u l=0.13u
X1661 GND.t1103 VDD GND.t23 GND.t1138 sg13_lv_nmos ad=79.8f pd=0.8u as=0 ps=0 w=0.42u l=1u
X1662 _243_.CLK a_3956_6888# GND.t557 GND.t563 sg13_lv_nmos ad=0.1406p pd=1.12u as=0.1406p ps=1.12u w=0.74u l=0.13u
X1663 VDD a_10415_12287# a_11082_12508# VDD sg13_lv_pmos ad=0.2128p pd=1.5u as=0.3864p ps=2.93u w=1.12u l=0.13u
X1664 VDD GND.t333 VDD VDD sg13_lv_pmos ad=0.34p pd=2.68u as=0 ps=0 w=1u l=1u
X1665 _207_.A2 a_4512_17547# a_4661_17878# GND.t142 sg13_lv_nmos ad=0.2516p pd=2.16u as=0.1406p ps=1.12u w=0.74u l=0.13u
X1666 GND.t515 _241_.Y a_11172_16746# GND.t19 sg13_lv_nmos ad=0.1626p pd=1.415u as=60.89999f ps=0.71u w=0.42u l=0.13u
X1667 a_2298_15238# a_2232_15428# GND.t439 GND.t438 sg13_lv_nmos ad=0.3367p pd=1.65u as=0.148p ps=1.14u w=0.74u l=0.13u
X1668 VDD GND.t557 VDD VDD sg13_lv_pmos ad=0.19p pd=1.38u as=0 ps=0 w=1u l=1u
X1669 VDD GND.t901 VDD VDD sg13_lv_pmos ad=0.34p pd=2.68u as=0 ps=0 w=1u l=1u
X1670 _172_.Y a_9120_9501# a_9269_9190# GND.t21 sg13_lv_nmos ad=0.2516p pd=2.16u as=0.1406p ps=1.12u w=0.74u l=0.13u
X1671 VDD GND.t687 VDD VDD sg13_lv_pmos ad=0.19p pd=1.38u as=0 ps=0 w=1u l=1u
X1672 GND.t842 VDD GND.t493 GND.t841 sg13_lv_nmos ad=0.1428p pd=1.52u as=0 ps=0 w=0.42u l=1u
X1673 GND.t1245 VDD GND.t1247 GND.t1246 sg13_lv_nmos ad=79.8f pd=0.8u as=0 ps=0 w=0.42u l=1u
X1674 a_2398_4654# _210_.A a_2301_4654# GND.t86 sg13_lv_nmos ad=0.1628p pd=1.18u as=0.13135p ps=1.095u w=0.74u l=0.13u
X1675 a_8006_16746# a_8811_16868# a_8266_16969# VDD sg13_lv_pmos ad=0.1428p pd=1.52u as=79.8f ps=0.8u w=0.42u l=0.13u
X1676 _264_.Q a_14730_15996# GND.t59 GND.t58 sg13_lv_nmos ad=0.2516p pd=2.16u as=0.1406p ps=1.12u w=0.74u l=0.13u
X1677 VDD GND.t1350 VDD VDD sg13_lv_pmos ad=0.19p pd=1.38u as=0 ps=0 w=1u l=1u
X1678 a_13775_5782# a_13740_5678# _157_.B GND.t5 sg13_lv_nmos ad=0.1406p pd=1.12u as=0.2516p ps=2.16u w=0.74u l=0.13u
X1679 VDD GND.t1000 VDD VDD sg13_lv_pmos ad=0.19p pd=1.38u as=0 ps=0 w=1u l=1u
X1680 GND.t37 _225_.A.t2 _252_.RESET_B GND.t343 sg13_lv_nmos ad=0.2516p pd=2.16u as=0.2516p ps=2.16u w=0.74u l=0.13u
X1681 VDD GND.t716 VDD VDD sg13_lv_pmos ad=0.19p pd=1.38u as=0 ps=0 w=1u l=1u
X1682 VDD GND.t838 VDD VDD sg13_lv_pmos ad=0.34p pd=2.68u as=0 ps=0 w=1u l=1u
X1683 VDD a_9551_16823# a_9808_16966# VDD sg13_lv_pmos ad=1.30717p pd=8.395u as=79.8f ps=0.8u w=0.42u l=0.13u
X1684 a_3664_16966# _222_.Y VDD VDD sg13_lv_pmos ad=79.8f pd=0.8u as=1.30717p ps=8.395u w=0.42u l=0.13u
X1685 a_7622_16434# a_8427_16007# a_7882_15964# VDD sg13_lv_pmos ad=0.1428p pd=1.52u as=79.8f ps=0.8u w=0.42u l=0.13u
X1686 VDD GND.t321 VDD VDD sg13_lv_pmos ad=0.19p pd=1.38u as=0 ps=0 w=1u l=1u
X1687 a_3014_5850# a_3819_5423# a_3274_5380# VDD sg13_lv_pmos ad=0.1428p pd=1.52u as=79.8f ps=0.8u w=0.42u l=0.13u
X1688 GND.t397 _238_.Y a_16118_16759# GND.t396 sg13_lv_nmos ad=0.1701p pd=1.65u as=37.8f ps=0.6u w=0.42u l=0.13u
X1689 a_3407_13333# a_2565_12983# a_3313_13333# GND.t46 sg13_lv_nmos ad=0.12665p pd=1.145u as=0.1428p ps=1.52u w=0.42u l=0.13u
X1690 GND.t319 VDD GND.t908 GND.t46 sg13_lv_nmos ad=0.1428p pd=1.52u as=0 ps=0 w=0.42u l=1u
X1691 _148_.A a_5226_5412# VDD VDD sg13_lv_pmos ad=0.3808p pd=2.92u as=0.2128p ps=1.5u w=1.12u l=0.13u
X1692 GND.t345 VDD GND.t345 GND.t1130 sg13_lv_nmos ad=79.8f pd=0.8u as=0 ps=0 w=0.42u l=1u
X1693 _244_.D a_2494_6166# GND.t5 GND.t83 sg13_lv_nmos ad=0.4033p pd=2.57u as=0.148p ps=1.14u w=0.74u l=0.13u
X1694 a_12992_15437# _134_.Y VDD VDD sg13_lv_pmos ad=0.1596p pd=1.22u as=0.1918p ps=1.5u w=0.84u l=0.13u
X1695 VDD _230_.Y a_8870_13722# VDD sg13_lv_pmos ad=0.36237p pd=2.605u as=79.8f ps=0.8u w=0.42u l=0.13u
X1696 a_8250_13738# _186_.Y GND.t319 GND.t46 sg13_lv_nmos ad=88.8f pd=0.98u as=0.15245p ps=1.17u w=0.74u l=0.13u
X1697 a_13244_5412# _157_.B VDD VDD sg13_lv_pmos ad=0.2128p pd=1.5u as=0.2128p ps=1.5u w=1.12u l=0.13u
X1698 _247_.CLK a_3380_13690# GND.t371 GND.t46 sg13_lv_nmos ad=0.1406p pd=1.12u as=0.1406p ps=1.12u w=0.74u l=0.13u
X1699 a_3526_5837# _244_.RESET_B GND.t5 GND.t1463 sg13_lv_nmos ad=37.8f pd=0.6u as=0.1701p ps=1.65u w=0.42u l=0.13u
X1700 _178_.Y _178_.B1 a_6389_9484# VDD sg13_lv_pmos ad=0.3808p pd=2.92u as=0.2128p ps=1.5u w=1.12u l=0.13u
X1701 VDD GND.t718 VDD VDD sg13_lv_pmos ad=0.19p pd=1.38u as=0 ps=0 w=1u l=1u
X1702 VDD GND.t495 VDD VDD sg13_lv_pmos ad=0.19p pd=1.38u as=0 ps=0 w=1u l=1u
X1703 VDD GND.t404 VDD VDD sg13_lv_pmos ad=0.19p pd=1.38u as=0 ps=0 w=1u l=1u
X1704 VDD a_2565_16725# a_2667_16868# VDD sg13_lv_pmos ad=1.30717p pd=8.395u as=0.3864p ps=2.93u w=1.12u l=0.13u
X1705 a_8538_5375# _144_.B GND.t228 GND.t5 sg13_lv_nmos ad=0.17462p pd=1.185u as=0.15245p ps=1.17u w=0.55u l=0.13u
X1706 VDD a_1580_16710# _222_.A VDD sg13_lv_pmos ad=0.2114p pd=1.54u as=0.42p ps=2.99u w=1.12u l=0.13u
X1707 VDD GND.t277 VDD VDD sg13_lv_pmos ad=0.34p pd=2.68u as=0 ps=0 w=1u l=1u
X1708 VDD GND.t1362 VDD VDD sg13_lv_pmos ad=0.34p pd=2.68u as=0 ps=0 w=1u l=1u
X1709 VDD _236_.Y a_14794_11428# VDD sg13_lv_pmos ad=0.1563p pd=1.22u as=0.147p ps=1.54u w=0.42u l=0.13u
X1710 a_9348_4968# a_9322_4873# VDD VDD sg13_lv_pmos ad=0.34p pd=2.68u as=0.36237p ps=2.605u w=1u l=0.13u
X1711 _183_.Y _171_.Y VDD VDD sg13_lv_pmos ad=0.2128p pd=1.5u as=0.3808p ps=2.92u w=1.12u l=0.13u
X1712 GND.t1006 VDD GND.t1006 GND.t1044 sg13_lv_nmos ad=79.8f pd=0.8u as=0 ps=0 w=0.42u l=1u
X1713 VDD a_15983_5773# a_16240_5654# VDD sg13_lv_pmos ad=1.48542p pd=9.54u as=79.8f ps=0.8u w=0.42u l=0.13u
X1714 VDD _153_.Y a_12652_6924# VDD sg13_lv_pmos ad=0.4032p pd=2.96u as=0.1176p ps=1.33u w=1.12u l=0.13u
X1715 a_3705_12525# a_2763_12332# a_3503_12287# VDD sg13_lv_pmos ad=93.45f pd=0.865u as=0.2048p ps=1.63u w=0.42u l=0.13u
X1716 a_13041_7996# _153_.Y VDD VDD sg13_lv_pmos ad=0.1225p pd=1.245u as=0.36p ps=2.72u w=1u l=0.13u
X1717 _139_.X _136_.A a_11034_4258# GND.t614 sg13_lv_nmos ad=0.1628p pd=1.18u as=88.8f ps=0.98u w=0.74u l=0.13u
X1718 VDD GND.t1322 VDD VDD sg13_lv_pmos ad=0.34p pd=2.68u as=0 ps=0 w=1u l=1u
X1719 GND.t1094 VDD GND.t1094 GND.t1124 sg13_lv_nmos ad=79.8f pd=0.8u as=0 ps=0 w=0.42u l=1u
X1720 VDD GND.t1281 VDD VDD sg13_lv_pmos ad=0.34p pd=2.68u as=0 ps=0 w=1u l=1u
X1721 _243_.CLK a_3956_6888# GND.t557 GND.t559 sg13_lv_nmos ad=0.1406p pd=1.12u as=0.1406p ps=1.12u w=0.74u l=0.13u
X1722 _236_.Y _236_.A GND.t671 GND.t670 sg13_lv_nmos ad=0.2516p pd=2.16u as=0.2516p ps=2.16u w=0.74u l=0.13u
X1723 a_3609_13095# a_2667_12983# a_3407_13333# VDD sg13_lv_pmos ad=93.45f pd=0.865u as=0.2048p ps=1.63u w=0.42u l=0.13u
X1724 VDD _251_.CLK a_16840_4688# VDD sg13_lv_pmos ad=0.2114p pd=1.54u as=0.2856p ps=2.36u w=0.84u l=0.13u
X1725 VDD GND.t790 VDD VDD sg13_lv_pmos ad=0.19p pd=1.38u as=0 ps=0 w=1u l=1u
X1726 VDD GND.t1335 VDD VDD sg13_lv_pmos ad=0.19p pd=1.38u as=0 ps=0 w=1u l=1u
X1727 a_9734_17946# a_10539_17519# a_9994_17476# VDD sg13_lv_pmos ad=0.1428p pd=1.52u as=79.8f ps=0.8u w=0.42u l=0.13u
X1728 _247_.CLK a_3380_13690# GND.t367 GND.t46 sg13_lv_nmos ad=0.1406p pd=1.12u as=0.1406p ps=1.12u w=0.74u l=0.13u
X1729 a_9156_12528# a_9130_12433# VDD VDD sg13_lv_pmos ad=0.34p pd=2.68u as=0.36237p ps=2.605u w=1u l=0.13u
X1730 GND.t508 a_4559_5773# a_5226_5412# GND.t5 sg13_lv_nmos ad=0.1406p pd=1.12u as=0.2516p ps=2.16u w=0.74u l=0.13u
X1731 a_12804_16000# a_12778_15964# GND.t177 GND.t176 sg13_lv_nmos ad=0.2516p pd=2.16u as=0.1626p ps=1.415u w=0.74u l=0.13u
X1732 _237_.Y _236_.A GND.t668 GND.t667 sg13_lv_nmos ad=0.2516p pd=2.16u as=0.2516p ps=2.16u w=0.74u l=0.13u
X1733 a_16079_9263# a_15237_9165# a_15985_9263# GND.t72 sg13_lv_nmos ad=0.12665p pd=1.145u as=0.1428p ps=1.52u w=0.42u l=0.13u
X1734 _120_.A0 a_4170_12508# VDD VDD sg13_lv_pmos ad=0.3808p pd=2.92u as=0.2128p ps=1.5u w=1.12u l=0.13u
X1735 GND.t292 a_12401_4704# _148_.X GND.t291 sg13_lv_nmos ad=0.3108p pd=2.32u as=0.1628p ps=1.18u w=0.74u l=0.13u
X1736 VDD GND.t1071 VDD VDD sg13_lv_pmos ad=0.34p pd=2.68u as=0 ps=0 w=1u l=1u
X1737 a_2436_16759# a_2148_17064# a_2374_16759# GND.t302 sg13_lv_nmos ad=0.1428p pd=1.52u as=37.8f ps=0.6u w=0.42u l=0.13u
X1738 GND.t1076 VDD GND.t90 GND.t21 sg13_lv_nmos ad=79.8f pd=0.8u as=0 ps=0 w=0.42u l=1u
X1739 VDD a_3952_8678# a_3897_8559# VDD sg13_lv_pmos ad=2.75005p pd=18.05u as=93.45f ps=0.865u w=0.42u l=0.13u
X1740 _193_.Y a_6958_13764# GND.t618 GND.t46 sg13_lv_nmos ad=0.1406p pd=1.12u as=0.17255p ps=1.25u w=0.74u l=0.13u
X1741 a_14482_16434# _237_.Y GND.t59 GND.t58 sg13_lv_nmos ad=37.8f pd=0.6u as=79.8f ps=0.8u w=0.42u l=0.13u
X1742 a_13073_7728# _153_.Y GND.t264 GND.t460 sg13_lv_nmos ad=0.17462p pd=1.185u as=0.374p ps=2.46u w=0.55u l=0.13u
X1743 VDD a_16079_11821# a_16336_11702# VDD sg13_lv_pmos ad=5.15485p pd=34.14u as=79.8f ps=0.8u w=0.42u l=0.13u
X1744 a_2126_17774# _250_.Q a_2298_17878# GND.t49 sg13_lv_nmos ad=0.1628p pd=1.18u as=0.3367p ps=1.65u w=0.74u l=0.13u
X1745 VDD a_7727_4727# a_8394_4948# VDD sg13_lv_pmos ad=0.2128p pd=1.5u as=0.3864p ps=2.93u w=1.12u l=0.13u
X1746 VDD GND.t1242 VDD VDD sg13_lv_pmos ad=0.19p pd=1.38u as=0 ps=0 w=1u l=1u
X1747 fanout6.A a_10218_17044# GND.t20 GND.t19 sg13_lv_nmos ad=0.2516p pd=2.16u as=0.1406p ps=1.12u w=0.74u l=0.13u
X1748 GND.t190 _124_.S a_2620_11830# GND.t189 sg13_lv_nmos ad=0.18945p pd=1.27u as=0.13135p ps=1.095u w=0.74u l=0.13u
X1749 VDD GND.t279 VDD VDD sg13_lv_pmos ad=0.19p pd=1.38u as=0 ps=0 w=1u l=1u
X1750 GND.t784 VDD GND.t68 GND.t10 sg13_lv_nmos ad=0.1428p pd=1.52u as=0 ps=0 w=0.42u l=1u
X1751 VDD a_15237_9165# a_15339_9308# VDD sg13_lv_pmos ad=1.94845p pd=12.685u as=0.3864p ps=2.93u w=1.12u l=0.13u
X1752 GND.t697 VDD GND.t701 GND.t700 sg13_lv_nmos ad=79.8f pd=0.8u as=0 ps=0 w=0.42u l=1u
X1753 _242_.RESET_B _215_.A VDD VDD sg13_lv_pmos ad=0.3808p pd=2.92u as=0.3808p ps=2.92u w=1.12u l=0.13u
X1754 VDD _147_.A1 a_10764_5678# VDD sg13_lv_pmos ad=0.4536p pd=2.76u as=0.1596p ps=1.22u w=0.84u l=0.13u
X1755 GND.t1094 VDD GND.t1094 GND.t1095 sg13_lv_nmos ad=79.8f pd=0.8u as=0 ps=0 w=0.42u l=1u
X1756 VDD _260_.RESET_B a_14534_9186# VDD sg13_lv_pmos ad=0.36237p pd=2.605u as=79.8f ps=0.8u w=0.42u l=0.13u
X1757 a_8870_12210# a_9675_12332# a_9130_12433# VDD sg13_lv_pmos ad=0.1428p pd=1.52u as=79.8f ps=0.8u w=0.42u l=0.13u
X1758 a_3664_13214# a_3407_13333# a_3826_13410# GND.t46 sg13_lv_nmos ad=0.1428p pd=1.52u as=37.8f ps=0.6u w=0.42u l=0.13u
X1759 _151_.X _151_.B a_13914_4666# GND.t433 sg13_lv_nmos ad=0.1628p pd=1.18u as=88.8f ps=0.98u w=0.74u l=0.13u
X1760 VDD _220_.Y a_1958_12210# VDD sg13_lv_pmos ad=0.36237p pd=2.605u as=79.8f ps=0.8u w=0.42u l=0.13u
X1761 a_6694_4663# _224_.Y GND.t65 GND.t427 sg13_lv_nmos ad=37.8f pd=0.6u as=0.1701p ps=1.65u w=0.42u l=0.13u
X1762 VDD GND.t671 VDD VDD sg13_lv_pmos ad=0.19p pd=1.38u as=0 ps=0 w=1u l=1u
X1763 a_9734_17946# _214_.Y VDD VDD sg13_lv_pmos ad=79.8f pd=0.8u as=0.1428p ps=1.52u w=0.42u l=0.13u
X1764 VDD _122_.A0 _165_.Y VDD sg13_lv_pmos ad=0.3808p pd=2.92u as=0.2128p ps=1.5u w=1.12u l=0.13u
X1765 a_14651_10996# _131_.A2 VDD VDD sg13_lv_pmos ad=0.3808p pd=2.92u as=0.2128p ps=1.5u w=1.12u l=0.13u
X1766 VDD fanout6.A a_4512_17547# VDD sg13_lv_pmos ad=0.2891p pd=1.695u as=0.1596p ps=1.22u w=0.84u l=0.13u
X1767 GND.t968 VDD GND.t970 GND.t969 sg13_lv_nmos ad=79.8f pd=0.8u as=0 ps=0 w=0.42u l=1u
X1768 GND.t1263 VDD GND.t1227 GND.t1262 sg13_lv_nmos ad=0.1428p pd=1.52u as=0 ps=0 w=0.42u l=1u
X1769 _168_.A a_11946_9484# GND.t169 GND.t1379 sg13_lv_nmos ad=0.2516p pd=2.16u as=0.1406p ps=1.12u w=0.74u l=0.13u
X1770 GND.t671 VDD GND.t671 GND.t1016 sg13_lv_nmos ad=0.1428p pd=1.52u as=0 ps=0 w=0.42u l=1u
X1771 VDD _190_.A _196_.Y VDD sg13_lv_pmos ad=0.3808p pd=2.92u as=0.2128p ps=1.5u w=1.12u l=0.13u
X1772 VDD GND.t465 VDD VDD sg13_lv_pmos ad=0.34p pd=2.68u as=0 ps=0 w=1u l=1u
X1773 VDD GND.t764 VDD VDD sg13_lv_pmos ad=0.19p pd=1.38u as=0 ps=0 w=1u l=1u
X1774 VDD _193_.Y a_7616_15437# VDD sg13_lv_pmos ad=0.2856p pd=2.36u as=0.1596p ps=1.22u w=0.84u l=0.13u
X1775 GND.t144 _250_.RESET_B a_1956_16434# GND.t629 sg13_lv_nmos ad=0.1626p pd=1.415u as=60.89999f ps=0.71u w=0.42u l=0.13u
X1776 GND.t277 clkbuf_1_0__f_sclk.A a_3380_13690# GND.t46 sg13_lv_nmos ad=0.2516p pd=2.16u as=0.1406p ps=1.12u w=0.74u l=0.13u
X1777 VDD GND.t1347 VDD VDD sg13_lv_pmos ad=0.34p pd=2.68u as=0 ps=0 w=1u l=1u
X1778 a_3695_8797# a_2853_8447# a_3601_8797# GND.t21 sg13_lv_nmos ad=0.12665p pd=1.145u as=0.1428p ps=1.52u w=0.42u l=0.13u
X1779 GND.t26 VDD GND.t26 GND.t683 sg13_lv_nmos ad=0.1428p pd=1.52u as=0 ps=0 w=0.42u l=1u
X1780 GND.t726 VDD GND.t726 GND.t158 sg13_lv_nmos ad=79.8f pd=0.8u as=0 ps=0 w=0.42u l=1u
X1781 _224_.Y _215_.A VDD VDD sg13_lv_pmos ad=0.3808p pd=2.92u as=0.3808p ps=2.92u w=1.12u l=0.13u
X1782 GND.t1032 VDD GND.t1027 GND.t1031 sg13_lv_nmos ad=0.1428p pd=1.52u as=0 ps=0 w=0.42u l=1u
X1783 GND.t1006 VDD GND.t1006 GND.t1008 sg13_lv_nmos ad=0.1428p pd=1.52u as=0 ps=0 w=0.42u l=1u
X1784 _178_.B1 _176_.B a_6579_11460# VDD sg13_lv_pmos ad=0.2408p pd=1.55u as=0.1428p ps=1.375u w=1.12u l=0.13u
X1785 GND.t557 VDD GND.t557 GND.t1088 sg13_lv_nmos ad=79.8f pd=0.8u as=0 ps=0 w=0.42u l=1u
X1786 _222_.Y _222_.A VDD VDD sg13_lv_pmos ad=0.3808p pd=2.92u as=0.3808p ps=2.92u w=1.12u l=0.13u
X1787 VDD GND.t1266 VDD VDD sg13_lv_pmos ad=0.34p pd=2.68u as=0 ps=0 w=1u l=1u
X1788 a_14794_8404# a_15237_8447# a_15177_8483# VDD sg13_lv_pmos ad=79.8f pd=0.8u as=63f ps=0.72u w=0.42u l=0.13u
X1789 a_2602_3868# a_3045_3911# a_2342_4338# GND.t505 sg13_lv_nmos ad=79.8f pd=0.8u as=0.1296p ps=1.52u w=0.42u l=0.13u
X1790 a_13820_4948# _151_.B VDD VDD sg13_lv_pmos ad=0.2128p pd=1.5u as=0.2128p ps=1.5u w=1.12u l=0.13u
X1791 a_14820_11464# a_15339_11471# a_16079_11821# GND.t3 sg13_lv_nmos ad=0.3473p pd=2.71u as=0.12665p ps=1.145u w=0.74u l=0.13u
X1792 a_13413_11460# _126_.B1 VDD VDD sg13_lv_pmos ad=0.2464p pd=1.56u as=0.3808p ps=2.92u w=1.12u l=0.13u
X1793 fanout8.A a_1192_17508# GND.t465 GND.t464 sg13_lv_nmos ad=0.2886p pd=2.26u as=0.14875p ps=1.16u w=0.74u l=0.13u
X1794 a_3760_12430# a_3503_12287# a_3922_12210# GND.t1486 sg13_lv_nmos ad=0.1428p pd=1.52u as=37.8f ps=0.6u w=0.42u l=0.13u
X1795 VDD GND.t703 VDD VDD sg13_lv_pmos ad=0.34p pd=2.68u as=0 ps=0 w=1u l=1u
X1796 GND.t319 _193_.Y a_7985_13776# GND.t46 sg13_lv_nmos ad=0.15245p pd=1.17u as=0.17462p ps=1.185u w=0.55u l=0.13u
X1797 GND.t441 _260_.CLK _131_.B1 GND.t540 sg13_lv_nmos ad=0.2516p pd=2.16u as=0.1406p ps=1.12u w=0.74u l=0.13u
X1798 GND.t342 VDD GND.t342 GND.t1256 sg13_lv_nmos ad=0.1428p pd=1.52u as=0 ps=0 w=0.42u l=1u
X1799 VDD GND.t1094 VDD VDD sg13_lv_pmos ad=0.19p pd=1.38u as=0 ps=0 w=1u l=1u
X1800 GND.t321 _230_.Y a_8964_13722# GND.t389 sg13_lv_nmos ad=0.1626p pd=1.415u as=60.89999f ps=0.71u w=0.42u l=0.13u
X1801 a_2628_3904# a_2602_3868# VDD VDD sg13_lv_pmos ad=0.34p pd=2.68u as=0.36237p ps=2.605u w=1u l=0.13u
X1802 a_9120_9501# _171_.Y a_9083_9232# GND.t21 sg13_lv_nmos ad=0.2176p pd=1.96u as=78.39999f ps=0.885u w=0.64u l=0.13u
X1803 GND.t273 clkbuf_1_0__f_sclk.A a_3380_13690# GND.t46 sg13_lv_nmos ad=0.1406p pd=1.12u as=0.1406p ps=1.12u w=0.74u l=0.13u
X1804 a_9444_12223# a_9156_12528# a_9382_12223# GND.t1564 sg13_lv_nmos ad=0.1428p pd=1.52u as=37.8f ps=0.6u w=0.42u l=0.13u
X1805 GND.t5 VDD GND.t5 GND.t83 sg13_lv_nmos ad=79.8f pd=0.8u as=0 ps=0 w=0.42u l=1u
X1806 VDD GND.t557 VDD VDD sg13_lv_pmos ad=0.19p pd=1.38u as=0 ps=0 w=1u l=1u
X1807 _184_.Y _173_.Y VDD VDD sg13_lv_pmos ad=0.3808p pd=2.92u as=0.2128p ps=1.5u w=1.12u l=0.13u
X1808 VDD GND.t797 VDD VDD sg13_lv_pmos ad=0.34p pd=2.68u as=0 ps=0 w=1u l=1u
X1809 GND.t307 VDD GND.t307 GND.t925 sg13_lv_nmos ad=79.8f pd=0.8u as=0 ps=0 w=0.42u l=1u
X1810 GND.t718 VDD GND.t718 GND.t712 sg13_lv_nmos ad=0.1428p pd=1.52u as=0 ps=0 w=0.42u l=1u
X1811 GND.t838 _148_.B a_5050_15238# GND.t1540 sg13_lv_nmos ad=0.2516p pd=2.16u as=0.1406p ps=1.12u w=0.74u l=0.13u
X1812 GND.t253 VDD GND.t253 GND.t939 sg13_lv_nmos ad=0.1428p pd=1.52u as=0 ps=0 w=0.42u l=1u
X1813 GND.t333 _151_.B a_13649_4704# GND.t432 sg13_lv_nmos ad=0.15245p pd=1.17u as=0.17462p ps=1.185u w=0.55u l=0.13u
X1814 VDD _145_.A2 a_7872_5451# VDD sg13_lv_pmos ad=0.2891p pd=1.695u as=0.1596p ps=1.22u w=0.84u l=0.13u
X1815 a_3952_8678# a_3695_8797# a_4114_8874# GND.t21 sg13_lv_nmos ad=0.1428p pd=1.52u as=37.8f ps=0.6u w=0.42u l=0.13u
X1816 VDD GND.t404 VDD VDD sg13_lv_pmos ad=0.34p pd=2.68u as=0 ps=0 w=1u l=1u
X1817 VDD _149_.A a_13914_5412# VDD sg13_lv_pmos ad=0.2891p pd=1.695u as=0.1428p ps=1.375u w=1.12u l=0.13u
X1818 a_2620_7678# _148_.A a_2126_7864# GND.t1585 sg13_lv_nmos ad=0.13135p pd=1.095u as=0.1628p ps=1.18u w=0.74u l=0.13u
X1819 a_6836_3900# a_6810_3863# _210_.B VDD sg13_lv_pmos ad=0.2128p pd=1.5u as=0.3808p ps=2.92u w=1.12u l=0.13u
X1820 _236_.Y _236_.A VDD VDD sg13_lv_pmos ad=0.3808p pd=2.92u as=0.3808p ps=2.92u w=1.12u l=0.13u
X1821 GND.t136 VDD GND.t136 GND.t997 sg13_lv_nmos ad=79.8f pd=0.8u as=0 ps=0 w=0.42u l=1u
X1822 a_15767_17137# _211_.Y a_16514_16746# GND.t10 sg13_lv_nmos ad=0.1428p pd=1.52u as=60.89999f ps=0.71u w=0.42u l=0.13u
X1823 VDD a_3956_6888# _243_.CLK VDD sg13_lv_pmos ad=0.2128p pd=1.5u as=0.2128p ps=1.5u w=1.12u l=0.13u
X1824 VDD _243_.RESET_B a_2602_3868# VDD sg13_lv_pmos ad=0.1563p pd=1.22u as=0.147p ps=1.54u w=0.42u l=0.13u
X1825 _164_.Y _164_.B1 a_10895_8436# VDD sg13_lv_pmos ad=0.2128p pd=1.5u as=0.2128p ps=1.5u w=1.12u l=0.13u
X1826 GND.t89 _171_.Y a_8705_9212# GND.t21 sg13_lv_nmos ad=0.2516p pd=2.16u as=0.1406p ps=1.12u w=0.74u l=0.13u
X1827 GND.t249 a_15237_11471# a_15339_11471# GND.t385 sg13_lv_nmos ad=3.6571p pd=23.85u as=0.2516p ps=2.16u w=0.74u l=0.13u
X1828 a_10752_7989# _154_.X a_10715_7720# GND.t346 sg13_lv_nmos ad=0.2176p pd=1.96u as=78.39999f ps=0.885u w=0.64u l=0.13u
X1829 VDD GND.t121 VDD VDD sg13_lv_pmos ad=0.34p pd=2.68u as=0 ps=0 w=1u l=1u
X1830 VDD _208_.X a_6720_17061# VDD sg13_lv_pmos ad=0.2891p pd=1.695u as=0.1596p ps=1.22u w=0.84u l=0.13u
X1831 a_6584_12218# _192_.B a_6482_12218# GND.t98 sg13_lv_nmos ad=0.1406p pd=1.12u as=0.1406p ps=1.12u w=0.74u l=0.13u
X1832 VDD GND.t915 VDD VDD sg13_lv_pmos ad=0.19p pd=1.38u as=0 ps=0 w=1u l=1u
X1833 _243_.CLK a_3956_6888# VDD VDD sg13_lv_pmos ad=0.2128p pd=1.5u as=0.2128p ps=1.5u w=1.12u l=0.13u
X1834 GND.t1076 VDD GND.t89 GND.t21 sg13_lv_nmos ad=0.1428p pd=1.52u as=0 ps=0 w=0.42u l=1u
X1835 VDD a_2853_8447# a_2955_8447# VDD sg13_lv_pmos ad=2.75005p pd=18.05u as=0.3864p ps=2.93u w=1.12u l=0.13u
X1836 a_10895_8436# _145_.X VDD VDD sg13_lv_pmos ad=0.2128p pd=1.5u as=0.2128p ps=1.5u w=1.12u l=0.13u
X1837 a_2126_13912# _120_.A0 a_2298_14020# VDD sg13_lv_pmos ad=0.2225p pd=1.445u as=0.2975p ps=1.595u w=1u l=0.13u
X1838 _126_.B1 a_14058_12508# GND.t55 GND.t1583 sg13_lv_nmos ad=0.2516p pd=2.16u as=0.1406p ps=1.12u w=0.74u l=0.13u
X1839 _162_.B a_10752_7989# a_10901_7678# GND.t1398 sg13_lv_nmos ad=0.2516p pd=2.16u as=0.1406p ps=1.12u w=0.74u l=0.13u
X1840 VDD GND.t77 VDD VDD sg13_lv_pmos ad=0.19p pd=1.38u as=0 ps=0 w=1u l=1u
X1841 GND.t345 VDD GND.t345 GND.t1131 sg13_lv_nmos ad=0.1428p pd=1.52u as=0 ps=0 w=0.42u l=1u
X1842 GND.t897 VDD GND.t897 GND.t899 sg13_lv_nmos ad=79.8f pd=0.8u as=0 ps=0 w=0.42u l=1u
X1843 a_1862_13410# a_2667_12983# a_2122_12940# VDD sg13_lv_pmos ad=0.1428p pd=1.52u as=79.8f ps=0.8u w=0.42u l=0.13u
X1844 a_4089_4023# a_3147_3911# a_3887_4261# VDD sg13_lv_pmos ad=93.45f pd=0.865u as=0.2048p ps=1.63u w=0.42u l=0.13u
X1845 a_11172_16746# _212_.Y a_11078_16746# GND.t19 sg13_lv_nmos ad=60.89999f pd=0.71u as=0.1428p ps=1.52u w=0.42u l=0.13u
X1846 a_10415_13799# a_9573_13701# a_9156_14040# VDD sg13_lv_pmos ad=0.2048p pd=1.63u as=0.34p ps=2.68u w=1u l=0.13u
X1847 VDD GND.t1079 VDD VDD sg13_lv_pmos ad=0.34p pd=2.68u as=0 ps=0 w=1u l=1u
X1848 GND.t885 VDD GND.t884 GND.t46 sg13_lv_nmos ad=0.1428p pd=1.52u as=0 ps=0 w=0.42u l=1u
X1849 VDD a_2126_11726# _120_.X VDD sg13_lv_pmos ad=0.2198p pd=1.52u as=0.6048p ps=3.32u w=1.12u l=0.13u
X1850 a_10617_12525# a_9675_12332# a_10415_12287# VDD sg13_lv_pmos ad=93.45f pd=0.865u as=0.2048p ps=1.63u w=0.42u l=0.13u
X1851 GND.t953 _148_.B a_4858_12214# GND.t1541 sg13_lv_nmos ad=0.2516p pd=2.16u as=0.1406p ps=1.12u w=0.74u l=0.13u
X1852 GND.t1177 VDD GND.t1178 GND.t5 sg13_lv_nmos ad=79.8f pd=0.8u as=0 ps=0 w=0.42u l=1u
X1853 VDD _259_.RESET_B a_8006_16746# VDD sg13_lv_pmos ad=0.36237p pd=2.605u as=79.8f ps=0.8u w=0.42u l=0.13u
X1854 VDD GND.t1352 VDD VDD sg13_lv_pmos ad=0.34p pd=2.68u as=0 ps=0 w=1u l=1u
X1855 VDD GND.t1185 VDD VDD sg13_lv_pmos ad=0.34p pd=2.68u as=0 ps=0 w=1u l=1u
X1856 VDD GND.t519 VDD VDD sg13_lv_pmos ad=0.34p pd=2.68u as=0 ps=0 w=1u l=1u
X1857 a_2724_8861# a_2436_8440# a_2662_8861# GND.t127 sg13_lv_nmos ad=0.1428p pd=1.52u as=37.8f ps=0.6u w=0.42u l=0.13u
X1858 a_2218_12433# a_2661_12189# a_1958_12210# GND.t62 sg13_lv_nmos ad=79.8f pd=0.8u as=0.1296p ps=1.52u w=0.42u l=0.13u
X1859 a_9322_4873# a_9765_4629# a_9705_5041# VDD sg13_lv_pmos ad=79.8f pd=0.8u as=63f ps=0.72u w=0.42u l=0.13u
X1860 GND.t1373 VDD GND.t1372 GND.t1371 sg13_lv_nmos ad=0.1428p pd=1.52u as=0 ps=0 w=0.42u l=1u
X1861 GND.t569 VDD GND.t279 GND.t1090 sg13_lv_nmos ad=79.8f pd=0.8u as=0 ps=0 w=0.42u l=1u
X1862 a_14265_16119# a_13323_16007# a_14063_16357# VDD sg13_lv_pmos ad=93.45f pd=0.865u as=0.2048p ps=1.63u w=0.42u l=0.13u
X1863 VDD GND.t247 VDD VDD sg13_lv_pmos ad=0.19p pd=1.38u as=0 ps=0 w=1u l=1u
X1864 a_2398_5782# _125_.A1 a_2301_5782# GND.t83 sg13_lv_nmos ad=0.1628p pd=1.18u as=0.13135p ps=1.095u w=0.74u l=0.13u
X1865 _230_.Y _236_.A GND.t625 GND.t46 sg13_lv_nmos ad=0.2516p pd=2.16u as=0.2516p ps=2.16u w=0.74u l=0.13u
X1866 _210_.Y a_6060_4166# VDD VDD sg13_lv_pmos ad=0.2408p pd=1.55u as=0.3808p ps=2.92u w=1.12u l=0.13u
X1867 a_3956_6888# clkbuf_1_0__f_sclk.A GND.t279 GND.t281 sg13_lv_nmos ad=0.1406p pd=1.12u as=0.1406p ps=1.12u w=0.74u l=0.13u
X1868 a_10308_9199# a_10539_9308# a_9994_9409# GND.t21 sg13_lv_nmos ad=0.2373p pd=1.97u as=79.8f ps=0.8u w=0.42u l=0.13u
X1869 a_5297_12264# _120_.A0 GND.t413 GND.t412 sg13_lv_nmos ad=0.17462p pd=1.185u as=0.374p ps=2.46u w=0.55u l=0.13u
X1870 VDD GND.t221 VDD VDD sg13_lv_pmos ad=0.34p pd=2.68u as=0 ps=0 w=1u l=1u
X1871 GND.t1224 VDD GND.t342 GND.t1258 sg13_lv_nmos ad=0.1428p pd=1.52u as=0 ps=0 w=0.42u l=1u
X1872 a_2608_6166# _148_.A a_2494_6166# GND.t83 sg13_lv_nmos ad=0.3367p pd=1.65u as=0.1628p ps=1.18u w=0.74u l=0.13u
X1873 GND.t26 VDD GND.t26 GND.t682 sg13_lv_nmos ad=79.8f pd=0.8u as=0 ps=0 w=0.42u l=1u
X1874 a_8557_4248# _145_.B1 a_8386_3900# VDD sg13_lv_pmos ad=0.35p pd=2.7u as=0.2125p ps=1.425u w=1u l=0.13u
X1875 _143_.A a_6747_5468# a_6949_5782# GND.t5 sg13_lv_nmos ad=0.333p pd=2.38u as=0.1406p ps=1.12u w=0.74u l=0.13u
X1876 GND.t1191 VDD GND.t181 GND.t5 sg13_lv_nmos ad=79.8f pd=0.8u as=0 ps=0 w=0.42u l=1u
X1877 GND.t1006 VDD GND.t1006 GND.t1007 sg13_lv_nmos ad=79.8f pd=0.8u as=0 ps=0 w=0.42u l=1u
X1878 VDD GND.t618 VDD VDD sg13_lv_pmos ad=0.34p pd=2.68u as=0 ps=0 w=1u l=1u
X1879 GND.t90 _164_.Y a_9269_9190# GND.t21 sg13_lv_nmos ad=0.1898p pd=1.36u as=0.2516p ps=2.16u w=0.74u l=0.13u
X1880 a_8870_13722# _194_.X VDD VDD sg13_lv_pmos ad=79.8f pd=0.8u as=0.1428p ps=1.52u w=0.42u l=0.13u
X1881 a_7929_4965# a_6987_4772# a_7727_4727# VDD sg13_lv_pmos ad=93.45f pd=0.865u as=0.2048p ps=1.63u w=0.42u l=0.13u
X1882 GND.t1027 VDD GND.t1025 GND.t1026 sg13_lv_nmos ad=0.1428p pd=1.52u as=0 ps=0 w=0.42u l=1u
X1883 a_8156_14020# _193_.Y VDD VDD sg13_lv_pmos ad=0.2128p pd=1.5u as=0.2128p ps=1.5u w=1.12u l=0.13u
X1884 GND.t279 a_3956_6888# _243_.CLK GND.t573 sg13_lv_nmos ad=0.1406p pd=1.12u as=0.1406p ps=1.12u w=0.74u l=0.13u
X1885 VDD _214_.A _214_.Y VDD sg13_lv_pmos ad=0.3808p pd=2.92u as=0.3808p ps=2.92u w=1.12u l=0.13u
X1886 VDD GND.t557 VDD VDD sg13_lv_pmos ad=0.19p pd=1.38u as=0 ps=0 w=1u l=1u
X1887 GND.t295 a_4625_16800# _208_.X GND.t14 sg13_lv_nmos ad=0.3108p pd=2.32u as=0.1628p ps=1.18u w=0.74u l=0.13u
X1888 a_2298_15532# a_2232_15428# VDD VDD sg13_lv_pmos ad=0.2975p pd=1.595u as=0.2198p ps=1.52u w=1u l=0.13u
X1889 VDD a_2075_5468# a_2575_5436# VDD sg13_lv_pmos ad=0.2198p pd=1.52u as=0.2975p ps=1.595u w=1u l=0.13u
X1890 _157_.Y _157_.B a_13130_4948# VDD sg13_lv_pmos ad=0.3808p pd=2.92u as=0.1176p ps=1.33u w=1.12u l=0.13u
X1891 GND.t5 a_15141_5423# a_15243_5423# GND.t81 sg13_lv_nmos ad=7.07497p pd=46.475u as=0.2516p ps=2.16u w=0.74u l=0.13u
X1892 GND.t228 _138_.Y a_8694_5770# GND.t5 sg13_lv_nmos ad=0.15245p pd=1.17u as=88.8f ps=0.98u w=0.74u l=0.13u
X1893 VDD GND.t26 VDD VDD sg13_lv_pmos ad=0.19p pd=1.38u as=0 ps=0 w=1u l=1u
X1894 a_12778_15964# a_13221_16007# a_13161_16043# VDD sg13_lv_pmos ad=79.8f pd=0.8u as=63f ps=0.72u w=0.42u l=0.13u
X1895 GND.t35 VDD GND.t1094 GND.t1125 sg13_lv_nmos ad=0.1428p pd=1.52u as=0 ps=0 w=0.42u l=1u
X1896 _243_.CLK a_3956_6888# VDD VDD sg13_lv_pmos ad=0.2128p pd=1.5u as=0.2128p ps=1.5u w=1.12u l=0.13u
X1897 GND.t40 _178_.B1 _178_.Y GND.t21 sg13_lv_nmos ad=0.2516p pd=2.16u as=0.1406p ps=1.12u w=0.74u l=0.13u
X1898 VDD GND.t1057 VDD VDD sg13_lv_pmos ad=0.34p pd=2.68u as=0 ps=0 w=1u l=1u
X1899 GND.t131 a_10672_12430# a_10321_12287# GND.t1381 sg13_lv_nmos ad=79.8f pd=0.8u as=0.1428p ps=1.52u w=0.42u l=0.13u
X1900 a_9573_12189# _251_.CLK GND.t249 GND.t548 sg13_lv_nmos ad=0.2516p pd=2.16u as=3.6571p ps=23.85u w=0.74u l=0.13u
X1901 _122_.A0 a_4362_8436# VDD VDD sg13_lv_pmos ad=0.3808p pd=2.92u as=0.2128p ps=1.5u w=1.12u l=0.13u
X1902 a_7168_15260# _205_.B1 _205_.Y GND.t603 sg13_lv_nmos ad=0.1406p pd=1.12u as=0.2516p ps=2.16u w=0.74u l=0.13u
X1903 VDD GND.t404 VDD VDD sg13_lv_pmos ad=0.19p pd=1.38u as=0 ps=0 w=1u l=1u
X1904 GND.t270 _239_.Y a_14148_15234# GND.t308 sg13_lv_nmos ad=0.1626p pd=1.415u as=60.89999f ps=0.71u w=0.42u l=0.13u
X1905 GND.t188 VDD GND.t557 GND.t1084 sg13_lv_nmos ad=79.8f pd=0.8u as=0 ps=0 w=0.42u l=1u
X1906 a_10672_12430# a_10415_12287# a_10834_12210# GND.t1566 sg13_lv_nmos ad=0.1428p pd=1.52u as=37.8f ps=0.6u w=0.42u l=0.13u
X1907 _244_.D a_2494_6166# VDD VDD sg13_lv_pmos ad=0.6048p pd=3.32u as=0.2198p ps=1.52u w=1.12u l=0.13u
X1908 VDD GND.t348 VDD VDD sg13_lv_pmos ad=0.19p pd=1.38u as=0 ps=0 w=1u l=1u
X1909 VDD GND.t279 VDD VDD sg13_lv_pmos ad=0.34p pd=2.68u as=0 ps=0 w=1u l=1u
X1910 a_7064_9194# _174_.Y a_6962_9194# GND.t21 sg13_lv_nmos ad=0.1406p pd=1.12u as=0.1406p ps=1.12u w=0.74u l=0.13u
X1911 _199_.B1 _207_.A2 a_5619_17044# VDD sg13_lv_pmos ad=0.2408p pd=1.55u as=0.1428p ps=1.375u w=1.12u l=0.13u
X1912 a_15237_9165# _260_.CLK GND.t21 GND.t539 sg13_lv_nmos ad=0.2516p pd=2.16u as=4.0443p ps=25.39u w=0.74u l=0.13u
X1913 VDD GND.t1170 VDD VDD sg13_lv_pmos ad=0.19p pd=1.38u as=0 ps=0 w=1u l=1u
X1914 _261_.RESET_B _236_.A GND.t666 GND.t665 sg13_lv_nmos ad=0.2516p pd=2.16u as=0.2516p ps=2.16u w=0.74u l=0.13u
X1915 a_6095_4270# _210_.A GND.t65 GND.t84 sg13_lv_nmos ad=0.2516p pd=2.16u as=0.1898p ps=1.36u w=0.74u l=0.13u
X1916 GND.t1252 VDD GND.t162 GND.t1251 sg13_lv_nmos ad=0.1428p pd=1.52u as=0 ps=0 w=0.42u l=1u
X1917 VDD GND.t1074 VDD VDD sg13_lv_pmos ad=0.19p pd=1.38u as=0 ps=0 w=1u l=1u
X1918 a_3588_4663# a_3300_4968# a_3526_4663# GND.t45 sg13_lv_nmos ad=0.1428p pd=1.52u as=37.8f ps=0.6u w=0.42u l=0.13u
X1919 a_13403_8436# _151_.B VDD VDD sg13_lv_pmos ad=0.3808p pd=2.92u as=0.2128p ps=1.5u w=1.12u l=0.13u
X1920 GND.t286 _251_.CLK a_16840_4688# GND.t1555 sg13_lv_nmos ad=0.14875p pd=1.16u as=0.187p ps=1.78u w=0.55u l=0.13u
X1921 VDD GND.t1357 VDD VDD sg13_lv_pmos ad=0.34p pd=2.68u as=0 ps=0 w=1u l=1u
X1922 a_6683_16792# _205_.Y GND.t656 GND.t14 sg13_lv_nmos ad=78.39999f pd=0.885u as=0.2272p ps=1.99u w=0.64u l=0.13u
X1923 GND.t776 VDD GND.t20 GND.t775 sg13_lv_nmos ad=0.1428p pd=1.52u as=0 ps=0 w=0.42u l=1u
X1924 freq_out a_16840_4688# GND.t286 GND.t285 sg13_lv_nmos ad=0.2886p pd=2.26u as=0.14875p ps=1.16u w=0.74u l=0.13u
X1925 GND.t146 _261_.RESET_B a_11940_12210# GND.t145 sg13_lv_nmos ad=0.1626p pd=1.415u as=60.89999f ps=0.71u w=0.42u l=0.13u
X1926 GND.t279 VDD GND.t279 GND.t1092 sg13_lv_nmos ad=79.8f pd=0.8u as=0 ps=0 w=0.42u l=1u
X1927 a_3045_3911# _243_.CLK GND.t234 GND.t235 sg13_lv_nmos ad=0.2516p pd=2.16u as=4.10715p ps=27.105u w=0.74u l=0.13u
X1928 VDD GND.t812 VDD VDD sg13_lv_pmos ad=0.34p pd=2.68u as=0 ps=0 w=1u l=1u
X1929 a_4593_17068# _250_.Q VDD VDD sg13_lv_pmos ad=0.1225p pd=1.245u as=0.36p ps=2.72u w=1u l=0.13u
X1930 a_3826_13410# _221_.Y GND.t369 GND.t46 sg13_lv_nmos ad=37.8f pd=0.6u as=79.8f ps=0.8u w=0.42u l=0.13u
X1931 a_12132_12528# a_12106_12433# VDD VDD sg13_lv_pmos ad=0.34p pd=2.68u as=0.36237p ps=2.605u w=1u l=0.13u
X1932 GND.t404 VDD GND.t404 GND.t962 sg13_lv_nmos ad=0.1428p pd=1.52u as=0 ps=0 w=0.42u l=1u
X1933 VDD GND.t726 VDD VDD sg13_lv_pmos ad=0.19p pd=1.38u as=0 ps=0 w=1u l=1u
X1934 GND.t261 _259_.RESET_B a_8100_16746# GND.t262 sg13_lv_nmos ad=0.1626p pd=1.415u as=60.89999f ps=0.71u w=0.42u l=0.13u
X1935 a_7074_15532# _186_.Y a_6862_15532# VDD sg13_lv_pmos ad=0.2128p pd=1.5u as=0.2128p ps=1.5u w=1.12u l=0.13u
X1936 a_14357_12972# _131_.A2 VDD VDD sg13_lv_pmos ad=0.2128p pd=1.5u as=0.2128p ps=1.5u w=1.12u l=0.13u
X1937 a_4512_17547# fanout6.A a_4475_17856# GND.t1408 sg13_lv_nmos ad=0.2176p pd=1.96u as=78.39999f ps=0.885u w=0.64u l=0.13u
X1938 GND.t307 VDD GND.t307 GND.t927 sg13_lv_nmos ad=79.8f pd=0.8u as=0 ps=0 w=0.42u l=1u
X1939 VDD _149_.A a_13019_6460# VDD sg13_lv_pmos ad=0.2128p pd=1.5u as=0.2128p ps=1.5u w=1.12u l=0.13u
X1940 VDD GND.t26 VDD VDD sg13_lv_pmos ad=0.19p pd=1.38u as=0 ps=0 w=1u l=1u
X1941 VDD GND.t790 VDD VDD sg13_lv_pmos ad=0.19p pd=1.38u as=0 ps=0 w=1u l=1u
X1942 a_7984_4870# _224_.Y VDD VDD sg13_lv_pmos ad=79.8f pd=0.8u as=1.48542p ps=9.54u w=0.42u l=0.13u
X1943 a_13121_6188# _149_.A _153_.Y GND.t5 sg13_lv_nmos ad=0.1406p pd=1.12u as=0.1406p ps=1.12u w=0.74u l=0.13u
X1944 _199_.B1 a_5376_17061# a_5525_16750# GND.t14 sg13_lv_nmos ad=0.2516p pd=2.16u as=0.1406p ps=1.12u w=0.74u l=0.13u
X1945 GND.t182 _149_.A a_14196_5760# GND.t5 sg13_lv_nmos ad=0.2272p pd=1.99u as=78.39999f ps=0.885u w=0.64u l=0.13u
X1946 GND.t77 _131_.A2 a_14753_10724# GND.t111 sg13_lv_nmos ad=0.2516p pd=2.16u as=0.1406p ps=1.12u w=0.74u l=0.13u
X1947 a_16185_5535# a_15243_5423# a_15983_5773# VDD sg13_lv_pmos ad=93.45f pd=0.865u as=0.2048p ps=1.63u w=0.42u l=0.13u
X1948 GND.t65 a_7984_4870# a_7633_4727# GND.t654 sg13_lv_nmos ad=79.8f pd=0.8u as=0.1428p ps=1.52u w=0.42u l=0.13u
X1949 GND.t519 VDD GND.t519 GND.t1110 sg13_lv_nmos ad=0.1428p pd=1.52u as=0 ps=0 w=0.42u l=1u
X1950 VDD a_15980_7638# _251_.CLK VDD sg13_lv_pmos ad=0.2114p pd=1.54u as=0.42p ps=2.99u w=1.12u l=0.13u
X1951 VDD a_2126_17774# _250_.D VDD sg13_lv_pmos ad=0.2198p pd=1.52u as=0.6048p ps=3.32u w=1.12u l=0.13u
X1952 GND.t806 VDD GND.t803 GND.t805 sg13_lv_nmos ad=0.1428p pd=1.52u as=0 ps=0 w=0.42u l=1u
X1953 a_3717_4629# _243_.CLK GND.t234 GND.t233 sg13_lv_nmos ad=0.2516p pd=2.16u as=4.10715p ps=27.105u w=0.74u l=0.13u
X1954 VDD GND.t693 VDD VDD sg13_lv_pmos ad=0.19p pd=1.38u as=0 ps=0 w=1u l=1u
X1955 VDD _225_.A.t2 _252_.RESET_B VDD sg13_lv_pmos ad=0.3808p pd=2.92u as=0.3808p ps=2.92u w=1.12u l=0.13u
X1956 GND.t337 VDD GND.t151 GND.t21 sg13_lv_nmos ad=0.1428p pd=1.52u as=0 ps=0 w=0.42u l=1u
X1957 a_14820_8440# a_14794_8404# VDD VDD sg13_lv_pmos ad=0.34p pd=2.68u as=0.36237p ps=2.605u w=1u l=0.13u
X1958 a_15108_9199# a_15339_9308# a_14794_9409# GND.t128 sg13_lv_nmos ad=0.2373p pd=1.97u as=79.8f ps=0.8u w=0.42u l=0.13u
X1959 a_16240_12430# _235_.Y VDD VDD sg13_lv_pmos ad=79.8f pd=0.8u as=1.42082p ps=9.125u w=0.42u l=0.13u
X1960 VDD a_8557_4248# _145_.X VDD sg13_lv_pmos ad=0.3808p pd=2.92u as=0.2128p ps=1.5u w=1.12u l=0.13u
X1961 _225_.A.t0 a_9352_17508# VDD VDD sg13_lv_pmos ad=0.42p pd=2.99u as=0.2114p ps=1.54u w=1.12u l=0.13u
X1962 GND.t345 VDD GND.t33 GND.t1127 sg13_lv_nmos ad=0.1428p pd=1.52u as=0 ps=0 w=0.42u l=1u
X1963 VDD GND.t780 VDD VDD sg13_lv_pmos ad=0.34p pd=2.68u as=0 ps=0 w=1u l=1u
X1964 _244_.RESET_B _215_.A GND.t5 GND.t360 sg13_lv_nmos ad=0.2516p pd=2.16u as=0.2516p ps=2.16u w=0.74u l=0.13u
X1965 VDD GND.t1163 VDD VDD sg13_lv_pmos ad=0.19p pd=1.38u as=0 ps=0 w=1u l=1u
X1966 a_14359_16710# a_14919_16964# a_14940_16710# GND.t209 sg13_lv_nmos ad=0.12665p pd=1.145u as=0.3473p ps=2.71u w=0.74u l=0.13u
X1967 VDD _236_.A _240_.Y VDD sg13_lv_pmos ad=0.3808p pd=2.92u as=0.3808p ps=2.92u w=1.12u l=0.13u
X1968 GND.t1027 a_3886_10702# clkbuf_1_0__f_sclk.A GND.t1452 sg13_lv_nmos ad=0.1406p pd=1.12u as=0.1406p ps=1.12u w=0.74u l=0.13u
X1969 _239_.Y _225_.A GND.t495 GND.t494 sg13_lv_nmos ad=0.2516p pd=2.16u as=0.2516p ps=2.16u w=0.74u l=0.13u
X1970 VDD GND.t815 VDD VDD sg13_lv_pmos ad=0.19p pd=1.38u as=0 ps=0 w=1u l=1u
X1971 VDD GND.t1342 VDD VDD sg13_lv_pmos ad=0.34p pd=2.68u as=0 ps=0 w=1u l=1u
X1972 GND.t784 VDD GND.t767 GND.t10 sg13_lv_nmos ad=79.8f pd=0.8u as=0 ps=0 w=0.42u l=1u
X1973 a_4816_4870# _242_.RESET_B VDD VDD sg13_lv_pmos ad=79.8f pd=0.8u as=1.48542p ps=9.54u w=0.42u l=0.13u
X1974 GND.t671 VDD GND.t671 GND.t1055 sg13_lv_nmos ad=0.1428p pd=1.52u as=0 ps=0 w=0.42u l=1u
X1975 a_6971_16344# _201_.Y GND.t15 GND.t14 sg13_lv_nmos ad=78.39999f pd=0.885u as=0.2272p ps=1.99u w=0.64u l=0.13u
X1976 VDD GND.t266 VDD VDD sg13_lv_pmos ad=0.19p pd=1.38u as=0 ps=0 w=1u l=1u
X1977 VDD _173_.Y a_6124_9945# VDD sg13_lv_pmos ad=0.1596p pd=1.22u as=0.2856p ps=2.36u w=0.84u l=0.13u
X1978 GND.t557 VDD GND.t557 GND.t1086 sg13_lv_nmos ad=79.8f pd=0.8u as=0 ps=0 w=0.42u l=1u
X1979 a_16514_16746# _238_.Y GND.t68 GND.t394 sg13_lv_nmos ad=60.89999f pd=0.71u as=0.1626p ps=1.415u w=0.42u l=0.13u
X1980 GND.t1073 VDD GND.t1072 GND.t21 sg13_lv_nmos ad=0.1428p pd=1.52u as=0 ps=0 w=0.42u l=1u
X1981 a_6810_3863# _136_.B GND.t65 GND.t239 sg13_lv_nmos ad=0.17462p pd=1.185u as=0.15245p ps=1.17u w=0.55u l=0.13u
X1982 VDD _164_.Y a_8156_9928# VDD sg13_lv_pmos ad=0.3808p pd=2.92u as=0.2128p ps=1.5u w=1.12u l=0.15u
X1983 GND.t77 VDD GND.t1010 GND.t1045 sg13_lv_nmos ad=0.1428p pd=1.52u as=0 ps=0 w=0.42u l=1u
X1984 VDD GND.t1094 VDD VDD sg13_lv_pmos ad=0.34p pd=2.68u as=0 ps=0 w=1u l=1u
X1985 a_3695_9263# a_2853_9165# a_3601_9263# GND.t21 sg13_lv_nmos ad=0.12665p pd=1.145u as=0.1428p ps=1.52u w=0.42u l=0.13u
X1986 VDD a_6336_11499# _178_.B1 VDD sg13_lv_pmos ad=0.3808p pd=2.92u as=0.2408p ps=1.55u w=1.12u l=0.13u
X1987 a_10940_3900# _136_.A VDD VDD sg13_lv_pmos ad=0.2128p pd=1.5u as=0.2128p ps=1.5u w=1.12u l=0.13u
X1988 VDD a_3886_10702# clkbuf_1_0__f_sclk.A VDD sg13_lv_pmos ad=0.2128p pd=1.5u as=0.2128p ps=1.5u w=1.12u l=0.13u
X1989 a_2397_6166# _124_.S GND.t5 GND.t83 sg13_lv_nmos ad=0.13135p pd=1.095u as=0.18945p ps=1.27u w=0.74u l=0.13u
X1990 GND.t356 VDD GND.t1057 GND.t217 sg13_lv_nmos ad=0.1428p pd=1.52u as=0 ps=0 w=0.42u l=1u
X1991 GND.t1027 a_3886_10702# clkbuf_1_0__f_sclk.A GND.t1448 sg13_lv_nmos ad=0.1406p pd=1.12u as=0.1406p ps=1.12u w=0.74u l=0.13u
X1992 GND.t198 sclk a_3886_10702# GND.t1425 sg13_lv_nmos ad=0.1406p pd=1.12u as=0.1406p ps=1.12u w=0.74u l=0.13u
X1993 GND.t121 a_11536_17750# a_11185_17869# GND.t158 sg13_lv_nmos ad=79.8f pd=0.8u as=0.1428p ps=1.52u w=0.42u l=0.13u
X1994 VDD GND.t1327 VDD VDD sg13_lv_pmos ad=0.34p pd=2.68u as=0 ps=0 w=1u l=1u
X1995 VDD GND.t671 VDD VDD sg13_lv_pmos ad=0.34p pd=2.68u as=0 ps=0 w=1u l=1u
X1996 _237_.Y _236_.A VDD VDD sg13_lv_pmos ad=0.3808p pd=2.92u as=0.3808p ps=2.92u w=1.12u l=0.13u
X1997 a_10769_4258# _136_.A a_10737_3900# VDD sg13_lv_pmos ad=0.34p pd=2.68u as=0.1225p ps=1.245u w=1u l=0.13u
X1998 a_12549_7996# _162_.Y a_12215_7664# VDD sg13_lv_pmos ad=0.2125p pd=1.425u as=0.35p ps=2.7u w=1u l=0.13u
X1999 a_11661_4696# _243_.Q VDD VDD sg13_lv_pmos ad=0.1596p pd=1.22u as=0.2856p ps=2.36u w=0.84u l=0.13u
X2000 _177_.X a_6124_9945# GND.t42 GND.t1423 sg13_lv_nmos ad=0.2516p pd=2.16u as=0.1371p ps=1.12u w=0.74u l=0.13u
X2001 GND.t26 VDD GND.t26 GND.t736 sg13_lv_nmos ad=79.8f pd=0.8u as=0 ps=0 w=0.42u l=1u
X2002 VDD GND.t136 VDD VDD sg13_lv_pmos ad=0.34p pd=2.68u as=0 ps=0 w=1u l=1u
X2003 VDD _148_.B _195_.Y VDD sg13_lv_pmos ad=0.3808p pd=2.92u as=0.2128p ps=1.5u w=1.12u l=0.13u
X2004 GND.t441 VDD GND.t104 GND.t893 sg13_lv_nmos ad=0.1428p pd=1.52u as=0 ps=0 w=0.42u l=1u
X2005 a_2565_16725# _247_.CLK GND.t14 GND.t477 sg13_lv_nmos ad=0.2516p pd=2.16u as=2.6164p ps=16.515u w=0.74u l=0.13u
X2006 VDD _184_.Y a_7157_9948# VDD sg13_lv_pmos ad=0.2128p pd=1.5u as=0.3808p ps=2.92u w=1.12u l=0.13u
X2007 VDD _222_.A _250_.RESET_B VDD sg13_lv_pmos ad=0.3808p pd=2.92u as=0.3808p ps=2.92u w=1.12u l=0.13u
X2008 _192_.Y _187_.Y a_6584_12218# GND.t1484 sg13_lv_nmos ad=0.2516p pd=2.16u as=0.1406p ps=1.12u w=0.74u l=0.13u
X2009 GND.t279 VDD GND.t279 GND.t1091 sg13_lv_nmos ad=0.1428p pd=1.52u as=0 ps=0 w=0.42u l=1u
X2010 GND.t121 a_10220_18222# _236_.A GND.t554 sg13_lv_nmos ad=0.14875p pd=1.16u as=0.2886p ps=2.26u w=0.74u l=0.13u
X2011 a_10377_17555# a_10020_17512# VDD VDD sg13_lv_pmos ad=63f pd=0.72u as=0.1563p ps=1.22u w=0.42u l=0.13u
X2012 VDD a_3886_10702# clkbuf_1_0__f_sclk.A VDD sg13_lv_pmos ad=0.2128p pd=1.5u as=0.2128p ps=1.5u w=1.12u l=0.13u
X2013 VDD sclk a_3886_10702# VDD sg13_lv_pmos ad=0.2128p pd=1.5u as=0.2128p ps=1.5u w=1.12u l=0.13u
X2014 VDD _124_.S a_2558_11484# VDD sg13_lv_pmos ad=0.253p pd=1.53u as=0.3325p ps=1.665u w=1u l=0.13u
X2015 a_3664_16966# a_3407_16823# a_3826_16746# GND.t14 sg13_lv_nmos ad=0.1428p pd=1.52u as=37.8f ps=0.6u w=0.42u l=0.13u
X2016 a_15767_17137# a_15071_17016# a_15861_16904# GND.t211 sg13_lv_nmos ad=0.1296p pd=1.52u as=79.8f ps=0.8u w=0.42u l=0.13u
X2017 a_3956_6888# clkbuf_1_0__f_sclk.A VDD VDD sg13_lv_pmos ad=0.2128p pd=1.5u as=0.2128p ps=1.5u w=1.12u l=0.13u
X2018 VDD GND.t671 VDD VDD sg13_lv_pmos ad=0.34p pd=2.68u as=0 ps=0 w=1u l=1u
X2019 VDD a_3695_8797# a_3952_8678# VDD sg13_lv_pmos ad=2.75005p pd=18.05u as=79.8f ps=0.8u w=0.42u l=0.13u
X2020 VDD _210_.B a_6747_5468# VDD sg13_lv_pmos ad=0.2198p pd=1.53u as=0.2856p ps=2.36u w=0.84u l=0.13u
X2021 GND.t310 a_15856_15454# a_15505_15311# GND.t589 sg13_lv_nmos ad=79.8f pd=0.8u as=0.1428p ps=1.52u w=0.42u l=0.13u
X2022 _194_.X _193_.Y a_8250_13738# GND.t46 sg13_lv_nmos ad=0.1628p pd=1.18u as=88.8f ps=0.98u w=0.74u l=0.13u
X2023 _136_.A a_8488_8436# GND.t152 GND.t21 sg13_lv_nmos ad=0.2886p pd=2.26u as=0.14875p ps=1.16u w=0.74u l=0.13u
X2024 clkbuf_1_0__f_sclk.A a_3886_10702# GND.t1027 GND.t1455 sg13_lv_nmos ad=0.1406p pd=1.12u as=0.1406p ps=1.12u w=0.74u l=0.13u
X2025 a_5427_15260# _196_.Y GND.t838 GND.t1581 sg13_lv_nmos ad=0.1406p pd=1.12u as=0.2516p ps=2.16u w=0.74u l=0.13u
X2026 VDD a_15599_15311# a_15856_15454# VDD sg13_lv_pmos ad=1.6291p pd=10.53u as=79.8f ps=0.8u w=0.42u l=0.13u
X2027 VDD _149_.A a_13740_5678# VDD sg13_lv_pmos ad=0.4536p pd=2.76u as=0.1596p ps=1.22u w=0.84u l=0.13u
X2028 VDD a_3956_6888# _243_.CLK VDD sg13_lv_pmos ad=0.2128p pd=1.5u as=0.2128p ps=1.5u w=1.12u l=0.13u
X2029 GND.t465 VDD GND.t465 GND.t676 sg13_lv_nmos ad=0.1428p pd=1.52u as=0 ps=0 w=0.42u l=1u
X2030 GND.t1000 VDD GND.t1000 GND.t1001 sg13_lv_nmos ad=0.1428p pd=1.52u as=0 ps=0 w=0.42u l=1u
X2031 GND.t1316 VDD GND.t1316 GND.t1315 sg13_lv_nmos ad=0.1428p pd=1.52u as=0 ps=0 w=0.42u l=1u
X2032 GND.t345 VDD GND.t345 GND.t1129 sg13_lv_nmos ad=0.1428p pd=1.52u as=0 ps=0 w=0.42u l=1u
X2033 VDD GND.t557 VDD VDD sg13_lv_pmos ad=0.34p pd=2.68u as=0 ps=0 w=1u l=1u
X2034 GND.t726 VDD GND.t726 GND.t158 sg13_lv_nmos ad=0.1428p pd=1.52u as=0 ps=0 w=0.42u l=1u
X2035 VDD GND.t1166 VDD VDD sg13_lv_pmos ad=0.19p pd=1.38u as=0 ps=0 w=1u l=1u
X2036 a_12623_16823# a_11781_16725# a_11364_17064# VDD sg13_lv_pmos ad=0.2048p pd=1.63u as=0.34p ps=2.68u w=1u l=0.13u
X2037 GND.t812 VDD GND.t812 GND.t813 sg13_lv_nmos ad=79.8f pd=0.8u as=0 ps=0 w=0.42u l=1u
X2038 _260_.RESET_B _225_.A VDD VDD sg13_lv_pmos ad=0.3808p pd=2.92u as=0.3808p ps=2.92u w=1.12u l=0.13u
X2039 GND.t229 VDD GND.t229 GND.t5 sg13_lv_nmos ad=79.8f pd=0.8u as=0 ps=0 w=0.42u l=1u
X2040 a_15081_12601# a_14724_12528# VDD VDD sg13_lv_pmos ad=63f pd=0.72u as=0.1563p ps=1.22u w=0.42u l=0.13u
X2041 _243_.RESET_B _215_.A GND.t354 GND.t355 sg13_lv_nmos ad=0.2516p pd=2.16u as=0.2516p ps=2.16u w=0.74u l=0.13u
X2042 a_2148_16000# a_2122_15964# VDD VDD sg13_lv_pmos ad=0.34p pd=2.68u as=0.36237p ps=2.605u w=1u l=0.13u
X2043 a_2374_16421# _250_.RESET_B GND.t144 GND.t630 sg13_lv_nmos ad=37.8f pd=0.6u as=0.1701p ps=1.65u w=0.42u l=0.13u
X2044 _143_.Y _143_.A GND.t225 GND.t224 sg13_lv_nmos ad=0.2516p pd=2.16u as=0.2516p ps=2.16u w=0.74u l=0.13u
X2045 VDD GND.t1065 VDD VDD sg13_lv_pmos ad=0.19p pd=1.38u as=0 ps=0 w=1u l=1u
X2046 clkbuf_1_0__f_sclk.A a_3886_10702# VDD VDD sg13_lv_pmos ad=0.2128p pd=1.5u as=0.2128p ps=1.5u w=1.12u l=0.13u
X2047 _170_.Y _168_.Y VDD VDD sg13_lv_pmos ad=0.2128p pd=1.5u as=0.3808p ps=2.92u w=1.12u l=0.13u
X2048 a_2232_17770# _124_.S VDD VDD sg13_lv_pmos ad=0.2856p pd=2.36u as=0.253p ps=1.53u w=0.84u l=0.13u
X2049 VDD GND.t1224 VDD VDD sg13_lv_pmos ad=0.19p pd=1.38u as=0 ps=0 w=1u l=1u
X2050 VDD GND.t1187 VDD VDD sg13_lv_pmos ad=0.19p pd=1.38u as=0 ps=0 w=1u l=1u
X2051 VDD GND.t1094 VDD VDD sg13_lv_pmos ad=0.34p pd=2.68u as=0 ps=0 w=1u l=1u
X2052 _260_.CLK a_16746_11460# VDD VDD sg13_lv_pmos ad=0.3808p pd=2.92u as=0.2128p ps=1.5u w=1.12u l=0.13u
X2053 GND.t169 _164_.B1 _164_.Y GND.t502 sg13_lv_nmos ad=0.2516p pd=2.16u as=0.1406p ps=1.12u w=0.74u l=0.13u
X2054 GND.t1227 VDD GND.t1227 GND.t1228 sg13_lv_nmos ad=0.1428p pd=1.52u as=0 ps=0 w=0.42u l=1u
X2055 VDD GND.t362 VDD VDD sg13_lv_pmos ad=0.34p pd=2.68u as=0 ps=0 w=1u l=1u
X2056 _247_.CLK a_3380_13690# VDD VDD sg13_lv_pmos ad=0.2128p pd=1.5u as=0.2128p ps=1.5u w=1.12u l=0.13u
X2057 GND.t307 VDD GND.t307 GND.t926 sg13_lv_nmos ad=0.1428p pd=1.52u as=0 ps=0 w=0.42u l=1u
X2058 a_2620_10318# _122_.A0 a_2126_10214# GND.t30 sg13_lv_nmos ad=0.13135p pd=1.095u as=0.1628p ps=1.18u w=0.74u l=0.13u
X2059 a_2628_3904# a_3147_3911# a_3887_4261# GND.t141 sg13_lv_nmos ad=0.3473p pd=2.71u as=0.12665p ps=1.145u w=0.74u l=0.13u
X2060 _174_.Y _168_.B VDD VDD sg13_lv_pmos ad=0.2128p pd=1.5u as=0.3808p ps=2.92u w=1.12u l=0.13u
X2061 a_5333_15532# _195_.Y VDD VDD sg13_lv_pmos ad=0.2128p pd=1.5u as=0.2128p ps=1.5u w=1.12u l=0.13u
X2062 GND.t162 _157_.B _157_.Y GND.t161 sg13_lv_nmos ad=0.2516p pd=2.16u as=0.1406p ps=1.12u w=0.74u l=0.13u
X2063 GND.t85 VDD GND.t1168 GND.t5 sg13_lv_nmos ad=79.8f pd=0.8u as=0 ps=0 w=0.42u l=1u
X2064 GND.t693 VDD GND.t693 GND.t740 sg13_lv_nmos ad=79.8f pd=0.8u as=0 ps=0 w=0.42u l=1u
X2065 VDD _210_.A a_6234_3900# VDD sg13_lv_pmos ad=0.2891p pd=1.695u as=0.1428p ps=1.375u w=1.12u l=0.13u
X2066 a_10989_8784# _145_.X _164_.Y GND.t329 sg13_lv_nmos ad=0.1406p pd=1.12u as=0.1406p ps=1.12u w=0.74u l=0.13u
X2067 GND.t266 VDD GND.t266 GND.t1062 sg13_lv_nmos ad=79.8f pd=0.8u as=0 ps=0 w=0.42u l=1u
X2068 GND.t37 a_8557_4248# _145_.X GND.t75 sg13_lv_nmos ad=0.2516p pd=2.16u as=0.1406p ps=1.12u w=0.74u l=0.13u
X2069 VDD _226_.Y a_14698_5380# VDD sg13_lv_pmos ad=0.1563p pd=1.22u as=0.147p ps=1.54u w=0.42u l=0.13u
X2070 VDD GND.t5 VDD VDD sg13_lv_pmos ad=0.19p pd=1.38u as=0 ps=0 w=1u l=1u
X2071 a_2122_15964# a_2565_16007# a_1862_16434# GND.t95 sg13_lv_nmos ad=79.8f pd=0.8u as=0.1296p ps=1.52u w=0.42u l=0.13u
X2072 GND.t133 _247_.CLK clkload0.Y GND.t478 sg13_lv_nmos ad=0.2516p pd=2.16u as=0.2516p ps=2.16u w=0.74u l=0.13u
X2073 VDD GND.t797 VDD VDD sg13_lv_pmos ad=0.19p pd=1.38u as=0 ps=0 w=1u l=1u
X2074 GND.t862 VDD GND.t305 GND.t863 sg13_lv_nmos ad=79.8f pd=0.8u as=0 ps=0 w=0.42u l=1u
X2075 GND.t1094 VDD GND.t1094 GND.t1123 sg13_lv_nmos ad=0.1428p pd=1.52u as=0 ps=0 w=0.42u l=1u
X2076 a_2244_8874# _122_.X a_2150_8874# GND.t217 sg13_lv_nmos ad=60.89999f pd=0.71u as=0.1428p ps=1.52u w=0.42u l=0.13u
X2077 VDD GND.t884 VDD VDD sg13_lv_pmos ad=0.19p pd=1.38u as=0 ps=0 w=1u l=1u
X2078 GND.t419 VDD GND.t1189 GND.t5 sg13_lv_nmos ad=79.8f pd=0.8u as=0 ps=0 w=0.42u l=1u
X2079 GND.t1094 VDD GND.t1094 GND.t1093 sg13_lv_nmos ad=0.1428p pd=1.52u as=0 ps=0 w=0.42u l=1u
X2080 GND.t249 a_9573_12189# a_9675_12332# GND.t548 sg13_lv_nmos ad=3.6571p pd=23.85u as=0.2516p ps=2.16u w=0.74u l=0.13u
X2081 a_2494_6166# _148_.A a_2397_6460# VDD sg13_lv_pmos ad=0.2225p pd=1.445u as=0.3325p ps=1.665u w=1u l=0.13u
X2082 GND.t1027 VDD GND.t1027 GND.t1028 sg13_lv_nmos ad=79.8f pd=0.8u as=0 ps=0 w=0.42u l=1u
X2083 GND.t279 clkbuf_1_0__f_sclk.A a_3956_6888# GND.t284 sg13_lv_nmos ad=0.2516p pd=2.16u as=0.1406p ps=1.12u w=0.74u l=0.13u
X2084 _250_.Q a_4074_15996# VDD VDD sg13_lv_pmos ad=0.3808p pd=2.92u as=0.2128p ps=1.5u w=1.12u l=0.13u
X2085 _247_.CLK a_3380_13690# VDD VDD sg13_lv_pmos ad=0.2128p pd=1.5u as=0.2128p ps=1.5u w=1.12u l=0.13u
X2086 VDD GND.t1057 VDD VDD sg13_lv_pmos ad=0.34p pd=2.68u as=0 ps=0 w=1u l=1u
X2087 VDD GND.t1000 VDD VDD sg13_lv_pmos ad=0.19p pd=1.38u as=0 ps=0 w=1u l=1u
X2088 a_13914_4666# _145_.X GND.t333 GND.t332 sg13_lv_nmos ad=88.8f pd=0.98u as=0.15245p ps=1.17u w=0.74u l=0.13u
X2089 GND.t1165 VDD GND.t1166 GND.t5 sg13_lv_nmos ad=0.1428p pd=1.52u as=0 ps=0 w=0.42u l=1u
X2090 VDD GND.t803 VDD VDD sg13_lv_pmos ad=0.19p pd=1.38u as=0 ps=0 w=1u l=1u
X2091 VDD GND.t1103 VDD VDD sg13_lv_pmos ad=0.19p pd=1.38u as=0 ps=0 w=1u l=1u
X2092 a_14240_16921# a_14359_16710# VDD VDD sg13_lv_pmos ad=0.3864p pd=2.93u as=0.2128p ps=1.5u w=1.12u l=0.13u
X2093 VDD GND.t668 VDD VDD sg13_lv_pmos ad=0.19p pd=1.38u as=0 ps=0 w=1u l=1u
X2094 VDD GND.t1221 VDD VDD sg13_lv_pmos ad=0.34p pd=2.68u as=0 ps=0 w=1u l=1u
X2095 VDD GND.t1314 VDD VDD sg13_lv_pmos ad=0.19p pd=1.38u as=0 ps=0 w=1u l=1u
X2096 VDD GND.t726 VDD VDD sg13_lv_pmos ad=0.34p pd=2.68u as=0 ps=0 w=1u l=1u
X2097 GND.t439 a_2126_15424# _118_.X GND.t600 sg13_lv_nmos ad=0.148p pd=1.14u as=0.4033p ps=2.57u w=0.74u l=0.13u
X2098 a_7180_14020# a_6958_13764# VDD VDD sg13_lv_pmos ad=0.1176p pd=1.33u as=0.2618p ps=1.63u w=1.12u l=0.13u
X2099 GND.t352 VDD GND.t943 GND.t62 sg13_lv_nmos ad=0.1428p pd=1.52u as=0 ps=0 w=0.42u l=1u
X2100 a_13221_16007# _266_.CLK VDD VDD sg13_lv_pmos ad=0.4088p pd=2.97u as=1.54765p ps=10.005u w=1.12u l=0.13u
X2101 GND.t108 a_13100_13686# _148_.B GND.t1485 sg13_lv_nmos ad=0.14875p pd=1.16u as=0.2886p ps=2.26u w=0.74u l=0.13u
X2102 a_6095_4270# a_6060_4166# _210_.Y GND.t66 sg13_lv_nmos ad=0.1406p pd=1.12u as=0.2516p ps=2.16u w=0.74u l=0.13u
X2103 GND.t1194 _226_.Y a_14532_5850# GND.t1571 sg13_lv_nmos ad=0.1626p pd=1.415u as=60.89999f ps=0.71u w=0.42u l=0.13u
X2104 a_9808_16966# a_9551_16823# a_9970_16746# GND.t19 sg13_lv_nmos ad=0.1428p pd=1.52u as=37.8f ps=0.6u w=0.42u l=0.13u
X2105 GND.t788 VDD GND.t790 GND.t789 sg13_lv_nmos ad=79.8f pd=0.8u as=0 ps=0 w=0.42u l=1u
X2106 a_14572_16746# a_14359_16710# VDD VDD sg13_lv_pmos ad=79.8f pd=0.8u as=1.30717p ps=8.395u w=0.42u l=0.13u
X2107 a_8134_16421# _258_.RESET_B GND.t261 GND.t1407 sg13_lv_nmos ad=37.8f pd=0.6u as=0.1701p ps=1.65u w=0.42u l=0.13u
X2108 GND.t48 a_3695_8797# a_4362_8436# GND.t21 sg13_lv_nmos ad=0.1406p pd=1.12u as=0.2516p ps=2.16u w=0.74u l=0.13u
X2109 _260_.CLK a_16746_11460# GND.t4 GND.t3 sg13_lv_nmos ad=0.2516p pd=2.16u as=0.1406p ps=1.12u w=0.74u l=0.13u
X2110 VDD GND.t270 VDD VDD sg13_lv_pmos ad=0.19p pd=1.38u as=0 ps=0 w=1u l=1u
X2111 VDD a_10415_13799# a_11082_14020# VDD sg13_lv_pmos ad=0.2128p pd=1.5u as=0.3864p ps=2.93u w=1.12u l=0.13u
X2112 VDD GND.t188 VDD VDD sg13_lv_pmos ad=0.19p pd=1.38u as=0 ps=0 w=1u l=1u
X2113 VDD a_5376_17061# _199_.B1 VDD sg13_lv_pmos ad=0.3808p pd=2.92u as=0.2408p ps=1.55u w=1.12u l=0.13u
X2114 a_6197_13342# _189_.X GND.t448 GND.t46 sg13_lv_nmos ad=0.1406p pd=1.12u as=0.1898p ps=1.36u w=0.74u l=0.13u
X2115 _136_.B a_8394_4948# GND.t37 GND.t640 sg13_lv_nmos ad=0.2516p pd=2.16u as=0.1406p ps=1.12u w=0.74u l=0.13u
X2116 GND.t169 a_11536_9406# a_11185_9263# GND.t1440 sg13_lv_nmos ad=79.8f pd=0.8u as=0.1428p ps=1.52u w=0.42u l=0.13u
X2117 _132_.Y _131_.A2 GND.t77 GND.t102 sg13_lv_nmos ad=0.1406p pd=1.12u as=0.2516p ps=2.16u w=0.74u l=0.13u
X2118 fanout7.A a_16746_9484# VDD VDD sg13_lv_pmos ad=0.3808p pd=2.92u as=0.2128p ps=1.5u w=1.12u l=0.13u
X2119 a_6182_4650# _210_.Y VDD VDD sg13_lv_pmos ad=79.8f pd=0.8u as=0.1428p ps=1.52u w=0.42u l=0.13u
X2120 VDD clkbuf_1_0__f_sclk.A a_3380_13690# VDD sg13_lv_pmos ad=0.3808p pd=2.92u as=0.2128p ps=1.5u w=1.12u l=0.13u
X2121 VDD GND.t1227 VDD VDD sg13_lv_pmos ad=0.19p pd=1.38u as=0 ps=0 w=1u l=1u
X2122 GND.t348 VDD GND.t348 GND.t1133 sg13_lv_nmos ad=0.1428p pd=1.52u as=0 ps=0 w=0.42u l=1u
X2123 a_14340_15552# a_14314_15457# VDD VDD sg13_lv_pmos ad=0.34p pd=2.68u as=0.36237p ps=2.605u w=1u l=0.13u
X2124 VDD GND.t188 VDD VDD sg13_lv_pmos ad=0.34p pd=2.68u as=0 ps=0 w=1u l=1u
X2125 VDD a_16079_8797# a_16746_8436# VDD sg13_lv_pmos ad=0.2128p pd=1.5u as=0.3864p ps=2.93u w=1.12u l=0.13u
X2126 VDD GND.t726 VDD VDD sg13_lv_pmos ad=0.19p pd=1.38u as=0 ps=0 w=1u l=1u
X2127 a_9130_12433# a_9573_12189# a_8870_12210# GND.t547 sg13_lv_nmos ad=79.8f pd=0.8u as=0.1296p ps=1.52u w=0.42u l=0.13u
X2128 GND.t1494 _207_.A2 a_5249_16344# GND.t14 sg13_lv_nmos ad=0.2516p pd=2.16u as=0.1406p ps=1.12u w=0.74u l=0.13u
X2129 a_7882_15964# a_8325_16007# a_7622_16434# GND.t27 sg13_lv_nmos ad=79.8f pd=0.8u as=0.1296p ps=1.52u w=0.42u l=0.13u
X2130 a_13648_12430# _261_.RESET_B VDD VDD sg13_lv_pmos ad=79.8f pd=0.8u as=1.42082p ps=9.125u w=0.42u l=0.13u
X2131 a_16498_11898# _236_.Y GND.t9 GND.t3 sg13_lv_nmos ad=37.8f pd=0.6u as=79.8f ps=0.8u w=0.42u l=0.13u
X2132 VDD GND.t1103 VDD VDD sg13_lv_pmos ad=0.34p pd=2.68u as=0 ps=0 w=1u l=1u
X2133 VDD GND.t286 VDD VDD sg13_lv_pmos ad=0.19p pd=1.38u as=0 ps=0 w=1u l=1u
X2134 GND.t122 _220_.Y a_2052_12210# GND.t62 sg13_lv_nmos ad=0.1626p pd=1.415u as=60.89999f ps=0.71u w=0.42u l=0.13u
X2135 GND.t223 _143_.A a_8021_5782# GND.t5 sg13_lv_nmos ad=0.1898p pd=1.36u as=0.2516p ps=2.16u w=0.74u l=0.13u
X2136 GND.t5 VDD GND.t1149 GND.t83 sg13_lv_nmos ad=0.1428p pd=1.52u as=0 ps=0 w=0.42u l=1u
X2137 VDD GND.t228 VDD VDD sg13_lv_pmos ad=0.34p pd=2.68u as=0 ps=0 w=1u l=1u
X2138 a_7739_9484# _170_.B VDD VDD sg13_lv_pmos ad=0.3808p pd=2.92u as=0.2128p ps=1.5u w=1.12u l=0.13u
X2139 a_2436_16421# a_2148_16000# a_2374_16421# GND.t302 sg13_lv_nmos ad=0.1428p pd=1.52u as=37.8f ps=0.6u w=0.42u l=0.13u
X2140 GND.t65 _136_.A a_6966_4258# GND.t608 sg13_lv_nmos ad=0.15245p pd=1.17u as=88.8f ps=0.98u w=0.74u l=0.13u
X2141 VDD GND.t106 VDD VDD sg13_lv_pmos ad=0.34p pd=2.68u as=0 ps=0 w=1u l=1u
X2142 GND.t1065 VDD GND.t1065 GND.t1066 sg13_lv_nmos ad=79.8f pd=0.8u as=0 ps=0 w=0.42u l=1u
X2143 a_3407_13333# a_2565_12983# a_2148_12976# VDD sg13_lv_pmos ad=0.2048p pd=1.63u as=0.34p ps=2.68u w=1u l=0.13u
X2144 VDD GND.t1299 VDD VDD sg13_lv_pmos ad=0.19p pd=1.38u as=0 ps=0 w=1u l=1u
X2145 GND.t48 a_3695_9263# a_4362_9484# GND.t21 sg13_lv_nmos ad=0.1406p pd=1.12u as=0.2516p ps=2.16u w=0.74u l=0.13u
X2146 VDD clkbuf_1_0__f_sclk.A a_3380_13690# VDD sg13_lv_pmos ad=0.2128p pd=1.5u as=0.2128p ps=1.5u w=1.12u l=0.13u
X2147 VDD GND.t1181 VDD VDD sg13_lv_pmos ad=0.19p pd=1.38u as=0 ps=0 w=1u l=1u
X2148 VDD GND.t716 VDD VDD sg13_lv_pmos ad=0.34p pd=2.68u as=0 ps=0 w=1u l=1u
X2149 VDD GND.t689 VDD VDD sg13_lv_pmos ad=0.19p pd=1.38u as=0 ps=0 w=1u l=1u
X2150 a_2298_13726# a_2232_13916# GND.t133 GND.t244 sg13_lv_nmos ad=0.3367p pd=1.65u as=0.148p ps=1.14u w=0.74u l=0.13u
X2151 GND.t1094 VDD GND.t1094 GND.t1096 sg13_lv_nmos ad=0.1428p pd=1.52u as=0 ps=0 w=0.42u l=1u
X2152 GND.t1000 VDD GND.t1000 GND.t1004 sg13_lv_nmos ad=79.8f pd=0.8u as=0 ps=0 w=0.42u l=1u
X2153 VDD a_12623_16823# a_13290_17044# VDD sg13_lv_pmos ad=0.2128p pd=1.5u as=0.3864p ps=2.93u w=1.12u l=0.13u
X2154 a_3300_5416# a_3274_5380# VDD VDD sg13_lv_pmos ad=0.34p pd=2.68u as=0.36237p ps=2.605u w=1u l=0.13u
X2155 GND.t1182 _139_.X a_10799_5782# GND.t5 sg13_lv_nmos ad=0.1898p pd=1.36u as=0.1406p ps=1.12u w=0.74u l=0.13u
X2156 VDD GND.t656 VDD VDD sg13_lv_pmos ad=0.19p pd=1.38u as=0 ps=0 w=1u l=1u
X2157 a_3887_4261# a_3045_3911# a_3793_4261# GND.t507 sg13_lv_nmos ad=0.12665p pd=1.145u as=0.1428p ps=1.52u w=0.42u l=0.13u
X2158 _227_.Y _225_.A.t3 VDD VDD sg13_lv_pmos ad=0.3808p pd=2.92u as=0.3808p ps=2.92u w=1.12u l=0.13u
X2159 VDD GND.t718 VDD VDD sg13_lv_pmos ad=0.34p pd=2.68u as=0 ps=0 w=1u l=1u
X2160 _261_.RESET_B _236_.A VDD VDD sg13_lv_pmos ad=0.3808p pd=2.92u as=0.3808p ps=2.92u w=1.12u l=0.13u
X2161 _243_.D a_2398_4654# VDD VDD sg13_lv_pmos ad=0.6048p pd=3.32u as=0.2198p ps=1.52u w=1.12u l=0.13u
X2162 GND.t379 a_3380_13690# _247_.CLK GND.t46 sg13_lv_nmos ad=0.1406p pd=1.12u as=0.1406p ps=1.12u w=0.74u l=0.13u
X2163 VDD GND.t697 VDD VDD sg13_lv_pmos ad=0.19p pd=1.38u as=0 ps=0 w=1u l=1u
X2164 a_9156_14040# a_9130_13945# VDD VDD sg13_lv_pmos ad=0.34p pd=2.68u as=0.36237p ps=2.605u w=1u l=0.13u
X2165 _158_.Y _157_.Y GND.t1065 GND.t1466 sg13_lv_nmos ad=0.1406p pd=1.12u as=0.2516p ps=2.16u w=0.74u l=0.13u
X2166 a_9994_17476# a_10437_17519# a_9734_17946# GND.t155 sg13_lv_nmos ad=79.8f pd=0.8u as=0.1296p ps=1.52u w=0.42u l=0.13u
X2167 a_14532_12210# _129_.Y a_14438_12210# GND.t153 sg13_lv_nmos ad=60.89999f pd=0.71u as=0.1428p ps=1.52u w=0.42u l=0.13u
X2168 VDD a_6747_5468# _143_.A VDD sg13_lv_pmos ad=0.3808p pd=2.92u as=0.2128p ps=1.5u w=1.12u l=0.13u
X2169 VDD sdata a_1192_7712# VDD sg13_lv_pmos ad=0.2114p pd=1.54u as=0.2856p ps=2.36u w=0.84u l=0.13u
X2170 _213_.Y _251_.CLK GND.t21 GND.t73 sg13_lv_nmos ad=0.2516p pd=2.16u as=0.2516p ps=2.16u w=0.74u l=0.13u
X2171 a_14340_15552# a_14314_15457# GND.t270 GND.t269 sg13_lv_nmos ad=0.2516p pd=2.16u as=0.1626p ps=1.415u w=0.74u l=0.13u
X2172 GND.t119 a_2075_4692# a_2512_4654# GND.t664 sg13_lv_nmos ad=0.148p pd=1.14u as=0.3367p ps=1.65u w=0.74u l=0.13u
X2173 GND.t1235 VDD GND.t7 GND.t1234 sg13_lv_nmos ad=0.1428p pd=1.52u as=0 ps=0 w=0.42u l=1u
X2174 VDD GND.t448 VDD VDD sg13_lv_pmos ad=0.34p pd=2.68u as=0 ps=0 w=1u l=1u
X2175 _211_.Y _264_.Q VDD VDD sg13_lv_pmos ad=0.3808p pd=2.92u as=0.3808p ps=2.92u w=1.12u l=0.13u
X2176 GND.t901 VDD GND.t901 GND.t933 sg13_lv_nmos ad=0.1428p pd=1.52u as=0 ps=0 w=0.42u l=1u
X2177 VDD _244_.RESET_B a_3274_5380# VDD sg13_lv_pmos ad=0.1563p pd=1.22u as=0.147p ps=1.54u w=0.42u l=0.13u
X2178 GND.t1071 VDD GND.t1071 GND.t21 sg13_lv_nmos ad=0.1428p pd=1.52u as=0 ps=0 w=0.42u l=1u
X2179 GND.t307 VDD GND.t307 GND.t886 sg13_lv_nmos ad=0.1428p pd=1.52u as=0 ps=0 w=0.42u l=1u
X2180 VDD GND.t718 VDD VDD sg13_lv_pmos ad=0.19p pd=1.38u as=0 ps=0 w=1u l=1u
X2181 VDD _258_.RESET_B a_7882_15964# VDD sg13_lv_pmos ad=0.1563p pd=1.22u as=0.147p ps=1.54u w=0.42u l=0.13u
X2182 GND.t671 VDD GND.t671 GND.t1056 sg13_lv_nmos ad=79.8f pd=0.8u as=0 ps=0 w=0.42u l=1u
X2183 a_2397_6460# _124_.S VDD VDD sg13_lv_pmos ad=0.3325p pd=1.665u as=0.253p ps=1.53u w=1u l=0.13u
X2184 a_3826_16746# _222_.Y GND.t446 GND.t14 sg13_lv_nmos ad=37.8f pd=0.6u as=79.8f ps=0.8u w=0.42u l=0.13u
X2185 VDD GND.t342 VDD VDD sg13_lv_pmos ad=0.19p pd=1.38u as=0 ps=0 w=1u l=1u
X2186 VDD GND.t557 VDD VDD sg13_lv_pmos ad=0.19p pd=1.38u as=0 ps=0 w=1u l=1u
X2187 VDD GND.t85 VDD VDD sg13_lv_pmos ad=0.34p pd=2.68u as=0 ps=0 w=1u l=1u
X2188 GND.t838 VDD GND.t493 GND.t840 sg13_lv_nmos ad=79.8f pd=0.8u as=0 ps=0 w=0.42u l=1u
X2189 a_13649_4704# _151_.B a_13617_4972# VDD sg13_lv_pmos ad=0.34p pd=2.68u as=0.1225p ps=1.245u w=1u l=0.13u
X2190 GND.t1103 VDD GND.t1103 GND.t1104 sg13_lv_nmos ad=79.8f pd=0.8u as=0 ps=0 w=0.42u l=1u
X2191 VDD _196_.Y _200_.Y VDD sg13_lv_pmos ad=0.2128p pd=1.5u as=0.2128p ps=1.5u w=1.12u l=0.13u
X2192 a_5562_12226# _120_.A0 GND.t411 GND.t410 sg13_lv_nmos ad=88.8f pd=0.98u as=0.15245p ps=1.17u w=0.74u l=0.13u
X2193 a_9466_7678# _154_.X GND.t345 GND.t344 sg13_lv_nmos ad=0.1406p pd=1.12u as=0.2516p ps=2.16u w=0.74u l=0.13u
X2194 GND.t1103 VDD GND.t348 GND.t1135 sg13_lv_nmos ad=0.1428p pd=1.52u as=0 ps=0 w=0.42u l=1u
X2195 _159_.Y _158_.Y a_14067_7972# VDD sg13_lv_pmos ad=0.2408p pd=1.55u as=0.1428p ps=1.375u w=1.12u l=0.13u
X2196 _202_.Y _191_.Y GND.t116 GND.t619 sg13_lv_nmos ad=0.1406p pd=1.12u as=0.2516p ps=2.16u w=0.74u l=0.13u
X2197 a_10246_9199# _228_.Y GND.t171 GND.t21 sg13_lv_nmos ad=37.8f pd=0.6u as=0.1701p ps=1.65u w=0.42u l=0.13u
X2198 VDD a_2565_12983# a_2667_12983# VDD sg13_lv_pmos ad=1.42082p pd=9.125u as=0.3864p ps=2.93u w=1.12u l=0.13u
X2199 VDD _139_.X a_11381_3900# VDD sg13_lv_pmos ad=0.2128p pd=1.5u as=0.3808p ps=2.92u w=1.12u l=0.13u
X2200 a_11721_17137# a_11364_17064# VDD VDD sg13_lv_pmos ad=63f pd=0.72u as=0.1563p ps=1.22u w=0.42u l=0.13u
X2201 _220_.Y _215_.A GND.t352 GND.t62 sg13_lv_nmos ad=0.2516p pd=2.16u as=0.2516p ps=2.16u w=0.74u l=0.13u
X2202 a_4306_4338# _243_.RESET_B GND.t1 GND.t424 sg13_lv_nmos ad=37.8f pd=0.6u as=79.8f ps=0.8u w=0.42u l=0.13u
X2203 a_6218_10296# _173_.Y a_6124_9945# GND.t472 sg13_lv_nmos ad=0.1216p pd=1.02u as=0.2176p ps=1.96u w=0.64u l=0.13u
X2204 VDD GND.t121 VDD VDD sg13_lv_pmos ad=0.34p pd=2.68u as=0 ps=0 w=1u l=1u
X2205 a_2126_15424# _118_.A0 a_2298_15238# GND.t1532 sg13_lv_nmos ad=0.1628p pd=1.18u as=0.3367p ps=1.65u w=0.74u l=0.13u
X2206 _151_.B _157_.B a_13338_5770# GND.t5 sg13_lv_nmos ad=0.1628p pd=1.18u as=88.8f ps=0.98u w=0.74u l=0.13u
X2207 _185_.Y _171_.A a_7251_10296# GND.t150 sg13_lv_nmos ad=0.1406p pd=1.12u as=0.1406p ps=1.12u w=0.74u l=0.13u
X2208 a_10834_13722# _230_.Y GND.t391 GND.t390 sg13_lv_nmos ad=37.8f pd=0.6u as=79.8f ps=0.8u w=0.42u l=0.13u
X2209 GND.t885 VDD GND.t884 GND.t46 sg13_lv_nmos ad=79.8f pd=0.8u as=0 ps=0 w=0.42u l=1u
X2210 GND.t303 a_16336_9406# a_15985_9263# GND.t72 sg13_lv_nmos ad=79.8f pd=0.8u as=0.1428p ps=1.52u w=0.42u l=0.13u
X2211 a_8694_5770# _144_.B _145_.A2 GND.t5 sg13_lv_nmos ad=88.8f pd=0.98u as=0.1628p ps=1.18u w=0.74u l=0.13u
X2212 VDD GND.t1176 VDD VDD sg13_lv_pmos ad=0.34p pd=2.68u as=0 ps=0 w=1u l=1u
X2213 _218_.Y _215_.A GND.t356 GND.t217 sg13_lv_nmos ad=0.2516p pd=2.16u as=0.2516p ps=2.16u w=0.74u l=0.13u
X2214 a_2565_16725# _247_.CLK VDD VDD sg13_lv_pmos ad=0.4088p pd=2.97u as=1.30717p ps=8.395u w=1.12u l=0.13u
X2215 _244_.RESET_B _215_.A VDD VDD sg13_lv_pmos ad=0.3808p pd=2.92u as=0.3808p ps=2.92u w=1.12u l=0.13u
X2216 GND.t578 a_14757_15213# a_14859_15356# GND.t577 sg13_lv_nmos ad=13.40377p pd=86.265u as=0.2516p ps=2.16u w=0.74u l=0.13u
X2217 GND.t139 VDD GND.t139 GND.t995 sg13_lv_nmos ad=79.8f pd=0.8u as=0 ps=0 w=0.42u l=1u
X2218 _126_.B1 a_14058_12508# VDD VDD sg13_lv_pmos ad=0.3808p pd=2.92u as=0.2128p ps=1.5u w=1.12u l=0.13u
X2219 a_14820_8440# a_15339_8447# a_16079_8797# GND.t72 sg13_lv_nmos ad=0.3473p pd=2.71u as=0.12665p ps=1.145u w=0.74u l=0.13u
X2220 GND.t441 VDD GND.t441 GND.t894 sg13_lv_nmos ad=79.8f pd=0.8u as=0 ps=0 w=0.42u l=1u
X2221 a_12489_12601# a_12132_12528# VDD VDD sg13_lv_pmos ad=63f pd=0.72u as=0.1563p ps=1.22u w=0.42u l=0.13u
X2222 VDD GND.t1304 VDD VDD sg13_lv_pmos ad=0.19p pd=1.38u as=0 ps=0 w=1u l=1u
X2223 _239_.Y _225_.A VDD VDD sg13_lv_pmos ad=0.3808p pd=2.92u as=0.3808p ps=2.92u w=1.12u l=0.13u
X2224 GND.t226 VDD GND.t1169 GND.t5 sg13_lv_nmos ad=0.1428p pd=1.52u as=0 ps=0 w=0.42u l=1u
X2225 GND.t310 VDD GND.t310 GND.t874 sg13_lv_nmos ad=79.8f pd=0.8u as=0 ps=0 w=0.42u l=1u
X2226 VDD GND.t815 VDD VDD sg13_lv_pmos ad=0.34p pd=2.68u as=0 ps=0 w=1u l=1u
X2227 a_2244_12528# a_2218_12433# VDD VDD sg13_lv_pmos ad=0.34p pd=2.68u as=0.36237p ps=2.605u w=1u l=0.13u
X2228 VDD GND.t1184 VDD VDD sg13_lv_pmos ad=0.19p pd=1.38u as=0 ps=0 w=1u l=1u
X2229 _178_.B1 a_6336_11499# a_6485_11830# GND.t91 sg13_lv_nmos ad=0.2516p pd=2.16u as=0.1406p ps=1.12u w=0.74u l=0.13u
X2230 a_11755_4696# _243_.Q a_11661_4696# GND.t642 sg13_lv_nmos ad=0.1216p pd=1.02u as=0.2176p ps=1.96u w=0.64u l=0.13u
X2231 a_3045_3911# _243_.CLK VDD VDD sg13_lv_pmos ad=0.4088p pd=2.97u as=5.15485p ps=34.14u w=1.12u l=0.13u
X2232 GND.t23 a_12215_7664# _164_.B1 GND.t24 sg13_lv_nmos ad=0.2516p pd=2.16u as=0.1406p ps=1.12u w=0.74u l=0.13u
X2233 GND.t188 VDD GND.t188 GND.t1083 sg13_lv_nmos ad=0.1428p pd=1.52u as=0 ps=0 w=0.42u l=1u
X2234 GND.t1000 VDD GND.t1000 GND.t1039 sg13_lv_nmos ad=0.1428p pd=1.52u as=0 ps=0 w=0.42u l=1u
X2235 VDD _258_.RESET_B a_7622_16434# VDD sg13_lv_pmos ad=0.36237p pd=2.605u as=79.8f ps=0.8u w=0.42u l=0.13u
X2236 a_6966_4258# _136_.B _210_.B GND.t238 sg13_lv_nmos ad=88.8f pd=0.98u as=0.1628p ps=1.18u w=0.74u l=0.13u
X2237 a_14820_8440# a_14794_8404# GND.t21 GND.t1403 sg13_lv_nmos ad=0.2516p pd=2.16u as=0.1626p ps=1.415u w=0.74u l=0.13u
X2238 VDD _228_.Y a_9734_9186# VDD sg13_lv_pmos ad=0.36237p pd=2.605u as=79.8f ps=0.8u w=0.42u l=0.13u
X2239 VDD a_15141_12189# a_15243_12332# VDD sg13_lv_pmos ad=1.42082p pd=9.125u as=0.3864p ps=2.93u w=1.12u l=0.13u
X2240 a_2410_9409# a_2853_9165# a_2150_9186# GND.t435 sg13_lv_nmos ad=79.8f pd=0.8u as=0.1296p ps=1.52u w=0.42u l=0.13u
X2241 GND.t1378 VDD GND.t1377 GND.t1376 sg13_lv_nmos ad=0.1428p pd=1.52u as=0 ps=0 w=0.42u l=1u
X2242 VDD _227_.Y a_14794_8404# VDD sg13_lv_pmos ad=0.1563p pd=1.22u as=0.147p ps=1.54u w=0.42u l=0.13u
X2243 VDD a_11279_9263# a_11536_9406# VDD sg13_lv_pmos ad=1.94845p pd=12.685u as=79.8f ps=0.8u w=0.42u l=0.13u
X2244 GND.t21 a_2853_9165# a_2955_9308# GND.t436 sg13_lv_nmos ad=4.0443p pd=25.39u as=0.2516p ps=2.16u w=0.74u l=0.13u
X2245 _176_.A a_11082_12508# GND.t131 GND.t130 sg13_lv_nmos ad=0.2516p pd=2.16u as=0.1406p ps=1.12u w=0.74u l=0.13u
X2246 VDD clkbuf_1_0__f_sclk.A a_3956_6888# VDD sg13_lv_pmos ad=0.3808p pd=2.92u as=0.2128p ps=1.5u w=1.12u l=0.13u
X2247 GND.t812 VDD GND.t812 GND.t857 sg13_lv_nmos ad=0.1428p pd=1.52u as=0 ps=0 w=0.42u l=1u
X2248 VDD a_9551_16823# a_10218_17044# VDD sg13_lv_pmos ad=0.2128p pd=1.5u as=0.3864p ps=2.93u w=1.12u l=0.13u
X2249 VDD a_3407_13333# a_4074_12972# VDD sg13_lv_pmos ad=0.2128p pd=1.5u as=0.3864p ps=2.93u w=1.12u l=0.13u
X2250 a_9348_4968# a_9322_4873# GND.t37 GND.t154 sg13_lv_nmos ad=0.2516p pd=2.16u as=0.1626p ps=1.415u w=0.74u l=0.13u
X2251 GND.t5 _124_.S a_2075_5468# GND.t83 sg13_lv_nmos ad=0.18945p pd=1.27u as=0.187p ps=1.78u w=0.55u l=0.13u
X2252 a_10607_4727# a_9765_4629# a_10513_4727# GND.t1470 sg13_lv_nmos ad=0.12665p pd=1.145u as=0.1428p ps=1.52u w=0.42u l=0.13u
X2253 GND.t726 VDD GND.t726 GND.t158 sg13_lv_nmos ad=79.8f pd=0.8u as=0 ps=0 w=0.42u l=1u
X2254 GND.t198 VDD GND.t198 GND.t1021 sg13_lv_nmos ad=0.1428p pd=1.52u as=0 ps=0 w=0.42u l=1u
X2255 GND.t173 a_3407_16357# a_4074_15996# GND.t14 sg13_lv_nmos ad=0.1406p pd=1.12u as=0.2516p ps=2.16u w=0.74u l=0.13u
X2256 a_16336_8678# _227_.Y VDD VDD sg13_lv_pmos ad=79.8f pd=0.8u as=2.75005p ps=18.05u w=0.42u l=0.13u
X2257 VDD a_3664_13214# a_3609_13095# VDD sg13_lv_pmos ad=1.42082p pd=9.125u as=93.45f ps=0.865u w=0.42u l=0.13u
X2258 _168_.Y a_6528_8475# a_6677_8806# GND.t21 sg13_lv_nmos ad=0.2516p pd=2.16u as=0.1406p ps=1.12u w=0.74u l=0.13u
X2259 a_6528_8475# _168_.B a_6491_8784# GND.t21 sg13_lv_nmos ad=0.2176p pd=1.96u as=78.39999f ps=0.885u w=0.64u l=0.13u
X2260 VDD GND.t1224 VDD VDD sg13_lv_pmos ad=0.19p pd=1.38u as=0 ps=0 w=1u l=1u
X2261 a_1862_16434# _250_.D VDD VDD sg13_lv_pmos ad=79.8f pd=0.8u as=0.1428p ps=1.52u w=0.42u l=0.13u
X2262 a_13129_15280# _134_.Y GND.t305 GND.t475 sg13_lv_nmos ad=0.1216p pd=1.02u as=0.1331p ps=1.12u w=0.64u l=0.13u
X2263 GND.t693 VDD GND.t693 GND.t694 sg13_lv_nmos ad=0.1428p pd=1.52u as=0 ps=0 w=0.42u l=1u
X2264 GND.t100 VDD GND.t100 GND.t985 sg13_lv_nmos ad=0.1428p pd=1.52u as=0 ps=0 w=0.42u l=1u
X2265 a_4475_17856# _118_.A0 GND.t687 GND.t1530 sg13_lv_nmos ad=78.39999f pd=0.885u as=0.2272p ps=1.99u w=0.64u l=0.13u
X2266 _230_.Y _236_.A VDD VDD sg13_lv_pmos ad=0.3808p pd=2.92u as=0.3808p ps=2.92u w=1.12u l=0.13u
X2267 GND.t897 VDD GND.t897 GND.t932 sg13_lv_nmos ad=79.8f pd=0.8u as=0 ps=0 w=0.42u l=1u
X2268 GND.t716 VDD GND.t716 GND.t158 sg13_lv_nmos ad=0.1428p pd=1.52u as=0 ps=0 w=0.42u l=1u
X2269 VDD a_14757_15213# a_14859_15356# VDD sg13_lv_pmos ad=1.6291p pd=10.53u as=0.3864p ps=2.93u w=1.12u l=0.13u
X2270 a_15983_5773# a_15141_5423# a_15889_5773# GND.t82 sg13_lv_nmos ad=0.12665p pd=1.145u as=0.1428p ps=1.52u w=0.42u l=0.13u
X2271 GND.t519 VDD GND.t519 GND.t1146 sg13_lv_nmos ad=79.8f pd=0.8u as=0 ps=0 w=0.42u l=1u
X2272 a_14919_16964# a_15071_17016# GND.t14 GND.t210 sg13_lv_nmos ad=0.2516p pd=2.16u as=2.85425p ps=18.015u w=0.74u l=0.13u
X2273 a_3887_4261# a_3045_3911# a_2628_3904# VDD sg13_lv_pmos ad=0.2048p pd=1.63u as=0.34p ps=2.68u w=1u l=0.13u
X2274 GND.t177 _237_.Y a_12612_16434# GND.t184 sg13_lv_nmos ad=0.1626p pd=1.415u as=60.89999f ps=0.71u w=0.42u l=0.13u
X2275 GND.t411 _148_.B a_5297_12264# GND.t1543 sg13_lv_nmos ad=0.15245p pd=1.17u as=0.17462p ps=1.185u w=0.55u l=0.13u
X2276 VDD a_12992_15437# _135_.X VDD sg13_lv_pmos ad=0.1918p pd=1.5u as=0.3808p ps=2.92u w=1.12u l=0.13u
X2277 GND.t1079 VDD GND.t170 GND.t21 sg13_lv_nmos ad=0.1428p pd=1.52u as=0 ps=0 w=0.42u l=1u
X2278 VDD _207_.A1 a_5147_15996# VDD sg13_lv_pmos ad=0.2128p pd=1.5u as=0.2128p ps=1.5u w=1.12u l=0.13u
X2279 VDD GND.t198 VDD VDD sg13_lv_pmos ad=0.34p pd=2.68u as=0 ps=0 w=1u l=1u
X2280 _243_.Q a_4554_3900# GND.t7 GND.t6 sg13_lv_nmos ad=0.2516p pd=2.16u as=0.1406p ps=1.12u w=0.74u l=0.13u
X2281 a_15980_7638# fanout7.A VDD VDD sg13_lv_pmos ad=0.2856p pd=2.36u as=0.2114p ps=1.54u w=0.84u l=0.13u
X2282 a_5242_8806# _173_.A _173_.Y GND.t21 sg13_lv_nmos ad=0.1406p pd=1.12u as=0.2516p ps=2.16u w=0.74u l=0.13u
X2283 a_2150_9186# _246_.D VDD VDD sg13_lv_pmos ad=79.8f pd=0.8u as=0.1428p ps=1.52u w=0.42u l=0.13u
X2284 a_7451_14484# _193_.Y VDD VDD sg13_lv_pmos ad=0.3808p pd=2.92u as=0.2128p ps=1.5u w=1.12u l=0.13u
X2285 GND.t718 VDD GND.t718 GND.t158 sg13_lv_nmos ad=0.1428p pd=1.52u as=0 ps=0 w=0.42u l=1u
X2286 a_8480_4248# _145_.A2 GND.t37 GND.t585 sg13_lv_nmos ad=94.35f pd=0.995u as=0.2516p ps=2.16u w=0.74u l=0.13u
X2287 GND.t136 VDD GND.t1000 GND.t999 sg13_lv_nmos ad=79.8f pd=0.8u as=0 ps=0 w=0.42u l=1u
X2288 a_6885_4629# _251_.CLK VDD VDD sg13_lv_pmos ad=0.4088p pd=2.97u as=1.42082p ps=9.125u w=1.12u l=0.13u
X2289 VDD GND.t1161 VDD VDD sg13_lv_pmos ad=0.34p pd=2.68u as=0 ps=0 w=1u l=1u
X2290 a_9322_4873# a_9765_4629# a_9062_4650# GND.t1468 sg13_lv_nmos ad=79.8f pd=0.8u as=0.1296p ps=1.52u w=0.42u l=0.13u
X2291 VDD a_13221_16007# a_13323_16007# VDD sg13_lv_pmos ad=1.6291p pd=10.53u as=0.3864p ps=2.93u w=1.12u l=0.13u
X2292 GND.t815 VDD GND.t812 GND.t814 sg13_lv_nmos ad=0.1428p pd=1.52u as=0 ps=0 w=0.42u l=1u
X2293 a_14063_16357# a_13221_16007# a_12804_16000# VDD sg13_lv_pmos ad=0.2048p pd=1.63u as=0.34p ps=2.68u w=1u l=0.13u
X2294 VDD a_2126_15424# _118_.X VDD sg13_lv_pmos ad=0.2198p pd=1.52u as=0.6048p ps=3.32u w=1.12u l=0.13u
X2295 a_9156_4650# _252_.D a_9062_4650# GND.t183 sg13_lv_nmos ad=60.89999f pd=0.71u as=0.1428p ps=1.52u w=0.42u l=0.13u
X2296 GND.t1172 VDD GND.t223 GND.t5 sg13_lv_nmos ad=0.1428p pd=1.52u as=0 ps=0 w=0.42u l=1u
X2297 VDD GND.t718 VDD VDD sg13_lv_pmos ad=0.34p pd=2.68u as=0 ps=0 w=1u l=1u
X2298 _241_.Y _236_.A GND.t515 GND.t596 sg13_lv_nmos ad=0.2516p pd=2.16u as=0.2516p ps=2.16u w=0.74u l=0.13u
X2299 _243_.RESET_B _215_.A VDD VDD sg13_lv_pmos ad=0.3808p pd=2.92u as=0.3808p ps=2.92u w=1.12u l=0.13u
X2300 a_15046_9199# _260_.RESET_B GND.t21 GND.t468 sg13_lv_nmos ad=37.8f pd=0.6u as=0.1701p ps=1.65u w=0.42u l=0.13u
X2301 a_5376_17061# _207_.A1 VDD VDD sg13_lv_pmos ad=0.1596p pd=1.22u as=0.4536p ps=2.76u w=0.84u l=0.13u
X2302 VDD GND.t701 VDD VDD sg13_lv_pmos ad=0.19p pd=1.38u as=0 ps=0 w=1u l=1u
X2303 _192_.C a_6048_13011# a_6197_13342# GND.t46 sg13_lv_nmos ad=0.2516p pd=2.16u as=0.1406p ps=1.12u w=0.74u l=0.13u
X2304 a_3300_5416# a_3819_5423# a_4559_5773# GND.t5 sg13_lv_nmos ad=0.3473p pd=2.71u as=0.12665p ps=1.145u w=0.74u l=0.13u
X2305 a_8964_13722# _194_.X a_8870_13722# GND.t46 sg13_lv_nmos ad=60.89999f pd=0.71u as=0.1428p ps=1.52u w=0.42u l=0.13u
X2306 VDD GND.t1061 VDD VDD sg13_lv_pmos ad=0.34p pd=2.68u as=0 ps=0 w=1u l=1u
X2307 a_2052_12210# _120_.X a_1958_12210# GND.t62 sg13_lv_nmos ad=60.89999f pd=0.71u as=0.1428p ps=1.52u w=0.42u l=0.13u
X2308 a_6862_15532# _200_.Y VDD VDD sg13_lv_pmos ad=0.2128p pd=1.5u as=0.3808p ps=2.92u w=1.12u l=0.13u
X2309 GND.t221 a_7616_15437# _205_.B1 GND.t257 sg13_lv_nmos ad=0.1331p pd=1.12u as=0.2516p ps=2.16u w=0.74u l=0.13u
X2310 freq_out a_16840_4688# VDD VDD sg13_lv_pmos ad=0.42p pd=2.99u as=0.2114p ps=1.54u w=1.12u l=0.13u
X2311 VDD _227_.Y a_14534_8874# VDD sg13_lv_pmos ad=0.36237p pd=2.605u as=79.8f ps=0.8u w=0.42u l=0.13u
X2312 VDD GND.t1182 VDD VDD sg13_lv_pmos ad=0.34p pd=2.68u as=0 ps=0 w=1u l=1u
X2313 a_14794_11428# a_15237_11471# a_15177_11507# VDD sg13_lv_pmos ad=79.8f pd=0.8u as=63f ps=0.72u w=0.42u l=0.13u
X2314 a_8292_17064# a_8266_16969# VDD VDD sg13_lv_pmos ad=0.34p pd=2.68u as=0.36237p ps=2.605u w=1u l=0.13u
X2315 VDD GND.t806 VDD VDD sg13_lv_pmos ad=0.34p pd=2.68u as=0 ps=0 w=1u l=1u
X2316 VDD a_11279_9263# a_11946_9484# VDD sg13_lv_pmos ad=0.2128p pd=1.5u as=0.3864p ps=2.93u w=1.12u l=0.13u
X2317 VDD GND.t188 VDD VDD sg13_lv_pmos ad=0.19p pd=1.38u as=0 ps=0 w=1u l=1u
X2318 GND.t307 VDD GND.t307 GND.t888 sg13_lv_nmos ad=0.1428p pd=1.52u as=0 ps=0 w=0.42u l=1u
X2319 GND.t447 VDD GND.t277 GND.t46 sg13_lv_nmos ad=0.1428p pd=1.52u as=0 ps=0 w=0.42u l=1u
X2320 a_6516_4248# _210_.B a_6060_4166# GND.t522 sg13_lv_nmos ad=78.39999f pd=0.885u as=0.2176p ps=1.96u w=0.64u l=0.13u
X2321 VDD _252_.RESET_B a_9322_4873# VDD sg13_lv_pmos ad=0.1563p pd=1.22u as=0.147p ps=1.54u w=0.42u l=0.13u
X2322 GND.t180 a_3380_13690# _247_.CLK GND.t46 sg13_lv_nmos ad=0.1406p pd=1.12u as=0.1406p ps=1.12u w=0.74u l=0.13u
X2323 a_10415_12287# a_9573_12189# a_9156_12528# VDD sg13_lv_pmos ad=0.2048p pd=1.63u as=0.34p ps=2.68u w=1u l=0.13u
X2324 a_9513_14113# a_9156_14040# VDD VDD sg13_lv_pmos ad=63f pd=0.72u as=0.1563p ps=1.22u w=0.42u l=0.13u
X2325 GND.t483 _170_.B a_7841_9212# GND.t21 sg13_lv_nmos ad=0.2516p pd=2.16u as=0.1406p ps=1.12u w=0.74u l=0.13u
X2326 VDD GND.t26 VDD VDD sg13_lv_pmos ad=0.34p pd=2.68u as=0 ps=0 w=1u l=1u
X2327 GND.t264 VDD GND.t264 GND.t1140 sg13_lv_nmos ad=79.8f pd=0.8u as=0 ps=0 w=0.42u l=1u
X2328 a_14628_9186# _213_.Y a_14534_9186# GND.t44 sg13_lv_nmos ad=60.89999f pd=0.71u as=0.1428p ps=1.52u w=0.42u l=0.13u
X2329 VDD _118_.A0 a_4462_16052# VDD sg13_lv_pmos ad=0.2618p pd=1.63u as=0.2856p ps=2.36u w=0.84u l=0.13u
X2330 a_12106_12433# a_12549_12189# a_11846_12210# GND.t145 sg13_lv_nmos ad=79.8f pd=0.8u as=0.1296p ps=1.52u w=0.42u l=0.13u
X2331 a_2853_8447# _243_.CLK GND.t21 GND.t231 sg13_lv_nmos ad=0.2516p pd=2.16u as=3.59495p ps=22.57u w=0.74u l=0.13u
X2332 a_2398_4654# _243_.Q a_2301_4948# VDD sg13_lv_pmos ad=0.2225p pd=1.445u as=0.3325p ps=1.665u w=1u l=0.13u
X2333 a_7616_15437# _193_.Y a_7753_15280# GND.t317 sg13_lv_nmos ad=0.2176p pd=1.96u as=0.1216p ps=1.02u w=0.64u l=0.13u
X2334 a_15012_12223# a_15243_12332# a_14698_12433# GND.t582 sg13_lv_nmos ad=0.2373p pd=1.97u as=79.8f ps=0.8u w=0.42u l=0.13u
X2335 a_12825_17061# a_11883_16868# a_12623_16823# VDD sg13_lv_pmos ad=93.45f pd=0.865u as=0.2048p ps=1.63u w=0.42u l=0.13u
X2336 VDD GND.t821 VDD VDD sg13_lv_pmos ad=0.19p pd=1.38u as=0 ps=0 w=1u l=1u
X2337 VDD a_15141_5423# a_15243_5423# VDD sg13_lv_pmos ad=1.48542p pd=9.54u as=0.3864p ps=2.93u w=1.12u l=0.13u
X2338 a_15177_8483# a_14820_8440# VDD VDD sg13_lv_pmos ad=63f pd=0.72u as=0.1563p ps=1.22u w=0.42u l=0.13u
X2339 _161_.Y _153_.Y a_12730_8806# GND.t459 sg13_lv_nmos ad=0.2516p pd=2.16u as=0.1406p ps=1.12u w=0.74u l=0.13u
X2340 VDD GND.t439 VDD VDD sg13_lv_pmos ad=0.19p pd=1.38u as=0 ps=0 w=1u l=1u
X2341 a_4816_5654# _244_.RESET_B VDD VDD sg13_lv_pmos ad=79.8f pd=0.8u as=1.48542p ps=9.54u w=0.42u l=0.13u
X2342 VDD GND.t1227 VDD VDD sg13_lv_pmos ad=0.19p pd=1.38u as=0 ps=0 w=1u l=1u
X2343 GND.t47 a_4913_13330# _189_.X GND.t46 sg13_lv_nmos ad=0.3108p pd=2.32u as=0.1628p ps=1.18u w=0.74u l=0.13u
X2344 VDD GND.t5 VDD VDD sg13_lv_pmos ad=0.34p pd=2.68u as=0 ps=0 w=1u l=1u
X2345 VDD a_16079_9263# a_16336_9406# VDD sg13_lv_pmos ad=1.94845p pd=12.685u as=79.8f ps=0.8u w=0.42u l=0.13u
X2346 VDD GND.t908 VDD VDD sg13_lv_pmos ad=0.34p pd=2.68u as=0 ps=0 w=1u l=1u
X2347 a_13978_13342# _260_.CLK _128_.B1 GND.t538 sg13_lv_nmos ad=0.1406p pd=1.12u as=0.2516p ps=2.16u w=0.74u l=0.13u
X2348 a_2620_11830# _173_.A a_2126_11726# GND.t189 sg13_lv_nmos ad=0.13135p pd=1.095u as=0.1628p ps=1.18u w=0.74u l=0.13u
X2349 _266_.CLK a_13290_17044# VDD VDD sg13_lv_pmos ad=0.3808p pd=2.92u as=0.2128p ps=1.5u w=1.12u l=0.13u
X2350 VDD GND.t1006 VDD VDD sg13_lv_pmos ad=0.34p pd=2.68u as=0 ps=0 w=1u l=1u
X2351 _138_.Y _136_.A GND.t65 GND.t605 sg13_lv_nmos ad=0.1406p pd=1.12u as=0.2516p ps=2.16u w=0.74u l=0.13u
X2352 VDD GND.t1164 VDD VDD sg13_lv_pmos ad=0.19p pd=1.38u as=0 ps=0 w=1u l=1u
X2353 GND.t5 a_2075_5468# a_2512_5782# GND.t83 sg13_lv_nmos ad=0.148p pd=1.14u as=0.3367p ps=1.65u w=0.74u l=0.13u
X2354 GND.t121 a_11279_17869# a_11946_17508# GND.t158 sg13_lv_nmos ad=0.1406p pd=1.12u as=0.2516p ps=2.16u w=0.74u l=0.13u
X2355 VDD _119_.A0 a_5084_12972# VDD sg13_lv_pmos ad=0.2128p pd=1.5u as=0.3808p ps=2.92u w=1.12u l=0.13u
X2356 GND.t356 _219_.Y a_2244_9186# GND.t451 sg13_lv_nmos ad=0.1626p pd=1.415u as=60.89999f ps=0.71u w=0.42u l=0.13u
X2357 VDD GND.t718 VDD VDD sg13_lv_pmos ad=0.34p pd=2.68u as=0 ps=0 w=1u l=1u
X2358 a_2232_17770# _124_.S GND.t26 GND.t192 sg13_lv_nmos ad=0.187p pd=1.78u as=0.18945p ps=1.27u w=0.55u l=0.13u
X2359 GND.t671 VDD GND.t671 GND.t1051 sg13_lv_nmos ad=0.1428p pd=1.52u as=0 ps=0 w=0.42u l=1u
X2360 a_11940_12210# _126_.Y a_11846_12210# GND.t1461 sg13_lv_nmos ad=60.89999f pd=0.71u as=0.1428p ps=1.52u w=0.42u l=0.13u
X2361 a_12331_5760# _148_.A a_12237_5760# GND.t5 sg13_lv_nmos ad=0.1216p pd=1.02u as=0.2176p ps=1.96u w=0.64u l=0.13u
X2362 _118_.A0 a_4074_17044# GND.t173 GND.t14 sg13_lv_nmos ad=0.2516p pd=2.16u as=0.1406p ps=1.12u w=0.74u l=0.13u
X2363 VDD GND.t68 VDD VDD sg13_lv_pmos ad=0.34p pd=2.68u as=0 ps=0 w=1u l=1u
X2364 VDD GND.t794 VDD VDD sg13_lv_pmos ad=0.19p pd=1.38u as=0 ps=0 w=1u l=1u
X2365 VDD GND.t1360 VDD VDD sg13_lv_pmos ad=0.19p pd=1.38u as=0 ps=0 w=1u l=1u
X2366 VDD _241_.Y a_11078_16746# VDD sg13_lv_pmos ad=0.36237p pd=2.605u as=79.8f ps=0.8u w=0.42u l=0.13u
X2367 GND.t119 _124_.S a_2075_4692# GND.t206 sg13_lv_nmos ad=0.18945p pd=1.27u as=0.187p ps=1.78u w=0.55u l=0.13u
X2368 _170_.Y _165_.Y a_7736_8802# GND.t21 sg13_lv_nmos ad=0.2516p pd=2.16u as=0.1406p ps=1.12u w=0.74u l=0.13u
X2369 VDD GND.t1164 VDD VDD sg13_lv_pmos ad=0.34p pd=2.68u as=0 ps=0 w=1u l=1u
X2370 GND.t1027 a_3886_10702# clkbuf_1_0__f_sclk.A GND.t1444 sg13_lv_nmos ad=0.1406p pd=1.12u as=0.1406p ps=1.12u w=0.74u l=0.13u
X2371 a_13804_10996# _131_.A2 _132_.Y VDD sg13_lv_pmos ad=0.1176p pd=1.33u as=0.3808p ps=2.92u w=1.12u l=0.13u
X2372 VDD GND.t359 VDD VDD sg13_lv_pmos ad=0.19p pd=1.38u as=0 ps=0 w=1u l=1u
X2373 VDD a_2661_12189# a_2763_12332# VDD sg13_lv_pmos ad=1.42082p pd=9.125u as=0.3864p ps=2.93u w=1.12u l=0.13u
X2374 VDD a_11731_8698# _180_.X VDD sg13_lv_pmos ad=0.3808p pd=2.92u as=0.3808p ps=2.92u w=1.12u l=0.13u
X2375 GND.t806 VDD GND.t806 GND.t853 sg13_lv_nmos ad=0.1428p pd=1.52u as=0 ps=0 w=0.42u l=1u
X2376 a_14950_5837# _226_.Y GND.t1194 GND.t1572 sg13_lv_nmos ad=37.8f pd=0.6u as=0.1701p ps=1.65u w=0.42u l=0.13u
X2377 _247_.CLK a_3380_13690# GND.t375 GND.t46 sg13_lv_nmos ad=0.1406p pd=1.12u as=0.1406p ps=1.12u w=0.74u l=0.13u
X2378 VDD GND.t354 VDD VDD sg13_lv_pmos ad=0.19p pd=1.38u as=0 ps=0 w=1u l=1u
X2379 VDD GND.t342 VDD VDD sg13_lv_pmos ad=0.34p pd=2.68u as=0 ps=0 w=1u l=1u
X2380 VDD GND.t1185 VDD VDD sg13_lv_pmos ad=0.34p pd=2.68u as=0 ps=0 w=1u l=1u
X2381 GND.t42 VDD GND.t42 GND.t990 sg13_lv_nmos ad=0.1428p pd=1.52u as=0 ps=0 w=0.42u l=1u
X2382 VDD GND.t718 VDD VDD sg13_lv_pmos ad=0.19p pd=1.38u as=0 ps=0 w=1u l=1u
X2383 VDD a_4144_4142# a_4089_4023# VDD sg13_lv_pmos ad=5.15485p pd=34.14u as=93.45f ps=0.865u w=0.42u l=0.13u
X2384 VDD a_3886_10702# clkbuf_1_0__f_sclk.A VDD sg13_lv_pmos ad=0.2128p pd=1.5u as=0.2128p ps=1.5u w=1.12u l=0.13u
X2385 a_14830_16746# a_15071_17016# a_14359_16710# GND.t209 sg13_lv_nmos ad=0.1428p pd=1.52u as=0.12665p ps=1.145u w=0.42u l=0.13u
X2386 VDD GND.t1221 VDD VDD sg13_lv_pmos ad=0.19p pd=1.38u as=0 ps=0 w=1u l=1u
X2387 a_2602_3868# a_3045_3911# a_2985_3947# VDD sg13_lv_pmos ad=79.8f pd=0.8u as=63f ps=0.72u w=0.42u l=0.13u
X2388 _149_.A a_16650_5412# VDD VDD sg13_lv_pmos ad=0.3808p pd=2.92u as=0.2128p ps=1.5u w=1.12u l=0.13u
X2389 _170_.B _154_.X VDD VDD sg13_lv_pmos ad=0.2128p pd=1.5u as=0.3808p ps=2.92u w=1.12u l=0.13u
X2390 GND.t198 VDD GND.t198 GND.t987 sg13_lv_nmos ad=0.1428p pd=1.52u as=0 ps=0 w=0.42u l=1u
X2391 VDD _145_.X a_11974_8436# VDD sg13_lv_pmos ad=0.19p pd=1.38u as=0.2125p ps=1.425u w=1u l=0.13u
X2392 GND.t13 VDD GND.t13 GND.t765 sg13_lv_nmos ad=0.1428p pd=1.52u as=0 ps=0 w=0.42u l=1u
X2393 GND.t266 VDD GND.t1061 GND.t1060 sg13_lv_nmos ad=0.1428p pd=1.52u as=0 ps=0 w=0.42u l=1u
X2394 GND.t106 _263_.CLK _133_.Y GND.t1512 sg13_lv_nmos ad=0.1463p pd=1.15u as=0.1694p ps=1.21u w=0.77u l=0.13u
X2395 a_8603_9484# _171_.A _181_.Y VDD sg13_lv_pmos ad=0.2128p pd=1.5u as=0.3808p ps=2.92u w=1.12u l=0.13u
X2396 VDD _176_.B a_6336_11499# VDD sg13_lv_pmos ad=0.2891p pd=1.695u as=0.1596p ps=1.22u w=0.84u l=0.13u
X2397 _243_.CLK a_3956_6888# GND.t557 GND.t567 sg13_lv_nmos ad=0.1406p pd=1.12u as=0.1406p ps=1.12u w=0.74u l=0.13u
X2398 VDD GND.t26 VDD VDD sg13_lv_pmos ad=0.19p pd=1.38u as=0 ps=0 w=1u l=1u
X2399 GND.t703 VDD GND.t703 GND.t705 sg13_lv_nmos ad=0.1428p pd=1.52u as=0 ps=0 w=0.42u l=1u
X2400 VDD a_14063_16357# a_14730_15996# VDD sg13_lv_pmos ad=0.2128p pd=1.5u as=0.3864p ps=2.93u w=1.12u l=0.13u
X2401 VDD GND.t1247 VDD VDD sg13_lv_pmos ad=0.19p pd=1.38u as=0 ps=0 w=1u l=1u
X2402 GND.t419 VDD GND.t1188 GND.t5 sg13_lv_nmos ad=0.1428p pd=1.52u as=0 ps=0 w=0.42u l=1u
X2403 VDD GND.t1155 VDD VDD sg13_lv_pmos ad=0.34p pd=2.68u as=0 ps=0 w=1u l=1u
X2404 VDD GND.t345 VDD VDD sg13_lv_pmos ad=0.19p pd=1.38u as=0 ps=0 w=1u l=1u
X2405 a_1580_16710# fanout8.A VDD VDD sg13_lv_pmos ad=0.2856p pd=2.36u as=0.2114p ps=1.54u w=0.84u l=0.13u
X2406 a_9130_13945# a_9573_13701# a_8870_13722# GND.t1535 sg13_lv_nmos ad=79.8f pd=0.8u as=0.1296p ps=1.52u w=0.42u l=0.13u
X2407 GND.t264 a_13073_7728# _160_.B GND.t487 sg13_lv_nmos ad=0.3108p pd=2.32u as=0.1628p ps=1.18u w=0.74u l=0.13u
X2408 a_10020_17512# a_10539_17519# a_11279_17869# GND.t158 sg13_lv_nmos ad=0.3473p pd=2.71u as=0.12665p ps=1.145u w=0.74u l=0.13u
X2409 _263_.CLK a_16266_15532# VDD VDD sg13_lv_pmos ad=0.3808p pd=2.92u as=0.2128p ps=1.5u w=1.12u l=0.13u
X2410 GND.t726 VDD GND.t718 GND.t158 sg13_lv_nmos ad=0.1428p pd=1.52u as=0 ps=0 w=0.42u l=1u
X2411 GND.t264 _160_.B a_13973_7678# GND.t532 sg13_lv_nmos ad=0.1898p pd=1.36u as=0.2516p ps=2.16u w=0.74u l=0.13u
X2412 VDD GND.t1224 VDD VDD sg13_lv_pmos ad=0.34p pd=2.68u as=0 ps=0 w=1u l=1u
X2413 VDD a_12549_12189# a_12651_12332# VDD sg13_lv_pmos ad=1.42082p pd=9.125u as=0.3864p ps=2.93u w=1.12u l=0.13u
X2414 VDD GND.t1103 VDD VDD sg13_lv_pmos ad=0.34p pd=2.68u as=0 ps=0 w=1u l=1u
X2415 GND.t404 _256_.RESET_B a_8964_12210# GND.t403 sg13_lv_nmos ad=0.1626p pd=1.415u as=60.89999f ps=0.71u w=0.42u l=0.13u
X2416 _147_.B1 a_11661_4696# VDD VDD sg13_lv_pmos ad=0.3808p pd=2.92u as=0.1918p ps=1.5u w=1.12u l=0.13u
X2417 a_2301_4948# _124_.S VDD VDD sg13_lv_pmos ad=0.3325p pd=1.665u as=0.253p ps=1.53u w=1u l=0.13u
X2418 a_6468_4968# a_6987_4772# a_7727_4727# GND.t652 sg13_lv_nmos ad=0.3473p pd=2.71u as=0.12665p ps=1.145u w=0.74u l=0.13u
X2419 a_3760_12430# _220_.Y VDD VDD sg13_lv_pmos ad=79.8f pd=0.8u as=1.42082p ps=9.125u w=0.42u l=0.13u
X2420 VDD GND.t1365 VDD VDD sg13_lv_pmos ad=0.19p pd=1.38u as=0 ps=0 w=1u l=1u
X2421 VDD a_10752_7989# _162_.B VDD sg13_lv_pmos ad=0.3808p pd=2.92u as=0.2408p ps=1.55u w=1.12u l=0.13u
X2422 a_14794_8404# a_15237_8447# a_14534_8874# GND.t70 sg13_lv_nmos ad=79.8f pd=0.8u as=0.1296p ps=1.52u w=0.42u l=0.13u
X2423 a_12612_16434# _135_.X a_12518_16434# GND.t596 sg13_lv_nmos ad=60.89999f pd=0.71u as=0.1428p ps=1.52u w=0.42u l=0.13u
X2424 GND.t400 a_4559_4727# a_5226_4948# GND.t399 sg13_lv_nmos ad=0.1406p pd=1.12u as=0.2516p ps=2.16u w=0.74u l=0.13u
X2425 VDD a_3717_4629# a_3819_4772# VDD sg13_lv_pmos ad=1.48542p pd=9.54u as=0.3864p ps=2.93u w=1.12u l=0.13u
X2426 VDD GND.t703 VDD VDD sg13_lv_pmos ad=0.19p pd=1.38u as=0 ps=0 w=1u l=1u
X2427 a_14340_15552# a_14859_15356# a_15599_15311# GND.t61 sg13_lv_nmos ad=0.3473p pd=2.71u as=0.12665p ps=1.145u w=0.74u l=0.13u
X2428 VDD GND.t188 VDD VDD sg13_lv_pmos ad=0.34p pd=2.68u as=0 ps=0 w=1u l=1u
X2429 GND.t40 _168_.A a_6677_8806# GND.t21 sg13_lv_nmos ad=0.1898p pd=1.36u as=0.2516p ps=2.16u w=0.74u l=0.13u
X2430 VDD GND.t307 VDD VDD sg13_lv_pmos ad=0.19p pd=1.38u as=0 ps=0 w=1u l=1u
X2431 a_1862_16746# _118_.X VDD VDD sg13_lv_pmos ad=79.8f pd=0.8u as=0.1428p ps=1.52u w=0.42u l=0.13u
X2432 GND.t391 VDD GND.t391 GND.t921 sg13_lv_nmos ad=0.1428p pd=1.52u as=0 ps=0 w=0.42u l=1u
X2433 GND.t794 VDD GND.t794 GND.t832 sg13_lv_nmos ad=79.8f pd=0.8u as=0 ps=0 w=0.42u l=1u
X2434 GND.t106 _131_.A2 a_13025_11808# GND.t105 sg13_lv_nmos ad=0.2516p pd=2.16u as=0.1406p ps=1.12u w=0.74u l=0.13u
X2435 GND.t180 a_3407_13333# a_4074_12972# GND.t46 sg13_lv_nmos ad=0.1406p pd=1.12u as=0.2516p ps=2.16u w=0.74u l=0.13u
X2436 VDD GND.t1311 VDD VDD sg13_lv_pmos ad=0.34p pd=2.68u as=0 ps=0 w=1u l=1u
X2437 a_8115_5412# _143_.A VDD VDD sg13_lv_pmos ad=0.1428p pd=1.375u as=0.2891p ps=1.695u w=1.12u l=0.13u
X2438 a_14820_9504# a_14794_9409# GND.t21 GND.t1403 sg13_lv_nmos ad=0.2516p pd=2.16u as=0.1626p ps=1.415u w=0.74u l=0.13u
X2439 GND.t450 a_3952_9406# a_3601_9263# GND.t21 sg13_lv_nmos ad=79.8f pd=0.8u as=0.1428p ps=1.52u w=0.42u l=0.13u
X2440 GND.t803 VDD GND.t803 GND.t804 sg13_lv_nmos ad=79.8f pd=0.8u as=0 ps=0 w=0.42u l=1u
X2441 _151_.B a_13073_5770# a_13244_5412# VDD sg13_lv_pmos ad=0.3808p pd=2.92u as=0.2128p ps=1.5u w=1.12u l=0.13u
X2442 a_2436_8440# a_2955_8447# a_3695_8797# GND.t21 sg13_lv_nmos ad=0.3473p pd=2.71u as=0.12665p ps=1.145u w=0.74u l=0.13u
X2443 a_11481_9501# a_10539_9308# a_11279_9263# VDD sg13_lv_pmos ad=93.45f pd=0.865u as=0.2048p ps=1.63u w=0.42u l=0.13u
X2444 _220_.Y _215_.A VDD VDD sg13_lv_pmos ad=0.3808p pd=2.92u as=0.3808p ps=2.92u w=1.12u l=0.13u
X2445 VDD GND.t33 VDD VDD sg13_lv_pmos ad=0.19p pd=1.38u as=0 ps=0 w=1u l=1u
X2446 VDD GND.t264 VDD VDD sg13_lv_pmos ad=0.19p pd=1.38u as=0 ps=0 w=1u l=1u
X2447 VDD GND.t671 VDD VDD sg13_lv_pmos ad=0.34p pd=2.68u as=0 ps=0 w=1u l=1u
X2448 _209_.Y a_6720_17061# a_6869_16750# GND.t14 sg13_lv_nmos ad=0.2516p pd=2.16u as=0.1406p ps=1.12u w=0.74u l=0.13u
X2449 a_14534_11898# _131_.Y VDD VDD sg13_lv_pmos ad=79.8f pd=0.8u as=0.1428p ps=1.52u w=0.42u l=0.13u
X2450 GND.t674 _236_.A _240_.Y GND.t19 sg13_lv_nmos ad=0.2516p pd=2.16u as=0.2516p ps=2.16u w=0.74u l=0.13u
X2451 _192_.C _189_.X a_6291_12972# VDD sg13_lv_pmos ad=0.2408p pd=1.55u as=0.1428p ps=1.375u w=1.12u l=0.13u
X2452 GND.t1205 a_16240_5654# a_15889_5773# GND.t82 sg13_lv_nmos ad=79.8f pd=0.8u as=0.1428p ps=1.52u w=0.42u l=0.13u
X2453 GND.t136 _179_.Y a_8501_10702# GND.t135 sg13_lv_nmos ad=0.1898p pd=1.36u as=0.2516p ps=2.16u w=0.74u l=0.13u
X2454 a_6048_13011# _190_.A VDD VDD sg13_lv_pmos ad=0.1596p pd=1.22u as=0.4536p ps=2.76u w=0.84u l=0.13u
X2455 VDD GND.t1296 VDD VDD sg13_lv_pmos ad=0.34p pd=2.68u as=0 ps=0 w=1u l=1u
X2456 GND.t1065 VDD GND.t1064 GND.t1063 sg13_lv_nmos ad=0.1428p pd=1.52u as=0 ps=0 w=0.42u l=1u
X2457 VDD _179_.Y _183_.Y VDD sg13_lv_pmos ad=0.3808p pd=2.92u as=0.2128p ps=1.5u w=1.12u l=0.13u
X2458 VDD GND.t1006 VDD VDD sg13_lv_pmos ad=0.34p pd=2.68u as=0 ps=0 w=1u l=1u
X2459 a_15599_15311# a_14757_15213# a_15505_15311# GND.t579 sg13_lv_nmos ad=0.12665p pd=1.145u as=0.1428p ps=1.52u w=0.42u l=0.13u
X2460 VDD _174_.Y a_6389_9484# VDD sg13_lv_pmos ad=0.2128p pd=1.5u as=0.3808p ps=2.92u w=1.12u l=0.13u
X2461 GND.t219 _201_.Y a_7157_16366# GND.t14 sg13_lv_nmos ad=0.1898p pd=1.36u as=0.2516p ps=2.16u w=0.74u l=0.13u
X2462 GND.t441 VDD GND.t441 GND.t895 sg13_lv_nmos ad=0.1428p pd=1.52u as=0 ps=0 w=0.42u l=1u
X2463 _147_.Y _147_.A1 a_11475_4248# GND.t1499 sg13_lv_nmos ad=0.1406p pd=1.12u as=0.1406p ps=1.12u w=0.74u l=0.13u
X2464 GND.t876 VDD GND.t310 GND.t875 sg13_lv_nmos ad=0.1428p pd=1.52u as=0 ps=0 w=0.42u l=1u
X2465 GND.t557 a_3956_6888# _243_.CLK GND.t560 sg13_lv_nmos ad=0.1406p pd=1.12u as=0.1406p ps=1.12u w=0.74u l=0.13u
X2466 GND.t671 VDD GND.t671 GND.t1054 sg13_lv_nmos ad=79.8f pd=0.8u as=0 ps=0 w=0.42u l=1u
X2467 a_14919_16964# a_15071_17016# VDD VDD sg13_lv_pmos ad=0.3864p pd=2.93u as=1.30717p ps=8.395u w=1.12u l=0.13u
X2468 GND.t797 VDD GND.t797 GND.t798 sg13_lv_nmos ad=0.1428p pd=1.52u as=0 ps=0 w=0.42u l=1u
X2469 VDD _247_.CLK clkload0.Y VDD sg13_lv_pmos ad=0.3808p pd=2.92u as=0.3808p ps=2.92u w=1.12u l=0.13u
X2470 a_7985_13776# _186_.Y GND.t908 GND.t46 sg13_lv_nmos ad=0.17462p pd=1.185u as=0.374p ps=2.46u w=0.55u l=0.13u
X2471 _256_.RESET_B _236_.A GND.t404 GND.t675 sg13_lv_nmos ad=0.2516p pd=2.16u as=0.2516p ps=2.16u w=0.74u l=0.13u
X2472 _148_.A a_5226_5412# GND.t508 GND.t5 sg13_lv_nmos ad=0.2516p pd=2.16u as=0.1406p ps=1.12u w=0.74u l=0.13u
X2473 VDD GND.t1227 VDD VDD sg13_lv_pmos ad=0.34p pd=2.68u as=0 ps=0 w=1u l=1u
X2474 a_8595_10996# _179_.Y VDD VDD sg13_lv_pmos ad=0.1428p pd=1.375u as=0.2891p ps=1.695u w=1.12u l=0.13u
X2475 VDD GND.t871 VDD VDD sg13_lv_pmos ad=0.34p pd=2.68u as=0 ps=0 w=1u l=1u
X2476 VDD GND.t1094 VDD VDD sg13_lv_pmos ad=0.19p pd=1.38u as=0 ps=0 w=1u l=1u
X2477 a_15108_11885# a_15339_11471# a_14794_11428# GND.t616 sg13_lv_nmos ad=0.2373p pd=1.97u as=79.8f ps=0.8u w=0.42u l=0.13u
X2478 VDD GND.t956 VDD VDD sg13_lv_pmos ad=0.19p pd=1.38u as=0 ps=0 w=1u l=1u
X2479 _136_.B a_8394_4948# VDD VDD sg13_lv_pmos ad=0.3808p pd=2.92u as=0.2128p ps=1.5u w=1.12u l=0.13u
X2480 VDD a_9765_4629# a_9867_4772# VDD sg13_lv_pmos ad=1.48542p pd=9.54u as=0.3864p ps=2.93u w=1.12u l=0.13u
X2481 a_12420_12223# a_12651_12332# a_12106_12433# GND.t145 sg13_lv_nmos ad=0.2373p pd=1.97u as=79.8f ps=0.8u w=0.42u l=0.13u
X2482 a_8042_3900# _136_.A VDD VDD sg13_lv_pmos ad=0.1176p pd=1.33u as=0.4032p ps=2.96u w=1.12u l=0.13u
X2483 a_2298_14020# a_2232_13916# VDD VDD sg13_lv_pmos ad=0.2975p pd=1.595u as=0.2198p ps=1.52u w=1u l=0.13u
X2484 GND.t768 _222_.A _250_.RESET_B GND.t601 sg13_lv_nmos ad=0.2516p pd=2.16u as=0.2516p ps=2.16u w=0.74u l=0.13u
X2485 VDD GND.t136 VDD VDD sg13_lv_pmos ad=0.19p pd=1.38u as=0 ps=0 w=1u l=1u
X2486 a_4796_17044# _207_.Y VDD VDD sg13_lv_pmos ad=0.2128p pd=1.5u as=0.2128p ps=1.5u w=1.12u l=0.13u
X2487 a_11652_16759# a_11883_16868# a_11338_16969# GND.t19 sg13_lv_nmos ad=0.2373p pd=1.97u as=79.8f ps=0.8u w=0.42u l=0.13u
X2488 a_2601_12601# a_2244_12528# VDD VDD sg13_lv_pmos ad=63f pd=0.72u as=0.1563p ps=1.22u w=0.42u l=0.13u
X2489 VDD GND.t188 VDD VDD sg13_lv_pmos ad=0.34p pd=2.68u as=0 ps=0 w=1u l=1u
X2490 VDD GND.t342 VDD VDD sg13_lv_pmos ad=0.34p pd=2.68u as=0 ps=0 w=1u l=1u
X2491 a_14314_15457# a_14757_15213# a_14054_15234# GND.t576 sg13_lv_nmos ad=79.8f pd=0.8u as=0.1296p ps=1.52u w=0.42u l=0.13u
X2492 VDD GND.t26 VDD VDD sg13_lv_pmos ad=0.34p pd=2.68u as=0 ps=0 w=1u l=1u
X2493 VDD a_3380_13690# _247_.CLK VDD sg13_lv_pmos ad=0.2128p pd=1.5u as=0.2128p ps=1.5u w=1.12u l=0.13u
X2494 GND.t1103 VDD GND.t1103 GND.t1102 sg13_lv_nmos ad=0.1428p pd=1.52u as=0 ps=0 w=0.42u l=1u
X2495 a_7262_3900# _136_.B a_6810_3863# VDD sg13_lv_pmos ad=0.1225p pd=1.245u as=0.34p ps=2.68u w=1u l=0.13u
X2496 GND.t1108 VDD GND.t264 GND.t1143 sg13_lv_nmos ad=0.1428p pd=1.52u as=0 ps=0 w=0.42u l=1u
X2497 GND.t671 VDD GND.t671 GND.t1018 sg13_lv_nmos ad=0.1428p pd=1.52u as=0 ps=0 w=0.42u l=1u
X2498 GND.t79 a_10607_4727# a_11274_4948# GND.t1576 sg13_lv_nmos ad=0.1406p pd=1.12u as=0.2516p ps=2.16u w=0.74u l=0.13u
X2499 GND.t264 a_13184_7183# _160_.X GND.t1457 sg13_lv_nmos ad=0.1331p pd=1.12u as=0.2516p ps=2.16u w=0.74u l=0.13u
X2500 a_14534_8874# a_15339_8447# a_14794_8404# VDD sg13_lv_pmos ad=0.1428p pd=1.52u as=79.8f ps=0.8u w=0.42u l=0.13u
X2501 a_2916_4325# a_3147_3911# a_2602_3868# GND.t140 sg13_lv_nmos ad=0.2373p pd=1.97u as=79.8f ps=0.8u w=0.42u l=0.13u
X2502 GND.t57 sdata a_1192_7712# GND.t526 sg13_lv_nmos ad=0.14875p pd=1.16u as=0.187p ps=1.78u w=0.55u l=0.13u
X2503 VDD GND.t897 VDD VDD sg13_lv_pmos ad=0.19p pd=1.38u as=0 ps=0 w=1u l=1u
X2504 VDD GND.t345 VDD VDD sg13_lv_pmos ad=0.19p pd=1.38u as=0 ps=0 w=1u l=1u
X2505 VDD GND.t1108 VDD VDD sg13_lv_pmos ad=0.19p pd=1.38u as=0 ps=0 w=1u l=1u
X2506 a_2662_9199# _219_.Y GND.t356 GND.t449 sg13_lv_nmos ad=37.8f pd=0.6u as=0.1701p ps=1.65u w=0.42u l=0.13u
X2507 a_15046_8861# _227_.Y GND.t21 GND.t468 sg13_lv_nmos ad=37.8f pd=0.6u as=0.1701p ps=1.65u w=0.42u l=0.13u
X2508 a_5201_9240# _136_.A a_5169_9508# VDD sg13_lv_pmos ad=0.34p pd=2.68u as=0.1225p ps=1.245u w=1u l=0.13u
X2509 clkbuf_1_0__f_sclk.A a_3886_10702# GND.t1027 GND.t1445 sg13_lv_nmos ad=0.1406p pd=1.12u as=0.1406p ps=1.12u w=0.74u l=0.13u
X2510 GND.t404 VDD GND.t404 GND.t941 sg13_lv_nmos ad=0.1428p pd=1.52u as=0 ps=0 w=0.42u l=1u
X2511 a_7984_4870# a_7727_4727# a_8146_4650# GND.t535 sg13_lv_nmos ad=0.1428p pd=1.52u as=37.8f ps=0.6u w=0.42u l=0.13u
X2512 VDD GND.t718 VDD VDD sg13_lv_pmos ad=0.34p pd=2.68u as=0 ps=0 w=1u l=1u
X2513 VDD GND.t693 VDD VDD sg13_lv_pmos ad=0.19p pd=1.38u as=0 ps=0 w=1u l=1u
X2514 VDD a_11279_17869# a_11536_17750# VDD sg13_lv_pmos ad=1.30717p pd=8.395u as=79.8f ps=0.8u w=0.42u l=0.13u
X2515 VDD GND.t838 VDD VDD sg13_lv_pmos ad=0.19p pd=1.38u as=0 ps=0 w=1u l=1u
X2516 VDD GND.t671 VDD VDD sg13_lv_pmos ad=0.19p pd=1.38u as=0 ps=0 w=1u l=1u
X2517 VDD GND.t131 VDD VDD sg13_lv_pmos ad=0.34p pd=2.68u as=0 ps=0 w=1u l=1u
X2518 a_6048_13011# _189_.X a_6011_13320# GND.t46 sg13_lv_nmos ad=0.2176p pd=1.96u as=78.39999f ps=0.885u w=0.64u l=0.13u
X2519 _219_.Y _215_.A VDD VDD sg13_lv_pmos ad=0.3808p pd=2.92u as=0.3808p ps=2.92u w=1.12u l=0.13u
X2520 a_14063_16357# a_13221_16007# a_13969_16357# GND.t58 sg13_lv_nmos ad=0.12665p pd=1.145u as=0.1428p ps=1.52u w=0.42u l=0.13u
X2521 a_16281_9501# a_15339_9308# a_16079_9263# VDD sg13_lv_pmos ad=93.45f pd=0.865u as=0.2048p ps=1.63u w=0.42u l=0.13u
X2522 GND.t9 a_16240_12430# a_15889_12287# GND.t241 sg13_lv_nmos ad=79.8f pd=0.8u as=0.1428p ps=1.52u w=0.42u l=0.13u
X2523 GND.t703 VDD GND.t703 GND.t748 sg13_lv_nmos ad=79.8f pd=0.8u as=0 ps=0 w=0.42u l=1u
X2524 a_14320_16238# _237_.Y VDD VDD sg13_lv_pmos ad=79.8f pd=0.8u as=1.6291p ps=10.53u w=0.42u l=0.13u
X2525 VDD _136_.B a_6836_3900# VDD sg13_lv_pmos ad=0.2128p pd=1.5u as=0.2128p ps=1.5u w=1.12u l=0.13u
X2526 GND.t264 VDD GND.t264 GND.t1106 sg13_lv_nmos ad=79.8f pd=0.8u as=0 ps=0 w=0.42u l=1u
X2527 VDD GND.t1006 VDD VDD sg13_lv_pmos ad=0.19p pd=1.38u as=0 ps=0 w=1u l=1u
X2528 GND.t1179 VDD GND.t1178 GND.t5 sg13_lv_nmos ad=0.1428p pd=1.52u as=0 ps=0 w=0.42u l=1u
X2529 _243_.CLK a_3956_6888# VDD VDD sg13_lv_pmos ad=0.2128p pd=1.5u as=0.2128p ps=1.5u w=1.12u l=0.13u
X2530 VDD GND.t806 VDD VDD sg13_lv_pmos ad=0.19p pd=1.38u as=0 ps=0 w=1u l=1u
X2531 VDD GND.t1247 VDD VDD sg13_lv_pmos ad=0.34p pd=2.68u as=0 ps=0 w=1u l=1u
X2532 VDD GND.t57 VDD VDD sg13_lv_pmos ad=0.34p pd=2.68u as=0 ps=0 w=1u l=1u
X2533 a_10895_8436# _164_.B1 _164_.Y VDD sg13_lv_pmos ad=0.3808p pd=2.92u as=0.2128p ps=1.5u w=1.12u l=0.13u
X2534 clkbuf_1_0__f_sclk.A a_3886_10702# VDD VDD sg13_lv_pmos ad=0.2128p pd=1.5u as=0.2128p ps=1.5u w=1.12u l=0.13u
X2535 VDD GND.t116 VDD VDD sg13_lv_pmos ad=0.19p pd=1.38u as=0 ps=0 w=1u l=1u
X2536 a_13338_5770# _147_.Y GND.t160 GND.t5 sg13_lv_nmos ad=88.8f pd=0.98u as=0.15245p ps=1.17u w=0.74u l=0.13u
X2537 clkbuf_1_0__f_sclk.A a_3886_10702# GND.t1025 GND.t1441 sg13_lv_nmos ad=0.1406p pd=1.12u as=0.1406p ps=1.12u w=0.74u l=0.13u
X2538 VDD GND.t307 VDD VDD sg13_lv_pmos ad=0.19p pd=1.38u as=0 ps=0 w=1u l=1u
X2539 a_2793_8483# a_2436_8440# VDD VDD sg13_lv_pmos ad=63f pd=0.72u as=0.1563p ps=1.22u w=0.42u l=0.13u
X2540 VDD GND.t465 VDD VDD sg13_lv_pmos ad=0.34p pd=2.68u as=0 ps=0 w=1u l=1u
X2541 GND.t133 a_2126_13912# _119_.X GND.t1382 sg13_lv_nmos ad=0.148p pd=1.14u as=0.4033p ps=2.57u w=0.74u l=0.13u
X2542 VDD _144_.B a_8564_5412# VDD sg13_lv_pmos ad=0.2128p pd=1.5u as=0.2128p ps=1.5u w=1.12u l=0.13u
X2543 VDD GND.t23 VDD VDD sg13_lv_pmos ad=0.19p pd=1.38u as=0 ps=0 w=1u l=1u
X2544 GND.t106 VDD GND.t106 GND.t982 sg13_lv_nmos ad=0.1428p pd=1.52u as=0 ps=0 w=0.42u l=1u
X2545 VDD a_3407_16357# a_3664_16238# VDD sg13_lv_pmos ad=1.6291p pd=10.53u as=79.8f ps=0.8u w=0.42u l=0.13u
X2546 a_14532_5850# _151_.X a_14438_5850# GND.t5 sg13_lv_nmos ad=60.89999f pd=0.71u as=0.1428p ps=1.52u w=0.42u l=0.13u
X2547 VDD _145_.X a_10895_8436# VDD sg13_lv_pmos ad=0.2128p pd=1.5u as=0.2128p ps=1.5u w=1.12u l=0.13u
X2548 _181_.Y _171_.A GND.t152 GND.t21 sg13_lv_nmos ad=0.1406p pd=1.12u as=0.2516p ps=2.16u w=0.74u l=0.13u
X2549 VDD GND.t198 VDD VDD sg13_lv_pmos ad=0.34p pd=2.68u as=0 ps=0 w=1u l=1u
X2550 VDD GND.t871 VDD VDD sg13_lv_pmos ad=0.19p pd=1.38u as=0 ps=0 w=1u l=1u
X2551 _134_.Y _128_.B1 a_12984_12952# VDD sg13_lv_pmos ad=0.2128p pd=1.5u as=0.2128p ps=1.5u w=1.12u l=0.15u
X2552 a_9636_4663# a_9348_4968# a_9574_4663# GND.t212 sg13_lv_nmos ad=0.1428p pd=1.52u as=37.8f ps=0.6u w=0.42u l=0.13u
X2553 GND.t21 _227_.Y a_14628_8874# GND.t467 sg13_lv_nmos ad=0.1626p pd=1.415u as=60.89999f ps=0.71u w=0.42u l=0.13u
X2554 VDD GND.t1367 VDD VDD sg13_lv_pmos ad=0.34p pd=2.68u as=0 ps=0 w=1u l=1u
X2555 VDD GND.t689 VDD VDD sg13_lv_pmos ad=0.34p pd=2.68u as=0 ps=0 w=1u l=1u
X2556 GND.t842 VDD GND.t315 GND.t843 sg13_lv_nmos ad=79.8f pd=0.8u as=0 ps=0 w=0.42u l=1u
X2557 VDD GND.t342 VDD VDD sg13_lv_pmos ad=0.34p pd=2.68u as=0 ps=0 w=1u l=1u
X2558 clkbuf_1_0__f_sclk.A a_3886_10702# VDD VDD sg13_lv_pmos ad=0.2128p pd=1.5u as=0.2128p ps=1.5u w=1.12u l=0.13u
X2559 GND.t26 _124_.S a_2620_17878# GND.t191 sg13_lv_nmos ad=0.18945p pd=1.27u as=0.13135p ps=1.095u w=0.74u l=0.13u
X2560 a_10989_8784# _160_.X GND.t171 GND.t338 sg13_lv_nmos ad=0.1406p pd=1.12u as=0.2516p ps=2.16u w=0.74u l=0.13u
X2561 _162_.B _154_.X a_10995_7972# VDD sg13_lv_pmos ad=0.2408p pd=1.55u as=0.1428p ps=1.375u w=1.12u l=0.13u
X2562 GND.t1094 VDD GND.t1094 GND.t1097 sg13_lv_nmos ad=79.8f pd=0.8u as=0 ps=0 w=0.42u l=1u
X2563 a_3886_10702# sclk GND.t198 GND.t1426 sg13_lv_nmos ad=0.1406p pd=1.12u as=0.1406p ps=1.12u w=0.74u l=0.13u
X2564 a_1580_16710# fanout8.A GND.t768 GND.t601 sg13_lv_nmos ad=0.187p pd=1.78u as=0.14875p ps=1.16u w=0.55u l=0.13u
X2565 GND.t773 VDD GND.t763 GND.t14 sg13_lv_nmos ad=0.1428p pd=1.52u as=0 ps=0 w=0.42u l=1u
X2566 VDD GND.t77 VDD VDD sg13_lv_pmos ad=0.34p pd=2.68u as=0 ps=0 w=1u l=1u
X2567 a_9062_4650# a_9867_4772# a_9322_4873# VDD sg13_lv_pmos ad=0.1428p pd=1.52u as=79.8f ps=0.8u w=0.42u l=0.13u
X2568 VDD GND.t345 VDD VDD sg13_lv_pmos ad=0.34p pd=2.68u as=0 ps=0 w=1u l=1u
X2569 VDD a_9808_16966# a_9753_17061# VDD sg13_lv_pmos ad=1.30717p pd=8.395u as=93.45f ps=0.865u w=0.42u l=0.13u
X2570 VDD GND.t697 VDD VDD sg13_lv_pmos ad=0.34p pd=2.68u as=0 ps=0 w=1u l=1u
X2571 VDD GND.t809 VDD VDD sg13_lv_pmos ad=0.34p pd=2.68u as=0 ps=0 w=1u l=1u
X2572 GND.t51 _207_.Y a_4625_16800# GND.t14 sg13_lv_nmos ad=0.15245p pd=1.17u as=0.17462p ps=1.185u w=0.55u l=0.13u
X2573 GND.t1200 VDD GND.t1202 GND.t1201 sg13_lv_nmos ad=79.8f pd=0.8u as=0 ps=0 w=0.42u l=1u
X2574 VDD GND.t345 VDD VDD sg13_lv_pmos ad=0.19p pd=1.38u as=0 ps=0 w=1u l=1u
X2575 GND.t279 clkbuf_1_0__f_sclk.A a_3956_6888# GND.t282 sg13_lv_nmos ad=0.1406p pd=1.12u as=0.1406p ps=1.12u w=0.74u l=0.13u
X2576 VDD GND.t5 VDD VDD sg13_lv_pmos ad=0.19p pd=1.38u as=0 ps=0 w=1u l=1u
X2577 GND.t319 VDD GND.t909 GND.t46 sg13_lv_nmos ad=79.8f pd=0.8u as=0 ps=0 w=0.42u l=1u
X2578 a_14320_16238# a_14063_16357# a_14482_16434# GND.t58 sg13_lv_nmos ad=0.1428p pd=1.52u as=37.8f ps=0.6u w=0.42u l=0.13u
X2579 VDD GND.t794 VDD VDD sg13_lv_pmos ad=0.34p pd=2.68u as=0 ps=0 w=1u l=1u
X2580 a_6881_13320# _187_.Y _191_.Y GND.t46 sg13_lv_nmos ad=0.1406p pd=1.12u as=0.1406p ps=1.12u w=0.74u l=0.13u
X2581 a_14067_7972# _160_.B VDD VDD sg13_lv_pmos ad=0.1428p pd=1.375u as=0.2891p ps=1.695u w=1.12u l=0.13u
X2582 VDD _157_.Y a_12549_7996# VDD sg13_lv_pmos ad=0.19p pd=1.38u as=0.2125p ps=1.425u w=1u l=0.13u
X2583 VDD GND.t279 VDD VDD sg13_lv_pmos ad=0.19p pd=1.38u as=0 ps=0 w=1u l=1u
X2584 _125_.A1 a_1192_7712# VDD VDD sg13_lv_pmos ad=0.42p pd=2.99u as=0.2114p ps=1.54u w=1.12u l=0.13u
X2585 a_3886_10702# sclk VDD VDD sg13_lv_pmos ad=0.2128p pd=1.5u as=0.2128p ps=1.5u w=1.12u l=0.13u
X2586 a_1956_13410# _119_.X a_1862_13410# GND.t358 sg13_lv_nmos ad=60.89999f pd=0.71u as=0.1428p ps=1.52u w=0.42u l=0.13u
X2587 VDD GND.t253 VDD VDD sg13_lv_pmos ad=0.34p pd=2.68u as=0 ps=0 w=1u l=1u
X2588 GND.t413 VDD GND.t956 GND.t955 sg13_lv_nmos ad=79.8f pd=0.8u as=0 ps=0 w=0.42u l=1u
X2589 a_1862_16746# a_2667_16868# a_2122_16969# VDD sg13_lv_pmos ad=0.1428p pd=1.52u as=79.8f ps=0.8u w=0.42u l=0.13u
X2590 GND.t50 _118_.A0 a_4462_16052# GND.t14 sg13_lv_nmos ad=0.17255p pd=1.25u as=0.187p ps=1.78u w=0.55u l=0.13u
X2591 GND.t671 VDD GND.t671 GND.t1015 sg13_lv_nmos ad=79.8f pd=0.8u as=0 ps=0 w=0.42u l=1u
X2592 a_3956_6888# clkbuf_1_0__f_sclk.A GND.t279 GND.t278 sg13_lv_nmos ad=0.1406p pd=1.12u as=0.1406p ps=1.12u w=0.74u l=0.13u
X2593 _161_.Y _162_.B VDD VDD sg13_lv_pmos ad=0.2128p pd=1.5u as=0.3808p ps=2.92u w=1.12u l=0.13u
X2594 a_13883_11460# _129_.B1 _129_.Y VDD sg13_lv_pmos ad=0.2128p pd=1.5u as=0.3808p ps=2.92u w=1.12u l=0.13u
X2595 _176_.A a_11082_12508# VDD VDD sg13_lv_pmos ad=0.3808p pd=2.92u as=0.2128p ps=1.5u w=1.12u l=0.13u
X2596 VDD _153_.Y a_13244_7972# VDD sg13_lv_pmos ad=0.2128p pd=1.5u as=0.3808p ps=2.92u w=1.12u l=0.13u
X2597 GND.t345 VDD GND.t345 GND.t1099 sg13_lv_nmos ad=79.8f pd=0.8u as=0 ps=0 w=0.42u l=1u
X2598 a_2671_6460# _243_.Q a_2494_6166# VDD sg13_lv_pmos ad=0.2975p pd=1.595u as=0.2225p ps=1.445u w=1u l=0.13u
X2599 GND.t1032 a_3886_10702# clkbuf_1_0__f_sclk.A GND.t1456 sg13_lv_nmos ad=0.2516p pd=2.16u as=0.1406p ps=1.12u w=0.74u l=0.13u
X2600 VDD GND.t1094 VDD VDD sg13_lv_pmos ad=0.19p pd=1.38u as=0 ps=0 w=1u l=1u
X2601 a_4559_5773# a_3717_5423# a_3300_5416# VDD sg13_lv_pmos ad=0.2048p pd=1.63u as=0.34p ps=2.68u w=1u l=0.13u
X2602 VDD a_3956_6888# _243_.CLK VDD sg13_lv_pmos ad=0.2128p pd=1.5u as=0.2128p ps=1.5u w=1.12u l=0.13u
X2603 GND.t1108 VDD GND.t1108 GND.t1109 sg13_lv_nmos ad=79.8f pd=0.8u as=0 ps=0 w=0.42u l=1u
X2604 GND.t26 VDD GND.t26 GND.t733 sg13_lv_nmos ad=0.1428p pd=1.52u as=0 ps=0 w=0.42u l=1u
X2605 GND.t1 _242_.RESET_B a_3108_4650# GND.t298 sg13_lv_nmos ad=0.1626p pd=1.415u as=60.89999f ps=0.71u w=0.42u l=0.13u
X2606 VDD GND.t162 VDD VDD sg13_lv_pmos ad=0.34p pd=2.68u as=0 ps=0 w=1u l=1u
X2607 a_15980_7638# fanout7.A GND.t519 GND.t1520 sg13_lv_nmos ad=0.187p pd=1.78u as=0.14875p ps=1.16u w=0.55u l=0.13u
X2608 GND.t33 a_7985_7728# _154_.X GND.t1514 sg13_lv_nmos ad=0.3108p pd=2.32u as=0.1628p ps=1.18u w=0.74u l=0.13u
X2609 a_6060_4166# _210_.B VDD VDD sg13_lv_pmos ad=0.1596p pd=1.22u as=0.2891p ps=1.695u w=0.84u l=0.13u
X2610 GND.t264 VDD GND.t264 GND.t1139 sg13_lv_nmos ad=0.1428p pd=1.52u as=0 ps=0 w=0.42u l=1u
X2611 VDD a_3407_16823# a_3664_16966# VDD sg13_lv_pmos ad=1.30717p pd=8.395u as=79.8f ps=0.8u w=0.42u l=0.13u
X2612 GND.t362 VDD GND.t362 GND.t1237 sg13_lv_nmos ad=0.1428p pd=1.52u as=0 ps=0 w=0.42u l=1u
X2613 a_6483_9212# _174_.Y GND.t634 GND.t21 sg13_lv_nmos ad=0.1406p pd=1.12u as=0.2516p ps=2.16u w=0.74u l=0.13u
X2614 VDD a_3886_10702# clkbuf_1_0__f_sclk.A VDD sg13_lv_pmos ad=0.3976p pd=2.95u as=0.2128p ps=1.5u w=1.12u l=0.13u
X2615 VDD GND.t1178 VDD VDD sg13_lv_pmos ad=0.19p pd=1.38u as=0 ps=0 w=1u l=1u
X2616 GND.t136 VDD GND.t136 GND.t1033 sg13_lv_nmos ad=0.1428p pd=1.52u as=0 ps=0 w=0.42u l=1u
X2617 GND.t94 a_9167_16357# a_9834_15996# GND.t101 sg13_lv_nmos ad=0.1406p pd=1.12u as=0.2516p ps=2.16u w=0.74u l=0.13u
X2618 VDD _135_.A a_12992_15437# VDD sg13_lv_pmos ad=0.2856p pd=2.36u as=0.1596p ps=1.22u w=0.84u l=0.13u
X2619 VDD GND.t1372 VDD VDD sg13_lv_pmos ad=0.34p pd=2.68u as=0 ps=0 w=1u l=1u
X2620 GND.t718 VDD GND.t718 GND.t712 sg13_lv_nmos ad=79.8f pd=0.8u as=0 ps=0 w=0.42u l=1u
X2621 GND.t446 a_3664_16238# a_3313_16357# GND.t14 sg13_lv_nmos ad=79.8f pd=0.8u as=0.1428p ps=1.52u w=0.42u l=0.13u
X2622 VDD a_7872_5451# _252_.D VDD sg13_lv_pmos ad=0.3808p pd=2.92u as=0.2408p ps=1.55u w=1.12u l=0.13u
X2623 a_8557_4248# _143_.Y a_8480_4248# GND.t513 sg13_lv_nmos ad=0.1406p pd=1.12u as=94.35f ps=0.995u w=0.74u l=0.13u
X2624 a_15237_11471# _263_.CLK GND.t249 GND.t1510 sg13_lv_nmos ad=0.2516p pd=2.16u as=3.25075p ps=21.2u w=0.74u l=0.13u
X2625 a_9994_9409# a_10437_9165# a_10377_9577# VDD sg13_lv_pmos ad=79.8f pd=0.8u as=63f ps=0.72u w=0.42u l=0.13u
X2626 GND.t803 VDD GND.t803 GND.t851 sg13_lv_nmos ad=0.1428p pd=1.52u as=0 ps=0 w=0.42u l=1u
X2627 VDD a_3380_13690# _247_.CLK VDD sg13_lv_pmos ad=0.2128p pd=1.5u as=0.2128p ps=1.5u w=1.12u l=0.13u
X2628 VDD GND.t63 VDD VDD sg13_lv_pmos ad=0.34p pd=2.68u as=0 ps=0 w=1u l=1u
X2629 GND.t976 VDD GND.t131 GND.t975 sg13_lv_nmos ad=0.1428p pd=1.52u as=0 ps=0 w=0.42u l=1u
X2630 _259_.RESET_B _222_.A VDD VDD sg13_lv_pmos ad=0.3808p pd=2.92u as=0.3808p ps=2.92u w=1.12u l=0.13u
X2631 VDD a_6048_13011# _192_.C VDD sg13_lv_pmos ad=0.3808p pd=2.92u as=0.2408p ps=1.55u w=1.12u l=0.13u
X2632 a_14666_16746# a_14359_16710# a_14572_16746# GND.t209 sg13_lv_nmos ad=37.8f pd=0.6u as=0.1428p ps=1.52u w=0.42u l=0.13u
X2633 GND.t809 VDD GND.t806 GND.t808 sg13_lv_nmos ad=0.1428p pd=1.52u as=0 ps=0 w=0.42u l=1u
X2634 VDD GND.t1162 VDD VDD sg13_lv_pmos ad=0.34p pd=2.68u as=0 ps=0 w=1u l=1u
X2635 VDD GND.t718 VDD VDD sg13_lv_pmos ad=0.19p pd=1.38u as=0 ps=0 w=1u l=1u
X2636 _129_.B1 _126_.B1 a_13464_12952# VDD sg13_lv_pmos ad=0.2128p pd=1.5u as=0.2128p ps=1.5u w=1.12u l=0.15u
X2637 GND.t1205 VDD GND.t1206 GND.t1203 sg13_lv_nmos ad=79.8f pd=0.8u as=0 ps=0 w=0.42u l=1u
X2638 _243_.CLK a_3956_6888# GND.t569 GND.t570 sg13_lv_nmos ad=0.1406p pd=1.12u as=0.1406p ps=1.12u w=0.74u l=0.13u
X2639 a_2505_16043# a_2148_16000# VDD VDD sg13_lv_pmos ad=63f pd=0.72u as=0.1563p ps=1.22u w=0.42u l=0.13u
X2640 a_14698_5380# a_15141_5423# a_14438_5850# GND.t80 sg13_lv_nmos ad=79.8f pd=0.8u as=0.1296p ps=1.52u w=0.42u l=0.13u
X2641 a_13403_8436# _157_.Y _158_.Y VDD sg13_lv_pmos ad=0.2128p pd=1.5u as=0.3808p ps=2.92u w=1.12u l=0.13u
X2642 a_2126_13912# _119_.A0 a_2298_13726# GND.t1419 sg13_lv_nmos ad=0.1628p pd=1.18u as=0.3367p ps=1.65u w=0.74u l=0.13u
X2643 a_13019_6460# _148_.X VDD VDD sg13_lv_pmos ad=0.3808p pd=2.92u as=0.2128p ps=1.5u w=1.12u l=0.13u
X2644 GND.t369 a_3380_13690# _247_.CLK GND.t46 sg13_lv_nmos ad=0.1406p pd=1.12u as=0.1406p ps=1.12u w=0.74u l=0.13u
X2645 VDD a_7727_4727# a_7984_4870# VDD sg13_lv_pmos ad=1.48542p pd=9.54u as=79.8f ps=0.8u w=0.42u l=0.13u
X2646 a_3108_5850# _244_.D a_3014_5850# GND.t83 sg13_lv_nmos ad=60.89999f pd=0.71u as=0.1428p ps=1.52u w=0.42u l=0.13u
X2647 GND.t160 _148_.X a_13121_6188# GND.t5 sg13_lv_nmos ad=0.2516p pd=2.16u as=0.1406p ps=1.12u w=0.74u l=0.13u
X2648 a_14820_9504# a_14794_9409# VDD VDD sg13_lv_pmos ad=0.34p pd=2.68u as=0.36237p ps=2.605u w=1u l=0.13u
X2649 GND.t1179 VDD GND.t1181 GND.t5 sg13_lv_nmos ad=79.8f pd=0.8u as=0 ps=0 w=0.42u l=1u
X2650 GND.t618 _191_.Y _193_.Y GND.t46 sg13_lv_nmos ad=0.2516p pd=2.16u as=0.1406p ps=1.12u w=0.74u l=0.13u
X2651 a_16079_8797# a_15237_8447# a_14820_8440# VDD sg13_lv_pmos ad=0.2048p pd=1.63u as=0.34p ps=2.68u w=1u l=0.13u
X2652 a_15237_9165# _260_.CLK VDD VDD sg13_lv_pmos ad=0.4088p pd=2.97u as=1.94845p ps=12.685u w=1.12u l=0.13u
X2653 VDD GND.t104 VDD VDD sg13_lv_pmos ad=0.34p pd=2.68u as=0 ps=0 w=1u l=1u
X2654 VDD GND.t307 VDD VDD sg13_lv_pmos ad=0.34p pd=2.68u as=0 ps=0 w=1u l=1u
X2655 a_8050_10326# _164_.Y GND.t139 GND.t499 sg13_lv_nmos ad=0.2516p pd=2.16u as=0.1406p ps=1.12u w=0.74u l=0.15u
X2656 a_14566_15247# _239_.Y GND.t270 GND.t311 sg13_lv_nmos ad=37.8f pd=0.6u as=0.1701p ps=1.65u w=0.42u l=0.13u
X2657 a_2565_12983# _247_.CLK VDD VDD sg13_lv_pmos ad=0.4088p pd=2.97u as=1.36162p ps=8.745u w=1.12u l=0.13u
X2658 GND.t345 VDD GND.t345 GND.t1100 sg13_lv_nmos ad=0.1428p pd=1.52u as=0 ps=0 w=0.42u l=1u
X2659 GND.t797 VDD GND.t794 GND.t833 sg13_lv_nmos ad=0.1428p pd=1.52u as=0 ps=0 w=0.42u l=1u
X2660 GND.t359 VDD GND.t359 GND.t358 sg13_lv_nmos ad=0.1428p pd=1.52u as=0 ps=0 w=0.42u l=1u
X2661 GND.t448 VDD GND.t485 GND.t46 sg13_lv_nmos ad=0.1428p pd=1.52u as=0 ps=0 w=0.42u l=1u
X2662 GND.t689 VDD GND.t689 GND.t737 sg13_lv_nmos ad=0.1428p pd=1.52u as=0 ps=0 w=0.42u l=1u
X2663 GND.t618 _192_.Y a_6958_13764# GND.t46 sg13_lv_nmos ad=0.17255p pd=1.25u as=0.187p ps=1.78u w=0.55u l=0.13u
X2664 VDD _240_.Y a_9734_17946# VDD sg13_lv_pmos ad=0.36237p pd=2.605u as=79.8f ps=0.8u w=0.42u l=0.13u
X2665 _207_.B1 a_4462_16052# GND.t50 GND.t14 sg13_lv_nmos ad=0.1406p pd=1.12u as=0.17255p ps=1.25u w=0.74u l=0.13u
X2666 GND.t337 _170_.Y a_8014_8492# GND.t21 sg13_lv_nmos ad=0.17255p pd=1.25u as=0.187p ps=1.78u w=0.55u l=0.13u
X2667 VDD GND.t792 VDD VDD sg13_lv_pmos ad=0.34p pd=2.68u as=0 ps=0 w=1u l=1u
X2668 VDD _148_.B a_8488_8436# VDD sg13_lv_pmos ad=0.2114p pd=1.54u as=0.2856p ps=2.36u w=0.84u l=0.13u
X2669 GND.t387 a_9424_16238# a_9073_16357# GND.t386 sg13_lv_nmos ad=79.8f pd=0.8u as=0.1428p ps=1.52u w=0.42u l=0.13u
X2670 GND.t264 VDD GND.t264 GND.t1141 sg13_lv_nmos ad=0.1428p pd=1.52u as=0 ps=0 w=0.42u l=1u
X2671 a_6124_9945# _174_.Y VDD VDD sg13_lv_pmos ad=0.1596p pd=1.22u as=0.1596p ps=1.22u w=0.84u l=0.13u
X2672 GND.t792 VDD GND.t794 GND.t793 sg13_lv_nmos ad=79.8f pd=0.8u as=0 ps=0 w=0.42u l=1u
X2673 a_4114_8874# _218_.Y GND.t450 GND.t21 sg13_lv_nmos ad=37.8f pd=0.6u as=79.8f ps=0.8u w=0.42u l=0.13u
X2674 GND.t697 VDD GND.t697 GND.t743 sg13_lv_nmos ad=0.1428p pd=1.52u as=0 ps=0 w=0.42u l=1u
X2675 a_8649_17137# a_8292_17064# VDD VDD sg13_lv_pmos ad=63f pd=0.72u as=0.1563p ps=1.22u w=0.42u l=0.13u
X2676 a_3407_16823# a_2565_16725# a_2148_17064# VDD sg13_lv_pmos ad=0.2048p pd=1.63u as=0.34p ps=2.68u w=1u l=0.13u
X2677 _247_.CLK a_3380_13690# VDD VDD sg13_lv_pmos ad=0.2128p pd=1.5u as=0.2128p ps=1.5u w=1.12u l=0.13u
X2678 VDD GND.t1000 VDD VDD sg13_lv_pmos ad=0.34p pd=2.68u as=0 ps=0 w=1u l=1u
X2679 a_2558_9972# _173_.A a_2126_10214# VDD sg13_lv_pmos ad=0.3325p pd=1.665u as=0.2225p ps=1.445u w=1u l=0.13u
X2680 a_8518_16759# _259_.RESET_B GND.t261 GND.t260 sg13_lv_nmos ad=37.8f pd=0.6u as=0.1701p ps=1.65u w=0.42u l=0.13u
X2681 VDD GND.t221 VDD VDD sg13_lv_pmos ad=0.34p pd=2.68u as=0 ps=0 w=1u l=1u
X2682 GND.t867 VDD GND.t495 GND.t866 sg13_lv_nmos ad=0.1428p pd=1.52u as=0 ps=0 w=0.42u l=1u
X2683 VDD GND.t345 VDD VDD sg13_lv_pmos ad=0.19p pd=1.38u as=0 ps=0 w=1u l=1u
X2684 GND.t160 _157_.B a_13073_5770# GND.t5 sg13_lv_nmos ad=0.15245p pd=1.17u as=0.17462p ps=1.185u w=0.55u l=0.13u
X2685 _139_.X a_10769_4258# a_10940_3900# VDD sg13_lv_pmos ad=0.3808p pd=2.92u as=0.2128p ps=1.5u w=1.12u l=0.13u
X2686 a_2398_5782# _210_.A a_2301_5436# VDD sg13_lv_pmos ad=0.2225p pd=1.445u as=0.3325p ps=1.665u w=1u l=0.13u
X2687 a_5376_17061# _207_.A2 a_5339_16792# GND.t14 sg13_lv_nmos ad=0.2176p pd=1.96u as=78.39999f ps=0.885u w=0.64u l=0.13u
X2688 GND.t106 a_13648_12430# a_13297_12287# GND.t112 sg13_lv_nmos ad=79.8f pd=0.8u as=0.1428p ps=1.52u w=0.42u l=0.13u
X2689 GND.t764 VDD GND.t763 GND.t14 sg13_lv_nmos ad=0.1428p pd=1.52u as=0 ps=0 w=0.42u l=1u
X2690 a_8265_16043# a_7908_16000# VDD VDD sg13_lv_pmos ad=63f pd=0.72u as=0.1563p ps=1.22u w=0.42u l=0.13u
X2691 a_10769_4258# _243_.Q GND.t644 GND.t643 sg13_lv_nmos ad=0.17462p pd=1.185u as=0.374p ps=2.46u w=0.55u l=0.13u
X2692 GND.t5 _124_.S a_2171_6204# GND.t83 sg13_lv_nmos ad=0.18945p pd=1.27u as=0.187p ps=1.78u w=0.55u l=0.13u
X2693 _256_.RESET_B _236_.A VDD VDD sg13_lv_pmos ad=0.3808p pd=2.92u as=0.3808p ps=2.92u w=1.12u l=0.13u
X2694 GND.t1000 VDD GND.t1000 GND.t1038 sg13_lv_nmos ad=79.8f pd=0.8u as=0 ps=0 w=0.42u l=1u
X2695 VDD GND.t1168 VDD VDD sg13_lv_pmos ad=0.34p pd=2.68u as=0 ps=0 w=1u l=1u
X2696 _207_.A1 a_9834_15996# VDD VDD sg13_lv_pmos ad=0.3808p pd=2.92u as=0.2128p ps=1.5u w=1.12u l=0.13u
X2697 VDD GND.t819 VDD VDD sg13_lv_pmos ad=0.34p pd=2.68u as=0 ps=0 w=1u l=1u
X2698 a_3380_13690# clkbuf_1_0__f_sclk.A GND.t273 GND.t46 sg13_lv_nmos ad=0.1406p pd=1.12u as=0.1406p ps=1.12u w=0.74u l=0.13u
X2699 VDD _148_.A a_12572_4948# VDD sg13_lv_pmos ad=0.2128p pd=1.5u as=0.3808p ps=2.92u w=1.12u l=0.13u
X2700 VDD GND.t819 VDD VDD sg13_lv_pmos ad=0.34p pd=2.68u as=0 ps=0 w=1u l=1u
X2701 VDD _239_.Y a_14314_15457# VDD sg13_lv_pmos ad=0.1563p pd=1.22u as=0.147p ps=1.54u w=0.42u l=0.13u
X2702 a_6779_12972# _192_.C _191_.Y VDD sg13_lv_pmos ad=0.2128p pd=1.5u as=0.3808p ps=2.92u w=1.12u l=0.13u
X2703 VDD GND.t190 VDD VDD sg13_lv_pmos ad=0.19p pd=1.38u as=0 ps=0 w=1u l=1u
X2704 GND.t59 a_14240_16921# _135_.A GND.t209 sg13_lv_nmos ad=0.1406p pd=1.12u as=0.2516p ps=2.16u w=0.74u l=0.13u
X2705 GND.t800 VDD GND.t803 GND.t850 sg13_lv_nmos ad=79.8f pd=0.8u as=0 ps=0 w=0.42u l=1u
X2706 a_7157_9948# _171_.A VDD VDD sg13_lv_pmos ad=0.2128p pd=1.5u as=0.2128p ps=1.5u w=1.12u l=0.13u
X2707 VDD a_2126_10214# _246_.D VDD sg13_lv_pmos ad=0.2198p pd=1.52u as=0.6048p ps=3.32u w=1.12u l=0.13u
X2708 GND.t1176 VDD GND.t229 GND.t5 sg13_lv_nmos ad=0.1428p pd=1.52u as=0 ps=0 w=0.42u l=1u
X2709 a_12369_4972# _148_.A VDD VDD sg13_lv_pmos ad=0.1225p pd=1.245u as=0.36p ps=2.72u w=1u l=0.13u
X2710 a_14794_9409# a_15237_9165# a_15177_9577# VDD sg13_lv_pmos ad=79.8f pd=0.8u as=63f ps=0.72u w=0.42u l=0.13u
X2711 VDD GND.t345 VDD VDD sg13_lv_pmos ad=0.34p pd=2.68u as=0 ps=0 w=1u l=1u
X2712 VDD clkbuf_1_0__f_sclk.A a_3956_6888# VDD sg13_lv_pmos ad=0.2128p pd=1.5u as=0.2128p ps=1.5u w=1.12u l=0.13u
X2713 GND.t7 a_4816_4870# a_4465_4727# GND.t17 sg13_lv_nmos ad=79.8f pd=0.8u as=0.1428p ps=1.52u w=0.42u l=0.13u
X2714 VDD GND.t800 VDD VDD sg13_lv_pmos ad=0.19p pd=1.38u as=0 ps=0 w=1u l=1u
X2715 GND.t354 VDD GND.t1230 GND.t1229 sg13_lv_nmos ad=0.1428p pd=1.52u as=0 ps=0 w=0.42u l=1u
X2716 VDD GND.t787 VDD VDD sg13_lv_pmos ad=0.34p pd=2.68u as=0 ps=0 w=1u l=1u
X2717 VDD GND.t1103 VDD VDD sg13_lv_pmos ad=0.19p pd=1.38u as=0 ps=0 w=1u l=1u
X2718 a_8050_10326# _185_.Y _186_.Y GND.t504 sg13_lv_nmos ad=0.1406p pd=1.12u as=0.2516p ps=2.16u w=0.74u l=0.15u
X2719 a_15861_16904# a_14919_16964# a_15767_17137# VDD sg13_lv_pmos ad=79.8f pd=0.8u as=0.1428p ps=1.52u w=0.42u l=0.13u
X2720 a_10752_7989# _166_.A VDD VDD sg13_lv_pmos ad=0.1596p pd=1.22u as=0.4536p ps=2.76u w=0.84u l=0.13u
X2721 GND.t689 VDD GND.t693 GND.t692 sg13_lv_nmos ad=79.8f pd=0.8u as=0 ps=0 w=0.42u l=1u
X2722 VDD _192_.Y a_6958_13764# VDD sg13_lv_pmos ad=0.2618p pd=1.63u as=0.2856p ps=2.36u w=0.84u l=0.13u
X2723 a_6106_9190# _168_.B GND.t1074 GND.t21 sg13_lv_nmos ad=0.1406p pd=1.12u as=0.2516p ps=2.16u w=0.74u l=0.13u
X2724 GND.t100 VDD GND.t100 GND.t984 sg13_lv_nmos ad=79.8f pd=0.8u as=0 ps=0 w=0.42u l=1u
X2725 VDD GND.t470 VDD VDD sg13_lv_pmos ad=0.19p pd=1.38u as=0 ps=0 w=1u l=1u
X2726 a_2853_8447# _243_.CLK VDD VDD sg13_lv_pmos ad=0.4088p pd=2.97u as=2.75005p ps=18.05u w=1.12u l=0.13u
X2727 _176_.B _148_.B a_5562_12226# GND.t1544 sg13_lv_nmos ad=0.1628p pd=1.18u as=88.8f ps=0.98u w=0.74u l=0.13u
X2728 a_2558_11484# _120_.A0 a_2126_11726# VDD sg13_lv_pmos ad=0.3325p pd=1.665u as=0.2225p ps=1.445u w=1u l=0.13u
X2729 a_12923_11460# _126_.B1 _126_.Y VDD sg13_lv_pmos ad=0.2128p pd=1.5u as=0.3808p ps=2.92u w=1.12u l=0.13u
X2730 GND.t1221 VDD GND.t1221 GND.t1220 sg13_lv_nmos ad=0.1428p pd=1.52u as=0 ps=0 w=0.42u l=1u
X2731 a_3956_6888# clkbuf_1_0__f_sclk.A VDD VDD sg13_lv_pmos ad=0.2128p pd=1.5u as=0.2128p ps=1.5u w=1.12u l=0.13u
X2732 a_11220_5760# _139_.X a_10764_5678# GND.t5 sg13_lv_nmos ad=78.39999f pd=0.885u as=0.2176p ps=1.96u w=0.64u l=0.13u
X2733 a_12401_4704# _148_.A GND.t1247 GND.t1586 sg13_lv_nmos ad=0.17462p pd=1.185u as=0.374p ps=2.46u w=0.55u l=0.13u
X2734 a_2662_8861# _218_.Y GND.t356 GND.t449 sg13_lv_nmos ad=37.8f pd=0.6u as=0.1701p ps=1.65u w=0.42u l=0.13u
X2735 GND.t404 VDD GND.t404 GND.t961 sg13_lv_nmos ad=79.8f pd=0.8u as=0 ps=0 w=0.42u l=1u
X2736 VDD GND.t77 VDD VDD sg13_lv_pmos ad=0.19p pd=1.38u as=0 ps=0 w=1u l=1u
X2737 VDD GND.t108 VDD VDD sg13_lv_pmos ad=0.19p pd=1.38u as=0 ps=0 w=1u l=1u
X2738 VDD GND.t1094 VDD VDD sg13_lv_pmos ad=0.34p pd=2.68u as=0 ps=0 w=1u l=1u
X2739 a_16336_8678# a_16079_8797# a_16498_8874# GND.t72 sg13_lv_nmos ad=0.1428p pd=1.52u as=37.8f ps=0.6u w=0.42u l=0.13u
X2740 GND.t718 VDD GND.t718 GND.t158 sg13_lv_nmos ad=79.8f pd=0.8u as=0 ps=0 w=0.42u l=1u
X2741 a_9513_12601# a_9156_12528# VDD VDD sg13_lv_pmos ad=63f pd=0.72u as=0.1563p ps=1.22u w=0.42u l=0.13u
X2742 _200_.Y _195_.Y VDD VDD sg13_lv_pmos ad=0.3808p pd=2.92u as=0.2128p ps=1.5u w=1.12u l=0.13u
X2743 a_2532_12223# a_2763_12332# a_2218_12433# GND.t62 sg13_lv_nmos ad=0.2373p pd=1.97u as=79.8f ps=0.8u w=0.42u l=0.13u
X2744 VDD _230_.Y a_9130_13945# VDD sg13_lv_pmos ad=0.1563p pd=1.22u as=0.147p ps=1.54u w=0.42u l=0.13u
X2745 a_2494_6166# _243_.Q a_2397_6166# GND.t83 sg13_lv_nmos ad=0.1628p pd=1.18u as=0.13135p ps=1.095u w=0.74u l=0.13u
X2746 VDD GND.t90 VDD VDD sg13_lv_pmos ad=0.19p pd=1.38u as=0 ps=0 w=1u l=1u
X2747 a_9828_9186# _172_.Y a_9734_9186# GND.t21 sg13_lv_nmos ad=60.89999f pd=0.71u as=0.1428p ps=1.52u w=0.42u l=0.13u
X2748 VDD GND.t214 VDD VDD sg13_lv_pmos ad=0.34p pd=2.68u as=0 ps=0 w=1u l=1u
X2749 GND.t726 VDD GND.t726 GND.t712 sg13_lv_nmos ad=79.8f pd=0.8u as=0 ps=0 w=0.42u l=1u
X2750 VDD GND.t792 VDD VDD sg13_lv_pmos ad=0.19p pd=1.38u as=0 ps=0 w=1u l=1u
X2751 GND.t465 rst a_1192_17508# GND.t1394 sg13_lv_nmos ad=0.14875p pd=1.16u as=0.187p ps=1.78u w=0.55u l=0.13u
X2752 VDD GND.t693 VDD VDD sg13_lv_pmos ad=0.34p pd=2.68u as=0 ps=0 w=1u l=1u
X2753 GND.t198 VDD GND.t198 GND.t989 sg13_lv_nmos ad=0.1428p pd=1.52u as=0 ps=0 w=0.42u l=1u
X2754 VDD _168_.A _174_.Y VDD sg13_lv_pmos ad=0.3808p pd=2.92u as=0.2128p ps=1.5u w=1.12u l=0.13u
X2755 VDD GND.t264 VDD VDD sg13_lv_pmos ad=0.34p pd=2.68u as=0 ps=0 w=1u l=1u
X2756 a_2410_8404# a_2853_8447# a_2793_8483# VDD sg13_lv_pmos ad=79.8f pd=0.8u as=63f ps=0.72u w=0.42u l=0.13u
X2757 VDD GND.t901 VDD VDD sg13_lv_pmos ad=0.34p pd=2.68u as=0 ps=0 w=1u l=1u
X2758 VDD a_4559_4727# a_5226_4948# VDD sg13_lv_pmos ad=0.2128p pd=1.5u as=0.3864p ps=2.93u w=1.12u l=0.13u
X2759 _193_.Y _191_.Y a_7180_14020# VDD sg13_lv_pmos ad=0.3808p pd=2.92u as=0.1176p ps=1.33u w=1.12u l=0.13u
X2760 VDD GND.t701 VDD VDD sg13_lv_pmos ad=0.19p pd=1.38u as=0 ps=0 w=1u l=1u
X2761 _194_.X a_7985_13776# a_8156_14020# VDD sg13_lv_pmos ad=0.3808p pd=2.92u as=0.2128p ps=1.5u w=1.12u l=0.13u
X2762 a_2148_12976# a_2122_12940# VDD VDD sg13_lv_pmos ad=0.34p pd=2.68u as=0.36237p ps=2.605u w=1u l=0.13u
X2763 GND.t169 _160_.X a_10989_8784# GND.t339 sg13_lv_nmos ad=0.1406p pd=1.12u as=0.1406p ps=1.12u w=0.74u l=0.13u
X2764 a_14724_5416# a_14698_5380# VDD VDD sg13_lv_pmos ad=0.34p pd=2.68u as=0.36237p ps=2.605u w=1u l=0.13u
X2765 a_15141_5423# _251_.CLK GND.t5 GND.t1550 sg13_lv_nmos ad=0.2516p pd=2.16u as=7.07497p ps=46.475u w=0.74u l=0.13u
X2766 a_11364_17064# a_11338_16969# VDD VDD sg13_lv_pmos ad=0.34p pd=2.68u as=0.36237p ps=2.605u w=1u l=0.13u
X2767 _252_.D _145_.A2 a_8115_5412# VDD sg13_lv_pmos ad=0.2408p pd=1.55u as=0.1428p ps=1.375u w=1.12u l=0.13u
X2768 VDD a_13824_7989# _159_.Y VDD sg13_lv_pmos ad=0.3808p pd=2.92u as=0.2408p ps=1.55u w=1.12u l=0.13u
X2769 GND.t121 VDD GND.t121 GND.t712 sg13_lv_nmos ad=0.1428p pd=1.52u as=0 ps=0 w=0.42u l=1u
X2770 GND.t345 VDD GND.t345 GND.t1101 sg13_lv_nmos ad=79.8f pd=0.8u as=0 ps=0 w=0.42u l=1u
X2771 a_2150_8874# _122_.X VDD VDD sg13_lv_pmos ad=79.8f pd=0.8u as=0.1428p ps=1.52u w=0.42u l=0.13u
X2772 a_12518_16434# a_13323_16007# a_12778_15964# VDD sg13_lv_pmos ad=0.1428p pd=1.52u as=79.8f ps=0.8u w=0.42u l=0.13u
X2773 a_9156_14040# a_9130_13945# GND.t321 GND.t320 sg13_lv_nmos ad=0.2516p pd=2.16u as=0.1626p ps=1.415u w=0.74u l=0.13u
X2774 GND.t79 a_10864_4870# a_10513_4727# GND.t488 sg13_lv_nmos ad=79.8f pd=0.8u as=0.1428p ps=1.52u w=0.42u l=0.13u
X2775 _243_.CLK a_3956_6888# VDD VDD sg13_lv_pmos ad=0.2128p pd=1.5u as=0.2128p ps=1.5u w=1.12u l=0.13u
X2776 a_2301_5436# _124_.S VDD VDD sg13_lv_pmos ad=0.3325p pd=1.665u as=0.253p ps=1.53u w=1u l=0.13u
X2777 VDD GND.t1006 VDD VDD sg13_lv_pmos ad=0.19p pd=1.38u as=0 ps=0 w=1u l=1u
X2778 VDD GND.t726 VDD VDD sg13_lv_pmos ad=0.34p pd=2.68u as=0 ps=0 w=1u l=1u
X2779 a_10834_12210# _256_.RESET_B GND.t131 GND.t405 sg13_lv_nmos ad=37.8f pd=0.6u as=79.8f ps=0.8u w=0.42u l=0.13u
X2780 GND.t116 _186_.Y a_7168_15260# GND.t1524 sg13_lv_nmos ad=0.1406p pd=1.12u as=0.1406p ps=1.12u w=0.74u l=0.13u
X2781 GND.t845 VDD GND.t114 GND.t844 sg13_lv_nmos ad=0.1428p pd=1.52u as=0 ps=0 w=0.42u l=1u
X2782 a_9753_17061# a_8811_16868# a_9551_16823# VDD sg13_lv_pmos ad=93.45f pd=0.865u as=0.2048p ps=1.63u w=0.42u l=0.13u
X2783 a_4816_4870# a_4559_4727# a_4978_4650# GND.t398 sg13_lv_nmos ad=0.1428p pd=1.52u as=37.8f ps=0.6u w=0.42u l=0.13u
X2784 VDD GND.t229 VDD VDD sg13_lv_pmos ad=0.19p pd=1.38u as=0 ps=0 w=1u l=1u
X2785 a_10437_9165# _251_.CLK GND.t21 GND.t1554 sg13_lv_nmos ad=0.2516p pd=2.16u as=3.59495p ps=22.57u w=0.74u l=0.13u
X2786 a_8266_16969# a_8709_16725# a_8006_16746# GND.t92 sg13_lv_nmos ad=79.8f pd=0.8u as=0.1296p ps=1.52u w=0.42u l=0.13u
X2787 VDD a_3407_16823# a_4074_17044# VDD sg13_lv_pmos ad=0.2128p pd=1.5u as=0.3864p ps=2.93u w=1.12u l=0.13u
X2788 a_3526_4663# _242_.RESET_B GND.t1 GND.t299 sg13_lv_nmos ad=37.8f pd=0.6u as=0.1701p ps=1.65u w=0.42u l=0.13u
X2789 _122_.A0 a_4362_8436# GND.t48 GND.t21 sg13_lv_nmos ad=0.2516p pd=2.16u as=0.1406p ps=1.12u w=0.74u l=0.13u
X2790 GND.t108 VDD GND.t108 GND.t892 sg13_lv_nmos ad=79.8f pd=0.8u as=0 ps=0 w=0.42u l=1u
X2791 VDD _122_.A0 a_8156_7972# VDD sg13_lv_pmos ad=0.2128p pd=1.5u as=0.3808p ps=2.92u w=1.12u l=0.13u
X2792 GND.t871 VDD GND.t870 GND.t869 sg13_lv_nmos ad=0.1428p pd=1.52u as=0 ps=0 w=0.42u l=1u
X2793 GND.t1194 VDD GND.t1194 GND.t1195 sg13_lv_nmos ad=0.1428p pd=1.52u as=0 ps=0 w=0.42u l=1u
X2794 VDD GND.t33 VDD VDD sg13_lv_pmos ad=0.34p pd=2.68u as=0 ps=0 w=1u l=1u
X2795 a_12237_5760# _148_.A VDD VDD sg13_lv_pmos ad=0.1596p pd=1.22u as=0.2856p ps=2.36u w=0.84u l=0.13u
X2796 GND.t514 VDD GND.t778 GND.t596 sg13_lv_nmos ad=0.1428p pd=1.52u as=0 ps=0 w=0.42u l=1u
X2797 GND.t911 VDD GND.t625 GND.t46 sg13_lv_nmos ad=0.1428p pd=1.52u as=0 ps=0 w=0.42u l=1u
X2798 a_11698_9186# _228_.Y GND.t169 GND.t168 sg13_lv_nmos ad=37.8f pd=0.6u as=79.8f ps=0.8u w=0.42u l=0.13u
X2799 a_3952_9406# _219_.Y VDD VDD sg13_lv_pmos ad=79.8f pd=0.8u as=1.94845p ps=12.685u w=0.42u l=0.13u
X2800 VDD _250_.RESET_B a_1862_16434# VDD sg13_lv_pmos ad=0.36237p pd=2.605u as=79.8f ps=0.8u w=0.42u l=0.13u
X2801 VDD GND.t397 VDD VDD sg13_lv_pmos ad=0.19p pd=1.38u as=0 ps=0 w=1u l=1u
X2802 a_8352_11013# _181_.Y a_8315_10744# GND.t574 sg13_lv_nmos ad=0.2176p pd=1.96u as=78.39999f ps=0.885u w=0.64u l=0.13u
X2803 a_2575_4948# _210_.A a_2398_4654# VDD sg13_lv_pmos ad=0.2975p pd=1.595u as=0.2225p ps=1.445u w=1u l=0.13u
X2804 VDD _224_.Y a_6182_4650# VDD sg13_lv_pmos ad=0.36237p pd=2.605u as=79.8f ps=0.8u w=0.42u l=0.13u
X2805 VDD GND.t557 VDD VDD sg13_lv_pmos ad=0.34p pd=2.68u as=0 ps=0 w=1u l=1u
X2806 VDD GND.t77 VDD VDD sg13_lv_pmos ad=0.34p pd=2.68u as=0 ps=0 w=1u l=1u
X2807 GND.t190 VDD GND.t190 GND.t945 sg13_lv_nmos ad=79.8f pd=0.8u as=0 ps=0 w=0.42u l=1u
X2808 VDD GND.t1168 VDD VDD sg13_lv_pmos ad=0.19p pd=1.38u as=0 ps=0 w=1u l=1u
X2809 a_1956_16746# _118_.X a_1862_16746# GND.t601 sg13_lv_nmos ad=60.89999f pd=0.71u as=0.1428p ps=1.52u w=0.42u l=0.13u
X2810 GND.t879 VDD GND.t247 GND.t878 sg13_lv_nmos ad=0.1428p pd=1.52u as=0 ps=0 w=0.42u l=1u
X2811 GND.t133 _221_.Y a_1956_13410# GND.t545 sg13_lv_nmos ad=0.1626p pd=1.415u as=60.89999f ps=0.71u w=0.42u l=0.13u
X2812 _166_.A a_16746_8436# VDD VDD sg13_lv_pmos ad=0.3808p pd=2.92u as=0.2128p ps=1.5u w=1.12u l=0.13u
X2813 a_2505_13019# a_2148_12976# VDD VDD sg13_lv_pmos ad=63f pd=0.72u as=0.1563p ps=1.22u w=0.42u l=0.13u
X2814 _243_.D a_2398_4654# GND.t119 GND.t646 sg13_lv_nmos ad=0.4033p pd=2.57u as=0.148p ps=1.14u w=0.74u l=0.13u
X2815 VDD GND.t307 VDD VDD sg13_lv_pmos ad=0.34p pd=2.68u as=0 ps=0 w=1u l=1u
X2816 _131_.B1 _260_.CLK a_14357_12972# VDD sg13_lv_pmos ad=0.3808p pd=2.92u as=0.2128p ps=1.5u w=1.12u l=0.13u
X2817 _205_.Y _199_.Y a_7074_15532# VDD sg13_lv_pmos ad=0.3808p pd=2.92u as=0.2128p ps=1.5u w=1.12u l=0.13u
X2818 GND.t100 VDD GND.t100 GND.t984 sg13_lv_nmos ad=79.8f pd=0.8u as=0 ps=0 w=0.42u l=1u
X2819 GND.t803 VDD GND.t806 GND.t852 sg13_lv_nmos ad=79.8f pd=0.8u as=0 ps=0 w=0.42u l=1u
X2820 GND.t1235 VDD GND.t400 GND.t1236 sg13_lv_nmos ad=79.8f pd=0.8u as=0 ps=0 w=0.42u l=1u
X2821 VDD GND.t89 VDD VDD sg13_lv_pmos ad=0.34p pd=2.68u as=0 ps=0 w=1u l=1u
X2822 VDD a_13184_7183# _160_.X VDD sg13_lv_pmos ad=0.1918p pd=1.5u as=0.3808p ps=2.92u w=1.12u l=0.13u
X2823 _186_.Y _185_.Y VDD VDD sg13_lv_pmos ad=0.2128p pd=1.5u as=0.3808p ps=2.92u w=1.12u l=0.15u
X2824 GND.t77 VDD GND.t77 GND.t1046 sg13_lv_nmos ad=79.8f pd=0.8u as=0 ps=0 w=0.42u l=1u
X2825 a_12132_12528# a_12106_12433# GND.t146 GND.t145 sg13_lv_nmos ad=0.2516p pd=2.16u as=0.1626p ps=1.415u w=0.74u l=0.13u
X2826 GND.t1068 VDD GND.t1068 GND.t1067 sg13_lv_nmos ad=0.1428p pd=1.52u as=0 ps=0 w=0.42u l=1u
X2827 GND.t264 VDD GND.t264 GND.t1105 sg13_lv_nmos ad=0.1428p pd=1.52u as=0 ps=0 w=0.42u l=1u
X2828 VDD GND.t767 VDD VDD sg13_lv_pmos ad=0.34p pd=2.68u as=0 ps=0 w=1u l=1u
X2829 VDD GND.t1189 VDD VDD sg13_lv_pmos ad=0.19p pd=1.38u as=0 ps=0 w=1u l=1u
X2830 GND.t51 fanout6.A _207_.B1 GND.t14 sg13_lv_nmos ad=0.2516p pd=2.16u as=0.1406p ps=1.12u w=0.74u l=0.13u
X2831 a_5906_15242# _199_.B1 GND.t493 GND.t492 sg13_lv_nmos ad=0.1406p pd=1.12u as=0.2886p ps=2.26u w=0.74u l=0.13u
X2832 _247_.CLK a_3380_13690# GND.t366 GND.t46 sg13_lv_nmos ad=0.1406p pd=1.12u as=0.2516p ps=2.16u w=0.74u l=0.13u
X2833 a_7908_16000# a_7882_15964# GND.t261 GND.t326 sg13_lv_nmos ad=0.2516p pd=2.16u as=0.1626p ps=1.415u w=0.74u l=0.13u
X2834 _173_.A a_4362_9484# GND.t48 GND.t21 sg13_lv_nmos ad=0.2516p pd=2.16u as=0.1406p ps=1.12u w=0.74u l=0.13u
X2835 GND.t256 _176_.A a_6485_11830# GND.t1459 sg13_lv_nmos ad=0.1898p pd=1.36u as=0.2516p ps=2.16u w=0.74u l=0.13u
X2836 a_9586_16434# _258_.RESET_B GND.t387 GND.t386 sg13_lv_nmos ad=37.8f pd=0.6u as=79.8f ps=0.8u w=0.42u l=0.13u
X2837 VDD GND.t1068 VDD VDD sg13_lv_pmos ad=0.34p pd=2.68u as=0 ps=0 w=1u l=1u
X2838 VDD GND.t7 VDD VDD sg13_lv_pmos ad=0.34p pd=2.68u as=0 ps=0 w=1u l=1u
X2839 VDD GND.t256 VDD VDD sg13_lv_pmos ad=0.34p pd=2.68u as=0 ps=0 w=1u l=1u
X2840 GND.t188 a_2126_7864# _122_.X GND.t1549 sg13_lv_nmos ad=0.148p pd=1.14u as=0.4033p ps=2.57u w=0.74u l=0.13u
X2841 GND.t100 VDD GND.t198 GND.t986 sg13_lv_nmos ad=79.8f pd=0.8u as=0 ps=0 w=0.42u l=1u
X2842 VDD GND.t897 VDD VDD sg13_lv_pmos ad=0.19p pd=1.38u as=0 ps=0 w=1u l=1u
X2843 VDD a_15983_12287# a_16240_12430# VDD sg13_lv_pmos ad=1.42082p pd=9.125u as=79.8f ps=0.8u w=0.42u l=0.13u
X2844 VDD a_16336_11702# a_16281_11583# VDD sg13_lv_pmos ad=5.15485p pd=34.14u as=93.45f ps=0.865u w=0.42u l=0.13u
X2845 GND.t441 VDD GND.t441 GND.t929 sg13_lv_nmos ad=0.1428p pd=1.52u as=0 ps=0 w=0.42u l=1u
X2846 GND.t1267 VDD GND.t1269 GND.t1268 sg13_lv_nmos ad=79.8f pd=0.8u as=0 ps=0 w=0.42u l=1u
X2847 VDD a_10607_4727# a_11274_4948# VDD sg13_lv_pmos ad=0.2128p pd=1.5u as=0.3864p ps=2.93u w=1.12u l=0.13u
X2848 VDD GND.t1094 VDD VDD sg13_lv_pmos ad=0.34p pd=2.68u as=0 ps=0 w=1u l=1u
X2849 a_9083_9232# _164_.Y GND.t89 GND.t21 sg13_lv_nmos ad=78.39999f pd=0.885u as=0.2272p ps=1.99u w=0.64u l=0.13u
X2850 clkbuf_1_0__f_sclk.A a_3886_10702# GND.t1027 GND.t1453 sg13_lv_nmos ad=0.1406p pd=1.12u as=0.1406p ps=1.12u w=0.74u l=0.13u
X2851 VDD GND.t139 VDD VDD sg13_lv_pmos ad=0.19p pd=1.38u as=0 ps=0 w=1u l=1u
C0 _211_.Y _264_.Q 0.05932f
C1 a_14240_16921# _135_.A 0.07035f
C2 a_9994_9409# _168_.A 0.01749f
C3 a_17120_13854# VDD 0.08082f
C4 a_9675_13844# a_10415_13799# 0.15395f
C5 _148_.A VDD 2.19362f
C6 _205_.Y _202_.Y 0.04521f
C7 _183_.Y a_8050_10326# 0.0689f
C8 _226_.Y a_15243_5423# 0.21798f
C9 _210_.B a_6468_4968# 0.04991f
C10 a_15339_8447# a_16336_8678# 0.01569f
C11 a_15237_8447# a_15985_8797# 0.01058f
C12 _138_.Y _145_.B1 0.11085f
C13 _136_.B a_8557_4248# 0.02897f
C14 fanout8.A _124_.S 0.03098f
C15 _179_.Y a_6890_9948# 0.01451f
C16 a_8292_17064# fanout7.A 0.06859f
C17 a_8709_16725# a_8811_16868# 0.26919f
C18 _171_.Y a_9120_9501# 0.20153f
C19 a_3300_4968# a_3819_4772# 0.18372f
C20 _196_.Y _191_.Y 0.02219f
C21 _214_.Y _214_.A 0.29841f
C22 _166_.A a_10901_7678# 0.0134f
C23 _131_.B1 a_14698_12433# 0.01443f
C24 _207_.A1 _199_.B1 0.07144f
C25 _225_.A _239_.Y 0.16677f
C26 _148_.A a_4559_5773# 0.01389f
C27 fanout6.A _214_.Y 0.02718f
C28 fanout7.A a_16746_9484# 0.13656f
C29 a_16336_11702# VDD 0.12596f
C30 _133_.Y a_12549_12189# 0.02571f
C31 a_9928_18390# VDD 0.1419f
C32 _258_.RESET_B VDD 1.01373f
C33 _181_.Y _171_.Y 0.32866f
C34 a_2410_8404# a_2436_8440# 0.21121f
C35 _207_.A1 _195_.Y 0.01048f
C36 a_11731_8698# VDD 0.22809f
C37 fanout6.A a_4796_17044# 0.01505f
C38 _246_.D a_1864_10034# 0.02599f
C39 _208_.X VDD 0.3094f
C40 a_9734_9186# _251_.CLK 0.05469f
C41 a_14940_16710# a_15767_17137# 0.21832f
C42 _189_.X a_5084_12972# 0.05461f
C43 _148_.A a_12237_5760# 0.12218f
C44 a_1580_12936# _221_.Y 0.01298f
C45 a_10539_17519# a_11279_17869# 0.15395f
C46 a_9867_4772# a_10864_4870# 0.01528f
C47 _148_.B _186_.Y 0.10458f
C48 _251_.CLK _252_.RESET_B 0.10591f
C49 _145_.X a_10989_8784# 0.02466f
C50 _131_.A2 _129_.B1 0.16439f
C51 _133_.Y _260_.CLK 0.01412f
C52 _151_.B _157_.B 0.24614f
C53 _148_.X a_12712_5498# 0.01856f
C54 a_11082_14020# VDD 0.24152f
C55 a_8870_13722# a_9573_13701# 0.02454f
C56 _226_.Y a_14698_5380# 0.15281f
C57 _118_.A0 a_4661_17878# 0.0116f
C58 a_1192_17508# rst 0.16549f
C59 a_13648_12430# _129_.Y 0.02377f
C60 a_14063_16357# a_14730_15996# 0.06982f
C61 a_14534_8874# a_15339_8447# 0.06896f
C62 a_14820_8440# a_15237_8447# 0.22698f
C63 _119_.A0 _120_.A0 0.44989f
C64 _161_.Y _166_.A 0.0201f
C65 _236_.A _194_.X 0.08339f
C66 _247_.CLK a_2565_12983# 0.18302f
C67 a_2126_10214# a_2298_9972# 0.01057f
C68 _243_.CLK a_3588_4663# 0.0214f
C69 _138_.Y _252_.D 0.07554f
C70 a_9994_9409# VDD 0.09769f
C71 _138_.Y a_9322_4873# 0.01009f
C72 _202_.Y a_7251_15996# 0.01244f
C73 _151_.B _151_.X 0.03108f
C74 a_16240_12430# a_16650_12508# 0.05221f
C75 _124_.S a_2126_10214# 0.0897f
C76 _215_.A a_3274_5380# 0.01229f
C77 _207_.A1 a_6720_17061# 0.01053f
C78 _139_.X a_10940_3900# 0.05357f
C79 _185_.Y a_8050_10326# 0.02286f
C80 _148_.A a_3300_5416# 0.01468f
C81 a_7953_14044# VDD 0.01063f
C82 a_15237_11471# VDD 0.24134f
C83 a_2436_16421# a_2667_16007# 0.06628f
C84 _145_.A2 a_8288_3986# 0.01157f
C85 _250_.Q VDD 0.51552f
C86 _138_.Y _143_.Y 0.02246f
C87 _225_.A a_13290_17044# 0.01401f
C88 _199_.B1 _195_.Y 0.07583f
C89 _136_.B _145_.B1 0.01846f
C90 _168_.A VDD 0.87017f
C91 _178_.B1 a_6389_9484# 0.03242f
C92 _157_.Y a_13403_8436# 0.01024f
C93 _171_.Y _180_.X 0.44758f
C94 fanout7.A a_9834_15996# 0.02424f
C95 _148_.B _164_.Y 0.0831f
C96 _171_.A _170_.B 0.03384f
C97 a_16840_4688# VDD 0.19241f
C98 _131_.A2 a_13985_11808# 0.01181f
C99 a_14820_9504# a_15108_9199# 0.22255f
C100 a_9062_4650# a_9867_4772# 0.06896f
C101 a_9348_4968# a_9765_4629# 0.22605f
C102 _182_.Y a_8352_11013# 0.11233f
C103 _160_.X _145_.X 1.40732f
C104 a_11536_17750# VDD 0.12694f
C105 _243_.CLK a_3045_3911# 0.15214f
C106 _263_.CLK _129_.Y 0.01363f
C107 _135_.A a_13969_16357# 0.01733f
C108 _151_.B a_13649_4704# 0.20254f
C109 a_9156_14040# VDD 0.07729f
C110 _194_.X _230_.Y 0.11194f
C111 _215_.A _173_.A 0.04251f
C112 a_4744_9318# VDD 0.12797f
C113 _236_.A _214_.Y 0.20645f
C114 _205_.Y _191_.Y 0.13597f
C115 a_12804_16000# a_14063_16357# 0.01303f
C116 _222_.A a_2148_16000# 0.01247f
C117 _205_.B1 a_7616_15437# 0.06483f
C118 _228_.Y _251_.CLK 0.12448f
C119 _133_.Y a_13527_11460# 0.02655f
C120 _168_.Y a_6677_8806# 0.02176f
C121 _192_.Y _192_.C 0.07793f
C122 _238_.Y _264_.Q 0.06434f
C123 _133_.Y _129_.B1 0.04703f
C124 a_9352_17508# a_9160_17594# 0.01226f
C125 _230_.Y a_9675_13844# 0.21552f
C126 a_4552_12342# VDD 0.14865f
C127 _192_.Y _176_.B 0.02343f
C128 a_11536_9406# a_11946_9484# 0.05221f
C129 _236_.A a_9994_17476# 0.01836f
C130 _227_.Y a_16079_8797# 0.07576f
C131 a_17120_3270# VDD 0.08028f
C132 _136_.A _210_.B 0.01435f
C133 a_2122_15964# a_2148_16000# 0.21121f
C134 a_12106_12433# a_12549_12189# 0.02242f
C135 _126_.Y a_12132_12528# 0.01338f
C136 _251_.CLK a_16736_4782# 0.01551f
C137 a_12215_7664# _162_.Y 0.14506f
C138 a_15767_17137# a_15722_16904# 0.16388f
C139 _220_.Y a_2218_12433# 0.15833f
C140 fanout7.A a_7908_16000# 0.07076f
C141 clkbuf_1_0__f_sclk.A a_5084_12972# 0.01038f
C142 _122_.X a_1952_7806# 0.01442f
C143 a_12572_4948# VDD 0.11833f
C144 _168_.A a_6528_8475# 0.10298f
C145 _252_.D _136_.B 0.0112f
C146 _138_.Y _252_.RESET_B 0.05628f
C147 a_14820_9504# a_15237_9165# 0.22605f
C148 _118_.A0 a_2148_16000# 0.05566f
C149 a_2126_7864# a_2232_7868# 0.22783f
C150 _214_.A a_11338_16969# 0.02178f
C151 a_9734_17946# VDD 0.44705f
C152 _135_.A a_13221_16007# 0.01079f
C153 _222_.A _259_.RESET_B 0.05316f
C154 a_6272_12342# VDD 0.09107f
C155 _201_.Y a_6508_15532# 0.01455f
C156 fanout7.A a_16746_11460# 0.06113f
C157 a_12778_15964# a_12804_16000# 0.21121f
C158 _260_.RESET_B a_15237_9165# 0.02692f
C159 a_3952_9406# VDD 0.14224f
C160 a_1376_4782# VDD 0.06894f
C161 _148_.B _183_.Y 0.02146f
C162 fanout6.A a_4928_16082# 0.01126f
C163 a_3695_9263# a_4362_9484# 0.06982f
C164 _238_.Y a_14572_16746# 0.0605f
C165 _136_.A _145_.X 1.24667f
C166 _250_.D a_2148_16000# 0.02577f
C167 _236_.A _126_.B1 0.14061f
C168 _214_.A a_11364_17064# 0.06701f
C169 _266_.CLK VDD 0.84288f
C170 _263_.CLK _235_.Y 0.31918f
C171 a_14438_12210# a_14724_12528# 0.21832f
C172 fanout6.A _207_.A2 0.15539f
C173 fanout6.A a_11364_17064# 0.03577f
C174 a_4559_5773# VDD 0.1831f
C175 _144_.B _145_.B1 0.09825f
C176 a_3760_12430# VDD 0.15882f
C177 a_12651_12332# a_12420_12223# 0.06628f
C178 a_13391_12287# a_13648_12430# 0.20069f
C179 a_12132_12528# a_13297_12287# 0.22369f
C180 a_9734_9186# a_10308_9199# 0.16388f
C181 _210_.A _210_.B 0.81832f
C182 a_10539_9308# a_11536_9406# 0.01528f
C183 _148_.B _153_.Y 0.03008f
C184 _222_.Y a_2148_16000# 0.01144f
C185 a_8386_3900# VDD 0.18136f
C186 a_6336_11499# VDD 0.17997f
C187 _124_.S _210_.A 0.09019f
C188 _225_.A a_14730_15996# 0.01293f
C189 a_17032_15366# VDD 0.14714f
C190 a_16840_4688# freq_out 0.13489f
C191 _124_.S _243_.CLK 0.06495f
C192 a_17120_7010# VDD 0.05657f
C193 a_7624_10034# VDD 0.12385f
C194 _148_.A _147_.A1 0.06157f
C195 _207_.A1 a_9808_16966# 0.05416f
C196 a_12237_5760# VDD 0.26973f
C197 _145_.A2 a_7872_5451# 0.20944f
C198 _176_.A _251_.CLK 0.01936f
C199 a_8394_4948# _136_.B 0.06888f
C200 _214_.Y _240_.Y 0.08858f
C201 _149_.A a_13740_5678# 0.0951f
C202 a_2126_15424# _119_.A0 0.28166f
C203 a_6442_4873# a_6885_4629# 0.02242f
C204 a_4816_5654# a_5226_5412# 0.05221f
C205 a_7985_13776# VDD 0.17053f
C206 _247_.CLK a_2148_16000# 0.07008f
C207 _260_.CLK a_15237_9165# 0.15951f
C208 a_3380_13690# VDD 1.66654f
C209 a_2763_12332# a_2532_12223# 0.06628f
C210 a_13000_8522# VDD 0.13314f
C211 a_3503_12287# a_4170_12508# 0.06982f
C212 a_2398_5782# a_2575_5436# 0.01057f
C213 a_2244_12528# a_3409_12287# 0.22369f
C214 _136_.A _170_.B 0.20873f
C215 _124_.S a_2244_12528# 0.02585f
C216 _261_.RESET_B a_12549_12189# 0.02692f
C217 a_2853_9165# VDD 0.25427f
C218 _173_.A a_4928_9318# 0.01516f
C219 a_15983_5773# VDD 0.18396f
C220 _120_.A0 _120_.X 0.02958f
C221 a_8427_16007# a_9424_16238# 0.01569f
C222 _145_.X _158_.Y 0.25277f
C223 a_2955_9308# a_3695_9263# 0.15395f
C224 a_6528_8475# VDD 0.17437f
C225 a_2494_6166# a_2397_6166# 0.01625f
C226 _207_.A1 a_8709_16725# 0.0227f
C227 _243_.Q a_10769_4258# 0.07738f
C228 a_2148_12976# VDD 0.07994f
C229 _240_.Y a_9994_17476# 0.15277f
C230 _136_.B _252_.RESET_B 0.07741f
C231 _186_.Y a_8156_14020# 0.01008f
C232 a_3886_10702# sclk 0.38089f
C233 _260_.CLK a_14724_12528# 0.03589f
C234 _149_.A a_14438_5850# 0.02555f
C235 _183_.Y a_8506_10318# 0.01574f
C236 _222_.A _258_.RESET_B 0.16379f
C237 a_12880_16966# VDD 0.12748f
C238 _131_.B1 a_14432_10830# 0.01144f
C239 _241_.Y _212_.Y 0.10454f
C240 a_3300_5416# VDD 0.10931f
C241 fanout7.A a_9675_13844# 0.04731f
C242 _222_.A _208_.X 0.34385f
C243 a_10437_9165# a_10539_9308# 0.26919f
C244 _251_.CLK _243_.Q 0.03531f
C245 a_12549_12189# a_12651_12332# 0.26919f
C246 _243_.CLK a_3819_5423# 0.04184f
C247 _220_.Y a_2763_12332# 0.21421f
C248 _225_.A a_12804_16000# 0.02357f
C249 a_2148_12976# a_3313_13333# 0.22369f
C250 a_17120_7806# VDD 0.05657f
C251 _160_.X _157_.Y 0.28524f
C252 _145_.X a_8557_4248# 0.09816f
C253 _144_.B a_9322_4873# 0.03021f
C254 _250_.Q a_4074_15996# 0.07035f
C255 VDD freq_out 0.08741f
C256 _143_.A a_7727_4727# 0.01945f
C257 a_6468_4968# a_7633_4727# 0.22369f
C258 a_7727_4727# a_7984_4870# 0.20069f
C259 a_6987_4772# a_6756_4663# 0.06628f
C260 a_3300_5416# a_4559_5773# 0.01303f
C261 fanout8.A _119_.A0 0.02871f
C262 _228_.Y _164_.Y 0.04311f
C263 fanout6.A _135_.X 0.01412f
C264 _147_.Y _147_.B1 0.14489f
C265 _124_.S a_2232_13916# 0.12662f
C266 fanout6.A a_7008_16035# 0.02008f
C267 _236_.A _131_.B1 0.02224f
C268 _129_.Y VDD 0.14599f
C269 a_15141_5423# VDD 0.26403f
C270 _119_.X _120_.A0 0.03253f
C271 _173_.A a_4362_9484# 0.08677f
C272 a_2398_4654# _243_.D 0.16766f
C273 _209_.Y a_6869_16750# 0.02473f
C274 _162_.B a_12512_8522# 0.01169f
C275 a_4362_8436# VDD 0.2439f
C276 a_2436_9504# a_2955_9308# 0.18372f
C277 a_13073_7728# VDD 0.16652f
C278 _179_.Y _181_.Y 0.29221f
C279 a_16240_5654# a_16650_5412# 0.05221f
C280 _131_.A2 a_17032_12342# 0.02647f
C281 _250_.Q _222_.A 0.36555f
C282 a_14794_9409# a_14534_9186# 0.39302f
C283 _207_.Y _208_.X 0.06482f
C284 _207_.A1 a_5376_17061# 0.10045f
C285 a_4512_17547# VDD 0.17981f
C286 _124_.S _125_.A1 0.08266f
C287 _224_.Y a_6885_4629# 0.02692f
C288 _147_.Y a_12712_5498# 0.01374f
C289 a_14240_13058# VDD 0.08002f
C290 fanout6.A _209_.Y 0.02524f
C291 _191_.Y a_6862_15532# 0.0116f
C292 a_2122_12940# a_2565_12983# 0.02242f
C293 a_1862_13410# a_2436_13397# 0.16388f
C294 _258_.RESET_B a_8427_16007# 0.21597f
C295 a_10415_12287# a_10672_12430# 0.20069f
C296 a_11279_9263# _180_.X 0.0253f
C297 _225_.A _263_.CLK 0.10286f
C298 _186_.Y _176_.A 0.04877f
C299 a_14534_9186# _225_.A 0.03633f
C300 a_8870_12210# a_9573_12189# 0.02454f
C301 a_2232_7868# _148_.A 0.06406f
C302 _149_.A _226_.Y 0.04633f
C303 a_12623_16823# a_13290_17044# 0.06982f
C304 a_11781_16725# a_11652_16759# 0.01562f
C305 fanout8.A a_1580_16710# 0.19324f
C306 a_1192_7712# VDD 0.16514f
C307 a_6885_4629# a_6987_4772# 0.26919f
C308 _129_.B1 _261_.RESET_B 0.02365f
C309 a_3274_5380# a_3717_5423# 0.02242f
C310 _225_.A _148_.A 0.02278f
C311 _250_.Q _118_.A0 0.91598f
C312 fanout6.A a_9167_16357# 0.01486f
C313 _135_.A a_14314_15457# 0.01216f
C314 _263_.CLK a_15339_11471# 0.02976f
C315 clkbuf_1_0__f_sclk.A _173_.A 0.01375f
C316 _215_.A _246_.D 0.06217f
C317 a_4074_15996# VDD 0.24898f
C318 fanout7.A _126_.B1 0.0102f
C319 _173_.A a_2955_9308# 0.02405f
C320 _160_.X _161_.Y 0.01125f
C321 _144_.B _252_.RESET_B 0.10072f
C322 _250_.Q _207_.Y 0.08117f
C323 _145_.X _145_.B1 0.0613f
C324 a_2410_8404# VDD 0.09796f
C325 a_14940_16710# VDD 0.07525f
C326 a_5376_17061# _199_.B1 0.11087f
C327 VDD sdata 0.12245f
C328 a_4144_4142# a_3887_4261# 0.20069f
C329 a_14063_16357# VDD 0.16848f
C330 a_14820_8440# VDD 0.07229f
C331 _222_.A a_3313_16823# 0.0102f
C332 _126_.B1 _126_.Y 0.15874f
C333 _236_.A _148_.B 2.26938f
C334 a_1862_16746# a_2148_17064# 0.21832f
C335 _243_.Q _138_.Y 0.56011f
C336 _260_.CLK a_13883_11460# 0.02882f
C337 _181_.Y _171_.A 0.11836f
C338 _236_.A _135_.X 0.06059f
C339 a_2232_13916# a_2298_14020# 0.03308f
C340 _235_.Y VDD 0.99724f
C341 _258_.RESET_B a_7622_16434# 0.08314f
C342 _266_.CLK a_14940_16710# 0.07064f
C343 a_2126_11726# a_2620_11830# 0.01625f
C344 a_10020_9504# _180_.X 0.03281f
C345 _118_.X VDD 0.43682f
C346 _162_.Y VDD 0.18736f
C347 _124_.S a_2565_16007# 0.01173f
C348 _147_.A1 VDD 0.53786f
C349 _222_.A VDD 0.77616f
C350 _243_.D a_2342_4338# 0.15689f
C351 _250_.Q _222_.Y 0.01674f
C352 _266_.CLK a_14063_16357# 0.01768f
C353 _191_.Y _190_.A 0.13419f
C354 a_15339_11471# a_16336_11702# 0.01569f
C355 _120_.A0 a_1862_13410# 0.04424f
C356 a_11168_16082# VDD 0.08273f
C357 a_4816_4870# a_5226_4948# 0.05221f
C358 _148_.B _145_.X 0.01788f
C359 _158_.Y a_13505_8784# 0.01171f
C360 fanout6.A a_7882_15964# 0.01177f
C361 _157_.Y _158_.Y 0.12884f
C362 a_5147_15996# VDD 0.17384f
C363 _263_.CLK a_14820_11464# 0.09038f
C364 _243_.D a_3014_4650# 0.02119f
C365 a_2122_15964# VDD 0.09827f
C366 _250_.Q _247_.CLK 0.03456f
C367 a_7712_7806# VDD 0.08506f
C368 fanout8.A _250_.RESET_B 0.10728f
C369 a_14859_15356# a_15856_15454# 0.01528f
C370 _251_.CLK a_15237_8447# 0.19034f
C371 a_14054_15234# a_14628_15247# 0.16388f
C372 a_14438_5850# a_15012_5837# 0.16388f
C373 a_3045_3911# a_2916_4325# 0.01562f
C374 a_2628_3904# a_3147_3911# 0.18362f
C375 _136_.A a_7633_4727# 0.01786f
C376 a_12778_15964# VDD 0.09677f
C377 _201_.Y _193_.Y 0.04168f
C378 _118_.A0 VDD 1.40275f
C379 _210_.A _210_.Y 0.10368f
C380 a_3695_8797# a_3601_8797# 0.15029f
C381 a_6376_16878# VDD 0.16562f
C382 _225_.A a_15237_11471# 0.0116f
C383 _135_.A _239_.Y 0.187f
C384 _260_.CLK a_14534_11898# 0.02998f
C385 _171_.A _180_.X 0.02225f
C386 _207_.Y VDD 0.21566f
C387 a_13391_12287# VDD 0.17587f
C388 _173_.Y a_7336_9318# 0.01645f
C389 _120_.A0 a_2126_11726# 0.08538f
C390 a_14359_16710# a_14572_16746# 0.20069f
C391 _145_.X _143_.Y 0.0109f
C392 a_10752_7989# VDD 0.17404f
C393 a_10672_13942# a_11082_14020# 0.05221f
C394 _199_.Y VDD 0.30655f
C395 _201_.Y a_7157_16366# 0.01075f
C396 _134_.Y a_13366_13350# 0.03021f
C397 VDD sclk 1.00166f
C398 _148_.B _170_.B 0.03359f
C399 _266_.CLK a_12778_15964# 0.01835f
C400 _143_.A a_8288_3270# 0.01458f
C401 a_15237_11471# a_15339_11471# 0.27006f
C402 _250_.D VDD 0.34951f
C403 _172_.Y _171_.Y 0.03449f
C404 _160_.B a_13244_7972# 0.05488f
C405 a_9551_16823# a_10218_17044# 0.06982f
C406 _201_.Y a_6286_15276# 0.13615f
C407 a_5201_9240# a_5372_9484# 0.19823f
C408 a_8427_16007# VDD 0.20639f
C409 _243_.Q _136_.B 0.20025f
C410 a_3819_4772# a_4559_4727# 0.15395f
C411 _210_.B a_6060_4166# 0.22733f
C412 _192_.Y _187_.Y 0.4681f
C413 _222_.Y VDD 1.03127f
C414 fanout7.A a_15980_7638# 0.14708f
C415 _242_.RESET_B a_3045_3911# 0.014f
C416 _202_.Y _258_.D 0.12443f
C417 _236_.A a_11846_12210# 0.07111f
C418 a_17120_11546# VDD 0.06817f
C419 _124_.S _215_.A 0.16825f
C420 _215_.A a_1864_5498# 0.01194f
C421 a_14054_15234# a_14859_15356# 0.06896f
C422 a_14340_15552# a_14757_15213# 0.22605f
C423 a_7727_4727# VDD 0.17907f
C424 _120_.A0 _221_.Y 0.08368f
C425 a_2342_4338# a_2628_3904# 0.21832f
C426 _202_.Y _191_.Y 0.13732f
C427 _168_.A _168_.Y 0.0197f
C428 a_2436_8440# a_3695_8797# 0.01303f
C429 a_8811_16868# a_9551_16823# 0.15395f
C430 _124_.S a_2075_4692# 0.12f
C431 _180_.X _160_.X 0.01269f
C432 a_14794_9409# VDD 0.09631f
C433 a_2232_10210# _122_.A0 0.10649f
C434 a_9765_4629# a_10513_4727# 0.01058f
C435 _145_.X _151_.B 0.37482f
C436 _247_.CLK VDD 2.54273f
C437 _145_.X a_11974_8436# 0.04448f
C438 _170_.B a_9466_7678# 0.01535f
C439 _157_.Y a_13073_5770# 0.05459f
C440 a_12808_13854# VDD 0.14664f
C441 a_2232_7868# VDD 0.53024f
C442 _210_.B a_6182_4650# 0.03662f
C443 _235_.Y _129_.Y 0.04449f
C444 _243_.CLK _218_.Y 0.02765f
C445 a_14820_8440# a_15985_8797# 0.22369f
C446 a_14534_8874# _166_.A 0.02849f
C447 a_14820_11464# a_15237_11471# 0.22698f
C448 _225_.A a_9734_17946# 0.07548f
C449 _225_.A VDD 4.45631f
C450 a_2232_17770# _250_.Q 0.02866f
C451 a_8292_17064# a_8811_16868# 0.18372f
C452 a_7622_16434# VDD 0.44653f
C453 a_3014_4650# a_3819_4772# 0.06896f
C454 _136_.A _168_.B 0.40848f
C455 a_3300_4968# a_3717_4629# 0.22605f
C456 _210_.A _243_.D 0.26127f
C457 _122_.X a_2150_8874# 0.14948f
C458 fanout8.A _119_.X 0.04948f
C459 _148_.B a_12401_4704# 0.2015f
C460 _251_.CLK _143_.A 0.02735f
C461 a_1192_7712# sdata 0.16857f
C462 _251_.CLK a_7984_4870# 0.01087f
C463 VDD en 0.11696f
C464 fanout7.A a_16336_9406# 0.01305f
C465 a_15339_11471# VDD 0.20504f
C466 fanout7.A _148_.B 0.05468f
C467 a_3407_16357# a_3313_16357# 0.15029f
C468 _133_.Y a_12132_12528# 0.04792f
C469 _225_.A _266_.CLK 0.41274f
C470 a_7328_16878# VDD 0.08131f
C471 _181_.Y a_8050_10326# 0.01125f
C472 a_14534_9186# _251_.CLK 0.01406f
C473 _164_.B1 _166_.A 0.05268f
C474 a_2150_8874# a_2853_8447# 0.02432f
C475 a_2240_3986# VDD 0.09159f
C476 _148_.B _126_.Y 0.06462f
C477 a_16079_9263# a_15985_9263# 0.15029f
C478 a_9867_4772# a_10607_4727# 0.15395f
C479 a_10539_17519# a_11536_17750# 0.01569f
C480 a_10437_17519# a_11185_17869# 0.01058f
C481 _251_.CLK _148_.A 0.0701f
C482 _243_.RESET_B a_3045_3911# 0.02927f
C483 _247_.CLK a_3380_13690# 0.93947f
C484 _131_.A2 a_13366_13350# 0.05331f
C485 _148_.X a_13740_5678# 0.19788f
C486 a_10672_13942# VDD 0.12786f
C487 a_9130_13945# a_9573_13701# 0.02242f
C488 a_8870_13722# a_9156_14040# 0.21832f
C489 _168_.Y VDD 0.45057f
C490 a_13391_12287# _129_.Y 0.01078f
C491 a_14320_16238# a_14730_15996# 0.05221f
C492 _118_.A0 a_4512_17547# 0.1017f
C493 _131_.Y VDD 0.25599f
C494 _148_.B _157_.Y 0.02741f
C495 a_14534_8874# a_15108_8861# 0.16388f
C496 a_14794_8404# a_15237_8447# 0.02242f
C497 _119_.A0 a_2232_13916# 0.05153f
C498 _243_.Q _144_.B 0.01576f
C499 _247_.CLK a_2148_12976# 0.07263f
C500 _124_.S _242_.RESET_B 0.03966f
C501 _122_.A0 a_2298_10318# 0.01744f
C502 a_9156_12528# a_10415_12287# 0.01303f
C503 a_8021_5782# _252_.D 0.02071f
C504 a_2126_7864# a_2620_7678# 0.01625f
C505 _151_.B a_13775_5782# 0.01167f
C506 a_15983_12287# a_16650_12508# 0.06982f
C507 _162_.B a_13184_7183# 0.01826f
C508 _185_.Y a_7808_10034# 0.01215f
C509 a_14820_11464# VDD 0.07247f
C510 a_2148_16000# a_3407_16357# 0.01303f
C511 a_2232_17770# VDD 0.52973f
C512 _173_.Y _184_.Y 0.15283f
C513 _222_.A _118_.X 0.10015f
C514 a_5084_12972# VDD 0.1175f
C515 _139_.X _147_.Y 0.01434f
C516 fanout7.A a_9167_16357# 0.04725f
C517 _122_.X _218_.Y 0.11759f
C518 _126_.B1 a_12704_11546# 0.01113f
C519 a_14624_4782# VDD 0.09334f
C520 a_9062_4650# a_9765_4629# 0.02454f
C521 a_15339_9308# a_16336_9406# 0.01528f
C522 a_9734_17946# a_10539_17519# 0.06896f
C523 _190_.A _192_.C 0.0633f
C524 a_10020_17512# a_10437_17519# 0.22698f
C525 _243_.CLK a_2628_3904# 0.06839f
C526 a_14651_10996# VDD 0.16602f
C527 a_10539_17519# VDD 0.20605f
C528 _176_.A a_9130_12433# 0.01605f
C529 _213_.Y _260_.RESET_B 0.03556f
C530 VDD freq_in 0.29046f
C531 _182_.Y VDD 0.48991f
C532 a_8870_13722# VDD 0.4488f
C533 a_13221_16007# a_13323_16007# 0.27006f
C534 _162_.B _166_.A 0.35138f
C535 _218_.Y a_2853_8447# 0.02707f
C536 _210_.A a_3819_4772# 0.01909f
C537 _238_.Y _211_.Y 0.23775f
C538 _133_.Y a_13413_11460# 0.02521f
C539 a_9994_9409# _251_.CLK 0.04095f
C540 _243_.CLK a_3819_4772# 0.05499f
C541 _168_.Y a_6528_8475# 0.1139f
C542 _143_.A _138_.Y 0.09285f
C543 a_2171_6204# a_2494_6166# 0.22783f
C544 _118_.A0 _118_.X 0.02261f
C545 _148_.B a_8603_9484# 0.02807f
C546 _119_.A0 _148_.B 1.21118f
C547 _118_.A0 _222_.A 0.06766f
C548 _160_.X a_12904_7010# 0.03033f
C549 a_14724_12528# a_15983_12287# 0.01303f
C550 _173_.Y _136_.A 0.33667f
C551 fanout6.A a_13290_17044# 0.02454f
C552 _230_.Y a_9573_13701# 0.02841f
C553 _251_.CLK _168_.A 1.04629f
C554 a_9269_9190# _164_.Y 0.02831f
C555 a_11279_9263# a_11946_9484# 0.06982f
C556 _148_.B _161_.Y 0.02861f
C557 _227_.Y a_16336_8678# 0.0605f
C558 _236_.Y a_14534_11898# 0.09828f
C559 _236_.A _176_.A 0.16232f
C560 a_8288_3270# VDD 0.09218f
C561 a_1862_16434# a_2565_16007# 0.02432f
C562 _222_.A _207_.Y 0.0424f
C563 _126_.Y a_11846_12210# 0.16306f
C564 a_12106_12433# a_12132_12528# 0.21121f
C565 _135_.X a_12518_16434# 0.16172f
C566 _173_.Y a_6124_9945# 0.11239f
C567 _251_.CLK a_16840_4688# 0.15566f
C568 _136_.A a_10940_3900# 0.02046f
C569 a_14940_16710# a_15722_16904# 0.22255f
C570 _157_.Y _151_.B 0.0879f
C571 a_7985_7728# _154_.X 0.13524f
C572 a_12369_4972# VDD 0.01089f
C573 _148_.B a_4744_15366# 0.01664f
C574 _250_.D _118_.X 0.10472f
C575 _148_.A _138_.Y 0.02672f
C576 _118_.A0 a_2122_15964# 0.03246f
C577 _250_.D _222_.A 0.03481f
C578 _178_.B1 _173_.Y 0.36277f
C579 _131_.A2 _126_.B1 1.70108f
C580 a_9160_17594# VDD 0.14274f
C581 _207_.Y a_5147_15996# 0.08668f
C582 _135_.A a_12804_16000# 0.02391f
C583 fanout7.A a_16079_11821# 0.01583f
C584 _136_.B a_6836_3900# 0.01274f
C585 a_3695_9263# VDD 0.20057f
C586 a_12518_16434# a_13221_16007# 0.02432f
C587 _260_.RESET_B a_14820_9504# 0.21712f
C588 _222_.Y _118_.X 0.14113f
C589 a_1192_4782# VDD 0.11992f
C590 _120_.X a_2244_12528# 0.01075f
C591 a_2218_12433# a_2661_12189# 0.02242f
C592 _243_.Q _210_.B 0.04072f
C593 _222_.A _222_.Y 0.18444f
C594 _210_.Y a_6060_4166# 0.11927f
C595 _170_.Y VDD 0.39701f
C596 _124_.S _243_.Q 0.06237f
C597 a_3695_9263# a_3952_9406# 0.20069f
C598 _238_.Y a_15071_17016# 0.03342f
C599 a_1192_4782# a_1376_4782# 0.0262f
C600 _252_.RESET_B a_9867_4772# 0.21491f
C601 a_4074_12972# VDD 0.24531f
C602 _131_.A2 a_14357_12972# 0.04526f
C603 _240_.Y a_11279_17869# 0.07576f
C604 _214_.A a_11078_16746# 0.03512f
C605 _164_.Y a_10895_8436# 0.0904f
C606 _215_.A _210_.Y 0.02019f
C607 _176_.A _256_.RESET_B 0.08212f
C608 VDD rst 0.16778f
C609 fanout8.A _221_.Y 0.05705f
C610 a_4816_5654# VDD 0.13097f
C611 a_3503_12287# VDD 0.20399f
C612 _210_.A a_6747_5468# 0.15646f
C613 a_10539_9308# a_11279_9263# 0.15395f
C614 a_12549_12189# a_12420_12223# 0.01562f
C615 _118_.A0 _250_.D 0.06279f
C616 a_10769_4258# VDD 0.16762f
C617 _227_.Y a_14534_8874# 0.1149f
C618 _222_.A _247_.CLK 0.03005f
C619 _225_.A a_14820_8440# 0.0831f
C620 _210_.A a_2398_5782# 0.07354f
C621 a_16936_7010# VDD 0.13211f
C622 a_7157_9948# VDD 0.14135f
C623 _207_.A1 a_9551_16823# 0.03629f
C624 _148_.B _181_.Y 0.1255f
C625 _148_.B a_13100_13686# 0.13284f
C626 _118_.A0 _222_.Y 0.27273f
C627 _178_.Y _168_.A 0.04052f
C628 _176_.A a_9675_12332# 0.02628f
C629 _143_.A _136_.B 0.08666f
C630 _225_.A _235_.Y 0.04482f
C631 _263_.CLK a_15243_12332# 0.0338f
C632 _124_.S a_2565_12983# 0.01492f
C633 _251_.CLK VDD 3.32349f
C634 _171_.Y a_8488_8436# 0.0264f
C635 a_2126_15424# a_2232_15428# 0.22783f
C636 _210_.Y a_6182_4650# 0.15311f
C637 a_6442_4873# a_6468_4968# 0.21121f
C638 a_4816_5654# a_4559_5773# 0.20069f
C639 _162_.B _154_.X 0.035f
C640 a_6958_13764# VDD 0.16712f
C641 _260_.CLK a_14820_9504# 0.04529f
C642 a_2565_16725# a_2565_16007# 0.01653f
C643 a_3503_12287# a_3760_12430# 0.20069f
C644 a_5704_13854# a_5888_13854# 0.0262f
C645 a_2661_12189# a_2532_12223# 0.01562f
C646 a_2398_5782# a_2301_5436# 0.02903f
C647 a_2075_5468# a_2575_5436# 0.03308f
C648 a_13019_6460# VDD 0.1748f
C649 _124_.S a_1958_12210# 0.05434f
C650 _261_.RESET_B a_12132_12528# 0.23616f
C651 _135_.X _237_.Y 0.25947f
C652 a_2436_9504# VDD 0.09202f
C653 _173_.A a_4744_9318# 0.03991f
C654 a_16240_5654# VDD 0.13415f
C655 _148_.B _134_.Y 0.19242f
C656 _120_.A0 a_2218_12433# 0.04889f
C657 _139_.X a_11274_4948# 0.02632f
C658 a_8325_16007# a_9073_16357# 0.01058f
C659 _157_.B VDD 0.52747f
C660 _260_.CLK _260_.RESET_B 0.02732f
C661 _207_.A1 a_8292_17064# 0.03195f
C662 _126_.Y a_12923_11460# 0.08668f
C663 _135_.X _134_.Y 0.03244f
C664 _250_.D _222_.Y 0.15357f
C665 a_2122_12940# VDD 0.0981f
C666 _260_.CLK a_14438_12210# 0.02044f
C667 a_2126_15424# a_2620_15238# 0.01625f
C668 a_16936_7010# a_17120_7010# 0.0262f
C669 _133_.Y _126_.B1 0.05893f
C670 a_12623_16823# VDD 0.17034f
C671 _222_.A a_7328_16878# 0.01016f
C672 a_3274_5380# VDD 0.12197f
C673 fanout7.A a_9573_13701# 0.17746f
C674 a_10020_9504# a_10539_9308# 0.18372f
C675 a_12132_12528# a_12651_12332# 0.18372f
C676 _237_.Y a_13221_16007# 0.02841f
C677 _220_.Y a_2661_12189# 0.02692f
C678 a_2436_13397# a_2667_12983# 0.06628f
C679 _215_.A _218_.Y 0.09256f
C680 a_16936_7806# VDD 0.13249f
C681 _151_.X VDD 0.45447f
C682 _145_.A2 a_8564_5412# 0.08486f
C683 _235_.Y _131_.Y 0.04064f
C684 fanout7.A _128_.B1 0.03414f
C685 _131_.A2 _131_.B1 0.16304f
C686 _202_.Y a_7451_14484# 0.0862f
C687 _200_.Y VDD 0.48658f
C688 _148_.B _180_.X 0.08534f
C689 a_6885_4629# a_6756_4663# 0.01562f
C690 _215_.A _243_.D 0.02818f
C691 a_3717_5423# a_3819_5423# 0.27006f
C692 _251_.CLK a_15983_5773# 0.01208f
C693 a_2661_12189# a_2763_12332# 0.26919f
C694 _250_.RESET_B a_2565_16007# 0.02751f
C695 _173_.A VDD 1.31062f
C696 _120_.A0 a_2532_12223# 0.01924f
C697 _171_.A a_7739_9484# 0.09173f
C698 a_14724_5416# VDD 0.08903f
C699 a_2398_4654# a_2575_4948# 0.01057f
C700 a_2075_4692# _243_.D 0.01939f
C701 _173_.A a_3952_9406# 0.01074f
C702 _244_.RESET_B _210_.A 0.01187f
C703 a_2126_13912# _120_.A0 0.27418f
C704 _235_.Y a_14820_11464# 0.01405f
C705 _192_.Y _192_.B 0.1608f
C706 a_2436_9504# a_2853_9165# 0.22605f
C707 _243_.CLK _244_.RESET_B 0.0431f
C708 a_2150_9186# a_2955_9308# 0.06896f
C709 _164_.Y _168_.A 0.05449f
C710 a_3695_8797# VDD 0.20294f
C711 _178_.Y VDD 0.38273f
C712 a_7622_16434# a_8427_16007# 0.06896f
C713 a_13649_4704# VDD 0.16811f
C714 en sclk 0.07617f
C715 a_16240_5654# a_15983_5773# 0.20069f
C716 _136_.A a_11661_4696# 0.16039f
C717 _124_.S a_2126_7864# 0.0943f
C718 a_16746_8436# VDD 0.23894f
C719 _224_.Y a_6468_4968# 0.23939f
C720 _145_.X _160_.B 0.10361f
C721 _125_.A1 a_2398_5782# 0.26753f
C722 fanout6.A a_12804_16000# 0.02966f
C723 _191_.Y _192_.C 0.14279f
C724 a_13464_12952# VDD 0.01765f
C725 a_2122_12940# a_2148_12976# 0.21121f
C726 _120_.A0 _220_.Y 0.05836f
C727 a_13244_7972# VDD 0.11749f
C728 a_8870_12210# a_9156_12528# 0.21832f
C729 _186_.Y VDD 1.32066f
C730 a_14794_9409# _225_.A 0.02318f
C731 _207_.A1 a_9834_15996# 0.07149f
C732 _124_.S a_2436_8440# 0.02788f
C733 _160_.X _164_.B1 0.09052f
C734 _157_.Y a_13130_4948# 0.01678f
C735 _138_.Y VDD 0.58222f
C736 a_11364_17064# a_11652_16759# 0.22255f
C737 a_12623_16823# a_12880_16966# 0.20069f
C738 a_17120_8522# VDD 0.06793f
C739 a_6468_4968# a_6987_4772# 0.18372f
C740 _178_.Y a_7624_10034# 0.01814f
C741 _160_.B a_13321_7272# 0.01001f
C742 _136_.A a_7872_5451# 0.04385f
C743 _159_.Y VDD 0.43097f
C744 a_3274_5380# a_3300_5416# 0.21121f
C745 a_2232_17770# _118_.A0 0.09962f
C746 _251_.CLK a_15141_5423# 0.1812f
C747 _120_.A0 a_2763_12332# 0.02466f
C748 a_3407_16357# VDD 0.1951f
C749 _173_.A a_2853_9165# 0.0157f
C750 _148_.A _144_.B 1.08992f
C751 _250_.Q a_4074_17044# 0.03408f
C752 _193_.Y _190_.A 0.02689f
C753 a_14724_5416# a_15983_5773# 0.01303f
C754 a_3147_3911# a_3887_4261# 0.15395f
C755 _243_.CLK a_2955_8447# 0.0417f
C756 _241_.Y a_11883_16868# 0.21621f
C757 a_16936_7806# a_17120_7806# 0.0262f
C758 _138_.Y a_8386_3900# 0.02063f
C759 a_14794_8404# VDD 0.09426f
C760 a_14320_16238# VDD 0.12695f
C761 _119_.A0 _189_.X 0.01414f
C762 _148_.B _152_.X 0.10115f
C763 _225_.A a_15339_11471# 0.01343f
C764 a_2232_13916# clkload0.Y 0.05105f
C765 _164_.Y VDD 0.66133f
C766 _151_.B _149_.A 0.06961f
C767 a_14698_12433# VDD 0.09615f
C768 _242_.RESET_B _243_.D 0.11348f
C769 a_2126_11726# a_2298_11830# 0.0308f
C770 a_9734_9186# _180_.X 0.01096f
C771 _129_.B1 _260_.CLK 0.13022f
C772 a_12032_7806# VDD 0.08403f
C773 a_17032_17594# VDD 0.13719f
C774 _124_.S a_2148_16000# 0.01696f
C775 _250_.Q a_2122_16969# 0.03039f
C776 _186_.Y a_7985_13776# 0.07054f
C777 _266_.CLK a_14320_16238# 0.0145f
C778 a_11781_16725# a_11883_16868# 0.26919f
C779 _148_.B _192_.Y 0.01194f
C780 _215_.A a_3819_4772# 0.01436f
C781 _165_.Y VDD 0.35629f
C782 _131_.A2 a_14058_12508# 0.07103f
C783 a_4559_4727# a_5226_4948# 0.06982f
C784 _210_.B a_6836_3900# 0.05357f
C785 _157_.Y a_13184_8522# 0.01289f
C786 _243_.Q _210_.Y 0.02021f
C787 a_15243_12332# VDD 0.20531f
C788 fanout8.A _207_.A1 0.11979f
C789 _179_.Y a_8501_10702# 0.02385f
C790 _250_.Q a_2667_16868# 0.02541f
C791 _205_.B1 VDD 0.17788f
C792 _160_.X _162_.B 0.54928f
C793 _151_.B a_13820_4948# 0.03239f
C794 _135_.A VDD 0.56476f
C795 _136_.B VDD 0.39248f
C796 _251_.CLK a_14820_8440# 0.07473f
C797 _207_.B1 a_4928_16082# 0.02124f
C798 a_14859_15356# a_15599_15311# 0.15395f
C799 a_2628_3904# a_2916_4325# 0.22255f
C800 a_14724_5416# a_15141_5423# 0.22698f
C801 _215_.A _120_.X 0.06642f
C802 _136_.A a_7985_7728# 0.24039f
C803 _201_.Y a_7616_15437# 0.17559f
C804 fanout6.A _258_.RESET_B 0.04953f
C805 a_3695_8797# a_4362_8436# 0.06982f
C806 _210_.A a_6442_4873# 0.03896f
C807 _225_.A a_14820_11464# 0.0186f
C808 _242_.D _243_.D 0.08532f
C809 _148_.B _133_.Y 0.01527f
C810 _251_.CLK _147_.A1 0.01843f
C811 a_4074_17044# VDD 0.24788f
C812 _136_.A a_6810_3863# 0.06501f
C813 _266_.CLK _135_.A 0.06486f
C814 a_14240_16921# a_14572_16746# 0.05221f
C815 _190_.A _187_.Y 0.01477f
C816 a_9248_7806# VDD 0.08505f
C817 a_5333_15532# VDD 0.16957f
C818 a_10415_13799# a_11082_14020# 0.06982f
C819 _225_.A a_14624_4782# 0.01128f
C820 _201_.Y a_7008_16035# 0.09033f
C821 a_15339_8447# _166_.A 0.02199f
C822 a_14820_11464# a_15339_11471# 0.18362f
C823 a_15237_11471# a_15108_11885# 0.01562f
C824 _225_.A a_10539_17519# 0.02799f
C825 _202_.Y _193_.Y 0.01521f
C826 _215_.A a_1864_6294# 0.01103f
C827 _225_.A freq_in 0.03175f
C828 a_13073_7728# a_13244_7972# 0.19823f
C829 a_9551_16823# a_9808_16966# 0.20069f
C830 _136_.A _224_.Y 0.01807f
C831 _183_.Y VDD 0.29137f
C832 _243_.RESET_B _243_.D 0.06443f
C833 _236_.A _263_.CLK 0.61378f
C834 _228_.Y _180_.X 0.03429f
C835 a_2122_16969# VDD 0.09797f
C836 _176_.A a_11082_12508# 0.09202f
C837 _202_.Y a_7157_16366# 0.01023f
C838 _148_.A _210_.B 0.03134f
C839 fanout7.A a_17120_9318# 0.01522f
C840 a_6656_5498# VDD 0.08604f
C841 _124_.S _148_.A 0.46087f
C842 a_14054_15234# a_14757_15213# 0.02454f
C843 a_2342_4338# a_2602_3868# 0.39302f
C844 _134_.Y _128_.B1 0.02841f
C845 _250_.Q fanout6.A 0.01216f
C846 _119_.A0 clkbuf_1_0__f_sclk.A 0.03626f
C847 _136_.A a_6987_4772# 0.01402f
C848 a_2853_8447# a_2955_8447# 0.27006f
C849 _153_.Y VDD 0.69174f
C850 a_3793_4261# VDD 0.01168f
C851 a_2126_10214# _122_.A0 0.27883f
C852 _242_.RESET_B a_3819_4772# 0.21421f
C853 a_9348_4968# a_10513_4727# 0.22369f
C854 a_9867_4772# a_9636_4663# 0.06628f
C855 _148_.A a_12128_4782# 0.01155f
C856 a_10864_4870# a_11274_4948# 0.05221f
C857 a_2667_16868# VDD 0.21006f
C858 _119_.A0 a_2565_12983# 0.01602f
C859 _243_.Q _243_.D 0.15785f
C860 _145_.X a_10895_8436# 0.02608f
C861 _181_.Y a_8352_11013# 0.21857f
C862 _148_.B _196_.Y 0.02937f
C863 a_1952_7806# VDD 0.0905f
C864 _131_.Y a_14651_10996# 0.08535f
C865 a_9156_14040# a_10415_13799# 0.01303f
C866 a_15108_8861# a_15339_8447# 0.06628f
C867 a_3588_4663# VDD 0.01234f
C868 a_14794_11428# a_15237_11471# 0.02242f
C869 _210_.A _224_.Y 0.0674f
C870 a_10220_18222# VDD 0.19673f
C871 a_2126_17774# _250_.Q 0.07074f
C872 a_8292_17064# a_8709_16725# 0.22605f
C873 a_8006_16746# a_8811_16868# 0.06896f
C874 _136_.A a_5201_9240# 0.17612f
C875 _207_.B1 _148_.B 0.01534f
C876 _260_.CLK _236_.Y 0.09537f
C877 _236_.A a_9928_18390# 0.02118f
C878 a_3014_4650# a_3717_4629# 0.02454f
C879 _210_.A a_2575_4948# 0.01333f
C880 a_9573_12189# a_10321_12287# 0.01058f
C881 a_14359_16710# _238_.Y 0.07576f
C882 _246_.D VDD 0.36778f
C883 _251_.CLK a_7727_4727# 0.02062f
C884 _144_.B VDD 0.72676f
C885 _243_.Q a_4554_3900# 0.09536f
C886 fanout7.A a_16079_9263# 0.02013f
C887 a_3407_16357# a_4074_15996# 0.06982f
C888 _236_.A a_11082_14020# 0.04383f
C889 _210_.A a_6987_4772# 0.01454f
C890 a_2150_8874# a_2436_8440# 0.21832f
C891 _153_.Y a_13000_8522# 0.01995f
C892 _131_.A2 a_12923_11460# 0.05928f
C893 a_14919_16964# a_15767_17137# 0.06896f
C894 a_3045_3911# VDD 0.27555f
C895 _192_.C _176_.B 0.01458f
C896 _185_.Y VDD 0.23455f
C897 _148_.B a_12106_12433# 0.02883f
C898 _199_.Y _200_.Y 0.17659f
C899 a_10020_17512# a_11185_17869# 0.22369f
C900 a_10539_17519# freq_in 0.01517f
C901 _131_.B1 a_14724_12528# 0.04349f
C902 _214_.A VDD 0.55976f
C903 _145_.X a_11731_8698# 0.01427f
C904 _243_.RESET_B a_2628_3904# 0.22556f
C905 a_10415_13799# VDD 0.17766f
C906 _122_.A0 _136_.A 0.26614f
C907 a_9130_13945# a_9156_14040# 0.21121f
C908 _171_.A a_8488_8436# 0.01191f
C909 _239_.Y a_14859_15356# 0.21577f
C910 fanout6.A VDD 1.36715f
C911 a_6389_9484# VDD 0.16948f
C912 a_14320_16238# a_14063_16357# 0.20069f
C913 _225_.A _251_.CLK 1.65078f
C914 _215_.A _244_.RESET_B 0.13732f
C915 a_14794_8404# a_14820_8440# 0.21121f
C916 _173_.A sclk 0.04955f
C917 _190_.A _194_.X 0.02407f
C918 _250_.Q _124_.S 0.10966f
C919 _210_.A a_5226_4948# 0.0854f
C920 clkbuf_1_0__f_sclk.A _168_.B 0.1476f
C921 _191_.Y _193_.Y 0.16994f
C922 a_2126_10214# a_2620_10318# 0.01625f
C923 _126_.B1 a_13883_11460# 0.05737f
C924 _168_.Y _170_.Y 0.01876f
C925 _195_.Y a_5427_15260# 0.01006f
C926 a_7872_5451# _252_.D 0.11016f
C927 a_2126_7864# a_2298_7678# 0.0308f
C928 a_7157_16366# _258_.D 0.02071f
C929 _214_.Y a_10437_17519# 0.04514f
C930 a_15983_12287# a_16240_12430# 0.20069f
C931 _162_.B a_12328_7010# 0.0161f
C932 a_15141_12189# a_15889_12287# 0.01058f
C933 fanout6.A _266_.CLK 0.16362f
C934 _243_.Q a_2628_3904# 0.01997f
C935 _215_.A a_3014_5850# 0.0556f
C936 _128_.B1 _131_.A2 0.16133f
C937 _185_.Y a_7624_10034# 0.02678f
C938 a_14698_12433# _235_.Y 0.13355f
C939 a_6760_13854# VDD 0.15499f
C940 a_14794_11428# VDD 0.09629f
C941 a_2565_16007# a_2667_16007# 0.27006f
C942 a_2126_17774# VDD 0.10461f
C943 _225_.A a_12623_16823# 0.01143f
C944 _173_.Y a_6320_10296# 0.01087f
C945 _178_.B1 a_6579_11460# 0.01033f
C946 a_4881_12972# VDD 0.01071f
C947 fanout7.A a_9424_16238# 0.01921f
C948 a_10799_5782# _147_.A1 0.0107f
C949 _192_.Y a_6779_12972# 0.02018f
C950 _199_.Y _186_.Y 0.19061f
C951 a_15339_9308# a_16079_9263# 0.15395f
C952 a_9994_17476# a_10437_17519# 0.02242f
C953 a_9734_17946# a_10308_17933# 0.16388f
C954 a_9322_4873# a_9765_4629# 0.02242f
C955 a_9062_4650# a_9348_4968# 0.21832f
C956 _190_.A a_6197_13342# 0.02954f
C957 _225_.A _151_.X 0.08035f
C958 a_14432_10830# VDD 0.08862f
C959 _135_.A a_14063_16357# 0.04777f
C960 _157_.Y a_12215_7664# 0.01751f
C961 _153_.Y a_13073_7728# 0.05638f
C962 _214_.Y a_10888_16878# 0.01691f
C963 a_9130_12433# VDD 0.09651f
C964 _235_.Y a_15243_12332# 0.21423f
C965 a_9130_13945# VDD 0.09699f
C966 _122_.A0 _243_.CLK 0.05107f
C967 _148_.B _148_.X 0.17109f
C968 a_13221_16007# a_13092_16421# 0.01562f
C969 a_12804_16000# a_13323_16007# 0.18362f
C970 clkbuf_1_0__f_sclk.A a_5800_9318# 0.01103f
C971 _148_.B _164_.B1 0.07456f
C972 a_2398_5782# _242_.D 0.11434f
C973 _218_.Y a_2436_8440# 0.25078f
C974 a_2048_6294# VDD 0.06687f
C975 _243_.CLK a_3717_4629# 0.18175f
C976 fanout7.A _263_.CLK 0.18202f
C977 a_4640_13058# VDD 0.0708f
C978 _148_.B _261_.RESET_B 0.07633f
C979 _148_.A a_12401_4704# 0.06408f
C980 _149_.A a_16650_5412# 0.0868f
C981 _143_.A a_8021_5782# 0.01258f
C982 _225_.A a_14724_5416# 0.05118f
C983 fanout6.A a_12880_16966# 0.01434f
C984 _210_.B VDD 0.48564f
C985 _230_.Y a_9156_14040# 0.2398f
C986 _263_.CLK _126_.Y 0.02274f
C987 _124_.S VDD 2.90686f
C988 _236_.A a_9734_17946# 0.03378f
C989 a_11279_9263# a_11536_9406# 0.20069f
C990 _227_.Y a_15339_8447# 0.21427f
C991 a_1864_5498# VDD 0.14659f
C992 _215_.A _219_.Y 0.0895f
C993 a_11381_3900# VDD 0.13796f
C994 a_1862_16434# a_2148_16000# 0.21832f
C995 _236_.A VDD 3.27291f
C996 _191_.Y _187_.Y 0.07827f
C997 a_12106_12433# a_11846_12210# 0.39302f
C998 _213_.Y _227_.Y 0.01532f
C999 _215_.A _221_.Y 0.15995f
C1000 a_7985_7728# a_8156_7972# 0.19823f
C1001 _244_.RESET_B _242_.RESET_B 0.02757f
C1002 a_12128_4782# VDD 0.08227f
C1003 _168_.A a_6184_8522# 0.0102f
C1004 _182_.Y _251_.CLK 0.02252f
C1005 _136_.A _147_.Y 0.07734f
C1006 _128_.B1 _133_.Y 0.15788f
C1007 _225_.A _138_.Y 0.13698f
C1008 fanout7.A a_16336_11702# 0.0128f
C1009 a_12518_16434# a_12804_16000# 0.21832f
C1010 a_17032_5498# VDD 0.1315f
C1011 _120_.X a_1958_12210# 0.1668f
C1012 a_2218_12433# a_2244_12528# 0.21121f
C1013 _200_.Y a_6008_15242# 0.01588f
C1014 _258_.RESET_B fanout7.A 0.0264f
C1015 _145_.X VDD 2.1677f
C1016 a_2853_9165# a_3601_9263# 0.01058f
C1017 _225_.A _159_.Y 0.15898f
C1018 _207_.A2 _207_.A1 0.47937f
C1019 _120_.X a_1952_11546# 0.01763f
C1020 _199_.Y _205_.B1 0.18338f
C1021 _243_.Q a_10940_3900# 0.01089f
C1022 _243_.Q a_2398_5782# 0.03546f
C1023 _118_.A0 a_4074_17044# 0.08013f
C1024 _244_.D _244_.RESET_B 0.04424f
C1025 a_3407_13333# VDD 0.1967f
C1026 _225_.A a_15012_12223# 0.02086f
C1027 _240_.Y a_11536_17750# 0.0605f
C1028 _136_.A a_8488_8436# 0.14202f
C1029 _252_.RESET_B a_9765_4629# 0.02765f
C1030 clkbuf_1_0__f_sclk.A _173_.Y 0.05214f
C1031 _256_.RESET_B VDD 1.09519f
C1032 _153_.Y _162_.Y 0.11047f
C1033 fanout8.A a_1580_12936# 0.16923f
C1034 fanout6.A a_4512_17547# 0.19032f
C1035 _230_.Y VDD 1.09707f
C1036 fanout7.A a_11082_14020# 0.01507f
C1037 a_3819_5423# VDD 0.24276f
C1038 a_12132_12528# a_12420_12223# 0.22255f
C1039 _148_.B _162_.B 0.08884f
C1040 a_6080_11546# VDD 0.09496f
C1041 a_14534_9186# a_15339_9308# 0.06896f
C1042 a_3407_13333# a_3313_13333# 0.15029f
C1043 _210_.A a_2075_5468# 0.03429f
C1044 _225_.A a_14794_8404# 0.03524f
C1045 _244_.D a_3014_5850# 0.15198f
C1046 a_2126_13912# a_2620_13726# 0.01625f
C1047 _122_.A0 _122_.X 0.04017f
C1048 _151_.B _148_.X 0.38563f
C1049 a_5333_15532# _199_.Y 0.08615f
C1050 _164_.B1 a_11974_8436# 0.0591f
C1051 _225_.A a_14698_12433# 0.02496f
C1052 _118_.A0 a_2122_16969# 0.02616f
C1053 _225_.A _164_.Y 0.66103f
C1054 a_7336_9318# a_7520_9318# 0.0262f
C1055 _176_.A a_9573_12189# 0.02192f
C1056 _124_.S a_2148_12976# 0.01927f
C1057 _263_.CLK a_15141_12189# 0.1761f
C1058 a_9675_12332# VDD 0.20563f
C1059 _171_.Y a_8014_8492# 0.13433f
C1060 _170_.B VDD 0.70999f
C1061 a_6442_4873# a_6182_4650# 0.39302f
C1062 a_3819_5423# a_4559_5773# 0.15395f
C1063 _196_.Y _189_.X 0.08053f
C1064 a_2075_5468# a_2301_5436# 0.02726f
C1065 _242_.D a_3014_5850# 0.02057f
C1066 a_2244_12528# a_2532_12223# 0.22255f
C1067 a_12800_6294# VDD 0.07988f
C1068 _207_.A2 _199_.B1 0.03977f
C1069 _261_.RESET_B a_11846_12210# 0.11348f
C1070 _131_.B1 a_14534_11898# 0.04913f
C1071 _172_.Y a_9734_9186# 0.17336f
C1072 a_2150_9186# VDD 0.45098f
C1073 _122_.A0 a_2853_8447# 0.0199f
C1074 a_15243_5423# VDD 0.21138f
C1075 _144_.B _147_.A1 0.02783f
C1076 a_12328_8522# a_12512_8522# 0.0262f
C1077 _260_.RESET_B _227_.Y 0.02535f
C1078 a_8196_16421# a_8427_16007# 0.06628f
C1079 a_7908_16000# a_9073_16357# 0.22369f
C1080 a_9269_9190# a_9120_9501# 0.17527f
C1081 _139_.X a_10864_4870# 0.05101f
C1082 a_2436_9504# a_3695_9263# 0.01303f
C1083 a_6184_8522# VDD 0.15122f
C1084 _207_.A1 a_8006_16746# 0.02079f
C1085 _148_.A a_2298_7678# 0.0207f
C1086 _135_.X a_12992_15437# 0.07539f
C1087 _250_.D a_2122_16969# 0.02135f
C1088 _225_.A a_15243_12332# 0.02368f
C1089 _118_.A0 a_2667_16868# 0.01308f
C1090 _240_.Y a_9734_17946# 0.09283f
C1091 a_2126_15424# a_2298_15238# 0.0308f
C1092 _136_.A _147_.B1 0.19928f
C1093 _240_.Y VDD 1.15183f
C1094 _222_.A a_6869_16750# 0.01017f
C1095 _225_.A _135_.A 0.13695f
C1096 fanout7.A a_9156_14040# 0.06265f
C1097 a_11846_12210# a_12651_12332# 0.06896f
C1098 a_12132_12528# a_12549_12189# 0.22605f
C1099 _237_.Y a_12804_16000# 0.22336f
C1100 a_9734_9186# a_10539_9308# 0.06896f
C1101 a_10020_9504# a_10437_9165# 0.22605f
C1102 a_2122_16969# _222_.Y 0.13217f
C1103 _220_.Y a_2244_12528# 0.23939f
C1104 a_2148_12976# a_3407_13333# 0.01303f
C1105 a_11185_9263# _180_.X 0.01197f
C1106 a_15776_7806# VDD 0.08201f
C1107 _145_.A2 a_8115_5412# 0.01104f
C1108 _243_.Q a_2608_6166# 0.02004f
C1109 _190_.A _192_.B 0.02496f
C1110 fanout6.A _222_.A 0.13832f
C1111 _236_.A _129_.Y 0.06053f
C1112 _128_.B1 a_13978_13342# 0.01695f
C1113 a_12623_16823# a_12529_16823# 0.15029f
C1114 _215_.A _224_.Y 0.0603f
C1115 a_6468_4968# a_6756_4663# 0.22255f
C1116 _214_.A a_11168_16082# 0.01013f
C1117 _212_.Y a_11078_16746# 0.15726f
C1118 _168_.Y _165_.Y 0.13647f
C1119 _205_.Y a_7168_15260# 0.01657f
C1120 _147_.Y a_13244_5412# 0.01008f
C1121 a_3717_5423# a_3588_5837# 0.01562f
C1122 a_3300_5416# a_3819_5423# 0.18362f
C1123 a_5608_4782# a_5792_4782# 0.0262f
C1124 _222_.Y a_2667_16868# 0.21421f
C1125 _250_.RESET_B a_2148_16000# 0.22383f
C1126 a_2244_12528# a_2763_12332# 0.18372f
C1127 a_2232_11722# VDD 0.52584f
C1128 a_12401_4704# a_12572_4948# 0.19823f
C1129 a_14698_5380# VDD 0.10114f
C1130 _162_.B _151_.B 0.02325f
C1131 _122_.A0 a_8156_7972# 0.01008f
C1132 a_2398_4654# a_2301_4948# 0.02903f
C1133 a_2075_4692# a_2575_4948# 0.03308f
C1134 a_2126_13912# a_2232_13916# 0.22783f
C1135 _173_.A a_3695_9263# 0.01857f
C1136 _119_.X a_1864_13854# 0.04537f
C1137 a_7622_16434# a_8196_16421# 0.16388f
C1138 a_7908_16000# a_8325_16007# 0.22698f
C1139 a_2150_9186# a_2853_9165# 0.02454f
C1140 a_3952_8678# VDD 0.14178f
C1141 _207_.A1 _209_.Y 0.19694f
C1142 a_12401_4704# VDD 0.16638f
C1143 a_15243_5423# a_15983_5773# 0.15395f
C1144 a_16079_8797# VDD 0.1729f
C1145 _125_.A1 a_2075_5468# 0.07383f
C1146 _224_.Y a_6182_4650# 0.11226f
C1147 _118_.A0 fanout6.A 0.74532f
C1148 fanout6.A a_12778_15964# 0.02328f
C1149 a_2667_16868# _247_.CLK 0.01586f
C1150 fanout7.A VDD 2.84002f
C1151 _147_.Y a_13073_5770# 0.0699f
C1152 _148_.B a_12886_13350# 0.08664f
C1153 a_12984_12952# VDD 0.01847f
C1154 _260_.CLK a_16746_11460# 0.07726f
C1155 _172_.Y _228_.Y 0.04302f
C1156 _244_.RESET_B a_3717_5423# 0.02912f
C1157 a_1862_13410# a_2565_12983# 0.02432f
C1158 a_15141_12189# a_15237_11471# 0.01276f
C1159 fanout6.A _207_.Y 0.3499f
C1160 a_13041_7996# VDD 0.01058f
C1161 _126_.Y VDD 0.27161f
C1162 _148_.B _195_.Y 0.14589f
C1163 _148_.B a_8501_10702# 0.01263f
C1164 _124_.S a_2410_8404# 0.02867f
C1165 a_11078_16746# a_11652_16759# 0.16388f
C1166 _215_.A a_5226_4948# 0.01654f
C1167 a_6182_4650# a_6987_4772# 0.06896f
C1168 a_6468_4968# a_6885_4629# 0.22605f
C1169 _178_.Y a_7157_9948# 0.01249f
C1170 _243_.Q a_11661_4696# 0.07638f
C1171 a_3014_5850# a_3717_5423# 0.02432f
C1172 _174_.Y _184_.Y 0.09511f
C1173 _157_.Y VDD 0.56251f
C1174 _228_.Y a_10539_9308# 0.21421f
C1175 fanout6.A a_8427_16007# 0.01659f
C1176 a_2126_17774# _118_.A0 0.26703f
C1177 _251_.CLK a_14724_5416# 0.0816f
C1178 _120_.A0 a_2661_12189# 0.02382f
C1179 a_3664_16238# VDD 0.16526f
C1180 a_10220_18222# _225_.A 0.16451f
C1181 _173_.A a_2436_9504# 0.02191f
C1182 _148_.A a_8538_5375# 0.0104f
C1183 _250_.Q a_3664_16966# 0.01532f
C1184 a_2150_8874# VDD 0.45145f
C1185 _236_.A _235_.Y 0.12431f
C1186 a_14919_16964# VDD 0.20664f
C1187 _124_.S _222_.A 0.02816f
C1188 fanout8.A a_1862_16746# 0.0133f
C1189 a_15856_15454# a_16266_15532# 0.05221f
C1190 a_9867_4772# VDD 0.20715f
C1191 a_15141_5423# a_15243_5423# 0.27006f
C1192 _147_.A1 a_11381_3900# 0.02365f
C1193 a_3147_3911# a_4144_4142# 0.01569f
C1194 _193_.Y a_7451_14484# 0.07889f
C1195 _241_.Y a_11781_16725# 0.02885f
C1196 _210_.Y VDD 0.28139f
C1197 _148_.B _190_.A 0.49668f
C1198 _192_.C _187_.Y 0.03789f
C1199 a_13323_16007# VDD 0.20537f
C1200 _225_.A _144_.B 0.82298f
C1201 _212_.Y a_11944_16082# 0.02581f
C1202 a_2126_17774# _250_.D 0.11406f
C1203 _180_.X a_10895_8436# 0.02303f
C1204 _225_.A a_15108_11885# 0.01597f
C1205 _236_.A a_11168_16082# 0.01593f
C1206 _148_.B _147_.Y 0.03232f
C1207 _187_.Y _176_.B 0.11454f
C1208 _215_.A _122_.A0 0.02468f
C1209 _266_.CLK a_14919_16964# 0.01758f
C1210 _251_.CLK _138_.Y 0.04184f
C1211 _219_.Y a_2955_9308# 0.21421f
C1212 a_10592_5498# VDD 0.08379f
C1213 _158_.Y a_13824_7989# 0.19715f
C1214 _174_.Y _136_.A 0.02431f
C1215 a_15339_9308# VDD 0.20203f
C1216 _266_.CLK a_13323_16007# 0.0678f
C1217 a_11364_17064# a_11883_16868# 0.18372f
C1218 a_15108_11885# a_15339_11471# 0.06628f
C1219 _132_.Y a_13804_10996# 0.01284f
C1220 _215_.A a_3717_4629# 0.01285f
C1221 _225_.A _214_.A 0.09461f
C1222 _131_.A2 a_13648_12430# 0.02591f
C1223 _160_.B a_13973_7678# 0.02125f
C1224 _118_.A0 _124_.S 0.17697f
C1225 a_4559_4727# a_4816_4870# 0.20069f
C1226 _151_.X a_13649_4704# 0.12897f
C1227 _225_.A fanout6.A 0.09772f
C1228 _174_.Y a_6124_9945# 0.12659f
C1229 fanout6.A a_7622_16434# 0.02288f
C1230 _148_.B a_8488_8436# 0.17485f
C1231 _165_.Y _170_.Y 0.19273f
C1232 _221_.Y a_2565_12983# 0.02751f
C1233 a_15141_12189# VDD 0.23844f
C1234 _131_.A2 _132_.Y 0.23968f
C1235 a_1862_16434# VDD 0.44989f
C1236 a_6720_17061# _209_.Y 0.13465f
C1237 _250_.Q a_2565_16725# 0.02005f
C1238 _178_.B1 _174_.Y 0.5164f
C1239 a_8603_9484# VDD 0.16419f
C1240 _207_.B1 a_4684_15996# 0.01352f
C1241 _124_.S sclk 0.0842f
C1242 _119_.A0 VDD 1.23808f
C1243 a_14698_5380# a_15141_5423# 0.02242f
C1244 _181_.Y _168_.A 0.01877f
C1245 a_12518_16434# VDD 0.4486f
C1246 a_3952_8678# a_4362_8436# 0.05221f
C1247 _161_.Y VDD 0.34834f
C1248 _168_.B _168_.A 0.33677f
C1249 _251_.CLK _164_.Y 0.04304f
C1250 _225_.A a_14794_11428# 0.03075f
C1251 _180_.X a_11731_8698# 0.10129f
C1252 a_10308_9199# _251_.CLK 0.0226f
C1253 _179_.Y _177_.X 0.12788f
C1254 a_3664_16966# VDD 0.15552f
C1255 _119_.A0 a_3313_13333# 0.01099f
C1256 _218_.Y VDD 1.05328f
C1257 _124_.S _222_.Y 0.01883f
C1258 a_9573_13701# a_10321_13799# 0.01058f
C1259 a_4744_15366# VDD 0.16789f
C1260 _263_.CLK _131_.A2 0.18558f
C1261 a_10415_13799# a_10672_13942# 0.20069f
C1262 a_6747_5468# _143_.A 0.17885f
C1263 _126_.B1 a_14438_12210# 0.02033f
C1264 _266_.CLK a_12518_16434# 0.02363f
C1265 a_16079_8797# a_15985_8797# 0.15029f
C1266 a_14820_11464# a_15108_11885# 0.22255f
C1267 _225_.A a_10308_17933# 0.01757f
C1268 _243_.D VDD 0.29461f
C1269 _179_.Y _171_.Y 0.02529f
C1270 a_3300_4968# a_4559_4727# 0.01303f
C1271 a_13366_13350# _129_.B1 0.04934f
C1272 a_1580_16710# VDD 0.19607f
C1273 _124_.S _247_.CLK 0.28832f
C1274 _176_.A a_10672_12430# 0.01591f
C1275 _251_.CLK _136_.B 0.07486f
C1276 a_11082_12508# VDD 0.23968f
C1277 _243_.Q a_6810_3863# 0.01938f
C1278 _202_.Y a_7008_16035# 0.20012f
C1279 _148_.A a_6747_5468# 0.01344f
C1280 _157_.Y a_13073_7728# 0.04161f
C1281 a_9120_9501# VDD 0.16853f
C1282 _124_.S a_2232_7868# 0.12651f
C1283 a_14054_15234# a_14340_15552# 0.21832f
C1284 a_14314_15457# a_14757_15213# 0.02242f
C1285 a_2565_16725# a_3313_16823# 0.01058f
C1286 _210_.A a_6756_4663# 0.01958f
C1287 _168_.A _180_.X 0.17809f
C1288 _119_.A0 a_3380_13690# 0.08592f
C1289 _136_.A a_6885_4629# 0.01998f
C1290 _191_.Y _192_.B 0.06695f
C1291 a_2436_8440# a_2955_8447# 0.18362f
C1292 a_2853_8447# a_2724_8861# 0.01562f
C1293 a_8292_17064# a_9551_16823# 0.01303f
C1294 a_4554_3900# VDD 0.24558f
C1295 _242_.RESET_B a_3717_4629# 0.02692f
C1296 a_10607_4727# a_11274_4948# 0.06982f
C1297 a_2126_10214# a_2232_10210# 0.22783f
C1298 _225_.A _236_.A 0.43212f
C1299 a_10764_5678# _139_.X 0.1967f
C1300 a_9765_4629# a_9636_4663# 0.01562f
C1301 _210_.A a_6095_4270# 0.0267f
C1302 _133_.Y _132_.Y 0.09553f
C1303 a_2565_16725# VDD 0.24699f
C1304 _119_.A0 a_2148_12976# 0.03832f
C1305 _166_.A _154_.X 0.97236f
C1306 _126_.B1 _260_.CLK 0.39995f
C1307 _243_.RESET_B a_3887_4261# 0.07596f
C1308 a_13100_13686# VDD 0.19995f
C1309 _181_.Y VDD 0.43368f
C1310 _215_.A _220_.Y 0.09753f
C1311 a_14730_15996# _264_.Q 0.0722f
C1312 a_14820_8440# a_16079_8797# 0.01303f
C1313 _136_.A _145_.A2 0.03214f
C1314 a_14794_11428# a_14820_11464# 0.21121f
C1315 _168_.B VDD 0.42987f
C1316 _237_.Y VDD 1.09914f
C1317 a_2126_17774# a_2232_17770# 0.22783f
C1318 a_8006_16746# a_8709_16725# 0.02454f
C1319 a_3014_4650# a_3300_4968# 0.21832f
C1320 _207_.A2 a_5376_17061# 0.2449f
C1321 a_3274_4873# a_3717_4629# 0.02242f
C1322 _260_.CLK a_14357_12972# 0.01049f
C1323 a_9156_12528# a_10321_12287# 0.22369f
C1324 a_9675_12332# a_9444_12223# 0.06628f
C1325 _134_.Y VDD 0.41028f
C1326 _166_.A a_10408_7806# 0.01224f
C1327 _225_.A _145_.X 1.70415f
C1328 a_8538_5375# VDD 0.17344f
C1329 _243_.Q a_3887_4261# 0.01787f
C1330 _263_.CLK _133_.Y 0.22144f
C1331 a_4625_16800# a_4796_17044# 0.19823f
C1332 _171_.A _171_.Y 0.53426f
C1333 _266_.CLK _237_.Y 0.05507f
C1334 a_6197_13342# _192_.C 0.02143f
C1335 a_3664_16238# a_4074_15996# 0.05221f
C1336 _186_.Y _164_.Y 0.01396f
C1337 _210_.A a_6885_4629# 0.01464f
C1338 _236_.A _131_.Y 0.03624f
C1339 a_2150_8874# a_2410_8404# 0.39302f
C1340 a_14859_15356# VDD 0.20572f
C1341 a_14919_16964# a_14940_16710# 0.18362f
C1342 a_15071_17016# a_15861_16904# 0.02242f
C1343 a_2628_3904# VDD 0.1176f
C1344 _153_.Y a_13019_6460# 0.0855f
C1345 a_9348_4968# a_10607_4727# 0.01303f
C1346 a_10308_17933# a_10539_17519# 0.06628f
C1347 _131_.B1 a_14438_12210# 0.02875f
C1348 _250_.RESET_B VDD 1.10419f
C1349 _120_.A0 _187_.Y 0.36694f
C1350 _243_.RESET_B a_2602_3868# 0.15332f
C1351 _173_.Y _168_.A 0.32783f
C1352 _157_.Y _162_.Y 0.09262f
C1353 _128_.B1 a_12886_13350# 0.04766f
C1354 a_5468_12508# _176_.B 0.05279f
C1355 a_9130_13945# a_8870_13722# 0.39302f
C1356 _136_.A _139_.X 0.05442f
C1357 _180_.X VDD 0.20027f
C1358 _239_.Y a_14757_15213# 0.02788f
C1359 _226_.Y a_14438_5850# 0.0932f
C1360 _171_.A a_8014_8492# 0.0324f
C1361 a_5800_9318# VDD 0.13945f
C1362 a_13323_16007# a_14063_16357# 0.15395f
C1363 a_12704_11546# VDD 0.08742f
C1364 a_14534_8874# a_15237_8447# 0.02432f
C1365 _148_.A _244_.RESET_B 0.02695f
C1366 a_3819_4772# VDD 0.22951f
C1367 a_2232_17770# _124_.S 0.11951f
C1368 _225_.A _170_.B 0.01803f
C1369 _136_.A a_5372_9484# 0.01268f
C1370 _236_.A a_14820_11464# 0.01575f
C1371 _149_.A VDD 0.76712f
C1372 _266_.CLK a_14859_15356# 0.02663f
C1373 clkbuf_1_0__f_sclk.A a_5201_9240# 0.0132f
C1374 _205_.B1 _186_.Y 0.13656f
C1375 a_2126_10214# a_2298_10318# 0.0308f
C1376 _195_.Y a_5050_15238# 0.01728f
C1377 _251_.CLK _144_.B 0.10866f
C1378 _148_.B _191_.Y 0.01279f
C1379 a_7074_15532# VDD 0.08256f
C1380 _138_.Y _136_.B 0.43564f
C1381 a_2494_6166# _244_.D 0.13304f
C1382 _168_.B a_6528_8475# 0.1904f
C1383 a_7008_16035# _258_.D 0.12102f
C1384 _126_.B1 _129_.B1 0.11065f
C1385 _214_.Y a_10020_17512# 0.02576f
C1386 a_15243_12332# a_15012_12223# 0.06628f
C1387 a_14724_12528# a_15889_12287# 0.22369f
C1388 fanout6.A a_12529_16823# 0.01144f
C1389 _230_.Y a_10672_13942# 0.06198f
C1390 a_15237_9165# a_15237_8447# 0.01653f
C1391 _185_.Y a_7157_9948# 0.08755f
C1392 _227_.Y _166_.A 0.02709f
C1393 a_2148_16000# a_2667_16007# 0.18362f
C1394 _145_.A2 a_8557_4248# 0.01207f
C1395 a_2565_16007# a_2436_16421# 0.01562f
C1396 _225_.A _240_.Y 0.06211f
C1397 _120_.X VDD 0.27006f
C1398 _173_.Y a_6218_10296# 0.01663f
C1399 _189_.X _190_.A 0.36162f
C1400 a_12215_7664# a_12549_7996# 0.07344f
C1401 _259_.RESET_B a_8811_16868# 0.21556f
C1402 fanout7.A a_8427_16007# 0.03428f
C1403 _260_.CLK _131_.B1 1.0827f
C1404 a_13820_4948# VDD 0.11851f
C1405 a_9322_4873# a_9348_4968# 0.21121f
C1406 a_8352_11013# a_8501_10702# 0.17527f
C1407 a_9994_17476# a_10020_17512# 0.21121f
C1408 _190_.A a_6048_13011# 0.10662f
C1409 _135_.A a_14320_16238# 0.01111f
C1410 clkbuf_1_0__f_sclk.A _122_.A0 0.03312f
C1411 _235_.Y a_15141_12189# 0.02791f
C1412 _162_.B _160_.B 0.26726f
C1413 _168_.Y _170_.B 0.17408f
C1414 a_5297_12264# _176_.B 0.12847f
C1415 _176_.B _178_.B1 0.07185f
C1416 a_12804_16000# a_13092_16421# 0.22255f
C1417 _260_.RESET_B a_16336_9406# 0.06198f
C1418 _186_.Y _183_.Y 0.01195f
C1419 _118_.X a_1862_16434# 0.02436f
C1420 _189_.X a_5888_13854# 0.01147f
C1421 a_2398_5782# a_2512_5782# 0.0308f
C1422 a_1864_6294# VDD 0.13325f
C1423 a_3695_9263# a_3601_9263# 0.15029f
C1424 _210_.A a_3300_4968# 0.01236f
C1425 _218_.Y a_2410_8404# 0.138f
C1426 _131_.A2 VDD 1.44815f
C1427 _149_.A a_13121_6188# 0.01232f
C1428 _243_.CLK a_3300_4968# 0.08656f
C1429 _238_.Y a_15861_16904# 0.13388f
C1430 a_4456_13058# VDD 0.12972f
C1431 _173_.Y VDD 0.62583f
C1432 _149_.A a_15983_5773# 0.02143f
C1433 _143_.A a_7872_5451# 0.08792f
C1434 _225_.A a_14698_5380# 0.02593f
C1435 _256_.RESET_B _182_.Y 0.08683f
C1436 _151_.B a_13824_7989# 0.01485f
C1437 a_2232_15428# a_2558_15532# 0.02726f
C1438 _153_.Y a_13244_7972# 0.01008f
C1439 _165_.Y a_7841_9212# 0.01177f
C1440 _160_.X a_13184_7183# 0.06176f
C1441 fanout6.A a_12623_16823# 0.01721f
C1442 a_6747_5468# VDD 0.20648f
C1443 _230_.Y a_8870_13722# 0.11496f
C1444 _173_.A _246_.D 0.02806f
C1445 _212_.Y VDD 0.29425f
C1446 a_13391_12287# a_13297_12287# 0.15029f
C1447 a_2398_5782# VDD 0.10958f
C1448 a_6958_13764# a_6760_13854# 0.01393f
C1449 a_10940_3900# VDD 0.11801f
C1450 a_1862_16434# a_2122_15964# 0.39302f
C1451 a_14534_9186# a_15108_9199# 0.16388f
C1452 a_6124_9945# _177_.X 0.09494f
C1453 _152_.X VDD 0.23795f
C1454 _119_.X VDD 0.28382f
C1455 a_10752_7989# a_10901_7678# 0.17527f
C1456 a_15071_17016# a_14830_16746# 0.01058f
C1457 a_14919_16964# a_15722_16904# 0.06628f
C1458 _225_.A fanout7.A 0.03673f
C1459 _215_.A a_1580_12936# 0.1615f
C1460 _171_.Y _136_.A 0.17289f
C1461 _148_.A a_7872_5451# 0.01028f
C1462 _118_.A0 a_1862_16434# 0.0476f
C1463 _263_.CLK a_16650_12508# 0.01314f
C1464 _243_.Q a_2494_6166# 0.2802f
C1465 _178_.B1 _177_.X 0.03767f
C1466 fanout6.A _200_.Y 0.01006f
C1467 _212_.Y _266_.CLK 0.05648f
C1468 _183_.Y _164_.Y 0.14357f
C1469 _118_.A0 _119_.A0 0.18262f
C1470 _192_.Y VDD 0.49466f
C1471 _164_.B1 a_12215_7664# 0.09779f
C1472 _178_.Y _185_.Y 0.13614f
C1473 a_3503_12287# a_3409_12287# 0.15029f
C1474 _261_.RESET_B a_13648_12430# 0.06198f
C1475 _172_.Y a_9269_9190# 0.03285f
C1476 a_12518_16434# a_12778_15964# 0.39302f
C1477 a_1580_16710# _118_.X 0.03119f
C1478 a_2218_12433# a_1958_12210# 0.39302f
C1479 _160_.X _166_.A 0.32127f
C1480 _222_.A a_1580_16710# 0.16031f
C1481 a_2436_9504# a_3601_9263# 0.22369f
C1482 _207_.A2 a_4625_16800# 0.01128f
C1483 a_2955_9308# a_2724_9199# 0.06628f
C1484 a_9167_16357# a_9073_16357# 0.15029f
C1485 _243_.Q a_2075_5468# 0.03947f
C1486 _138_.Y _144_.B 0.24973f
C1487 _178_.Y a_6389_9484# 0.10532f
C1488 a_6810_3863# a_6836_3900# 0.19823f
C1489 _250_.D a_1862_16434# 0.16726f
C1490 a_3664_13214# VDD 0.16186f
C1491 _252_.RESET_B a_9348_4968# 0.21735f
C1492 _136_.A a_8014_8492# 0.04976f
C1493 _240_.Y a_10539_17519# 0.21427f
C1494 _149_.A a_15141_5423# 0.02073f
C1495 a_7736_8802# _170_.Y 0.01426f
C1496 _152_.X a_12237_5760# 0.06176f
C1497 a_3588_5837# VDD 0.02127f
C1498 _243_.Q _147_.Y 0.21172f
C1499 _192_.C _192_.B 0.2037f
C1500 fanout7.A a_10672_13942# 0.01626f
C1501 a_11846_12210# a_12420_12223# 0.16388f
C1502 a_10020_9504# a_11279_9263# 0.01303f
C1503 a_12651_12332# a_13648_12430# 0.01528f
C1504 _186_.Y _185_.Y 0.14262f
C1505 _237_.Y a_14063_16357# 0.07576f
C1506 _173_.Y a_6528_8475# 0.02923f
C1507 a_8288_3986# VDD 0.07362f
C1508 _222_.Y a_1862_16434# 0.02214f
C1509 a_3407_13333# a_4074_12972# 0.06982f
C1510 a_14534_9186# a_15237_9165# 0.02454f
C1511 _225_.A a_13323_16007# 0.03715f
C1512 a_2126_13912# a_2298_13726# 0.0308f
C1513 _124_.S a_2436_9504# 0.02838f
C1514 a_12904_7010# VDD 0.14298f
C1515 _192_.B _176_.B 0.0803f
C1516 _133_.Y VDD 0.32756f
C1517 _201_.Y VDD 0.55833f
C1518 _122_.A0 a_2126_7864# 0.07772f
C1519 _164_.B1 a_10895_8436# 0.06053f
C1520 _176_.A a_9156_12528# 0.02745f
C1521 _263_.CLK a_14724_12528# 0.09609f
C1522 a_7727_4727# a_7633_4727# 0.15029f
C1523 _124_.S a_2122_12940# 0.01123f
C1524 a_9573_12189# VDD 0.25419f
C1525 a_3819_5423# a_4816_5654# 0.01569f
C1526 a_2232_17770# a_2558_17532# 0.02726f
C1527 _222_.Y a_3664_16966# 0.06198f
C1528 a_1958_12210# a_2532_12223# 0.16388f
C1529 _120_.A0 a_5468_12508# 0.01032f
C1530 clkload0.Y VDD 0.1135f
C1531 _244_.RESET_B VDD 1.0587f
C1532 _207_.A2 a_5619_17044# 0.01107f
C1533 a_2410_9409# VDD 0.09818f
C1534 _122_.A0 a_2436_8440# 0.07684f
C1535 _170_.B _170_.Y 0.20723f
C1536 _144_.B a_10799_5782# 0.02071f
C1537 _139_.X a_10607_4727# 0.02938f
C1538 _247_.CLK _119_.A0 0.11569f
C1539 _193_.Y _194_.X 0.03464f
C1540 _207_.A1 a_8266_16969# 0.01617f
C1541 _145_.A2 _252_.D 0.25393f
C1542 _118_.A0 a_2565_16725# 0.01087f
C1543 _256_.RESET_B _251_.CLK 0.0103f
C1544 a_6060_4166# a_6095_4270# 0.17527f
C1545 _225_.A a_15141_12189# 0.01335f
C1546 a_1862_13410# VDD 0.4499f
C1547 _205_.Y _208_.X 0.27386f
C1548 _131_.A2 _129_.Y 0.37889f
C1549 _143_.A _224_.Y 0.02076f
C1550 _263_.CLK a_12651_12332# 0.01443f
C1551 _224_.Y a_7984_4870# 0.06198f
C1552 _145_.X _157_.B 0.02143f
C1553 a_3014_5850# VDD 0.48872f
C1554 _145_.A2 _143_.Y 0.09615f
C1555 a_9734_9186# a_10437_9165# 0.02454f
C1556 a_11846_12210# a_12549_12189# 0.02454f
C1557 _237_.Y a_12778_15964# 0.16201f
C1558 _244_.RESET_B a_4559_5773# 0.07576f
C1559 _250_.RESET_B _118_.X 0.04185f
C1560 _220_.Y a_1958_12210# 0.11044f
C1561 a_2565_12983# a_2667_12983# 0.27006f
C1562 _222_.A _250_.RESET_B 0.13824f
C1563 _124_.S _173_.A 0.17782f
C1564 a_10415_12287# a_10321_12287# 0.15029f
C1565 a_9675_12332# _251_.CLK 0.01621f
C1566 _131_.A2 a_14240_13058# 0.01197f
C1567 _164_.B1 a_11731_8698# 0.18168f
C1568 a_14240_16921# a_14359_16710# 0.06982f
C1569 _196_.Y VDD 0.62338f
C1570 _215_.A a_5792_4782# 0.0123f
C1571 a_6987_4772# a_7984_4870# 0.01528f
C1572 _148_.A _224_.Y 0.01555f
C1573 a_6182_4650# a_6756_4663# 0.16388f
C1574 _145_.X _151_.X 0.20944f
C1575 _205_.Y a_6862_15260# 0.01839f
C1576 _191_.Y a_6779_12972# 0.0926f
C1577 _243_.Q _147_.B1 0.19332f
C1578 a_10218_17044# VDD 0.24038f
C1579 a_3300_5416# a_3588_5837# 0.22255f
C1580 _228_.Y a_11536_9406# 0.06198f
C1581 _222_.Y a_2565_16725# 0.02692f
C1582 _251_.CLK a_15243_5423# 0.04348f
C1583 a_1958_12210# a_2763_12332# 0.06896f
C1584 _250_.RESET_B a_2122_15964# 0.15035f
C1585 a_2244_12528# a_2661_12189# 0.22605f
C1586 a_2126_11726# VDD 0.10456f
C1587 _120_.A0 a_5297_12264# 0.05695f
C1588 _179_.Y _171_.A 0.01275f
C1589 _148_.B _192_.C 0.03385f
C1590 _171_.A a_7336_9318# 0.01445f
C1591 _207_.B1 VDD 0.20299f
C1592 a_2075_4692# a_2301_4948# 0.02726f
C1593 a_2150_9186# a_2436_9504# 0.21832f
C1594 a_7882_15964# a_8325_16007# 0.02242f
C1595 a_2955_8447# VDD 0.22435f
C1596 a_2410_9409# a_2853_9165# 0.02242f
C1597 a_11946_9484# _168_.A 0.08588f
C1598 a_11661_4696# VDD 0.25332f
C1599 a_15243_5423# a_16240_5654# 0.01569f
C1600 _118_.A0 _250_.RESET_B 0.03364f
C1601 _145_.A2 a_8394_4948# 0.06693f
C1602 fanout6.A _135_.A 0.10537f
C1603 _148_.B _176_.B 0.04961f
C1604 _236_.A _186_.Y 0.02235f
C1605 _264_.Q VDD 0.3675f
C1606 a_16336_8678# VDD 0.12548f
C1607 _158_.Y _166_.A 0.03692f
C1608 _145_.X a_13649_4704# 0.08988f
C1609 a_8811_16868# VDD 0.20479f
C1610 a_2565_16725# _247_.CLK 0.1523f
C1611 _260_.CLK a_16079_11821# 0.01907f
C1612 _251_.CLK a_15776_7806# 0.01543f
C1613 _219_.Y VDD 1.05061f
C1614 _244_.RESET_B a_3300_5416# 0.24505f
C1615 a_1862_13410# a_2148_12976# 0.21832f
C1616 _219_.Y a_3952_9406# 0.06198f
C1617 a_12549_7996# VDD 0.2016f
C1618 _225_.A a_14628_15247# 0.01055f
C1619 a_12106_12433# VDD 0.09805f
C1620 _243_.D a_2240_3986# 0.01657f
C1621 _207_.A1 _259_.RESET_B 0.08764f
C1622 _250_.D _250_.RESET_B 0.06266f
C1623 _145_.A2 _252_.RESET_B 0.01217f
C1624 _221_.Y VDD 1.09416f
C1625 _172_.Y _168_.A 0.01649f
C1626 a_7872_5451# VDD 0.18339f
C1627 _266_.CLK _264_.Q 0.36521f
C1628 a_16079_11821# a_15985_11821# 0.15029f
C1629 _133_.Y _129_.Y 0.0395f
C1630 _131_.A2 _235_.Y 0.05249f
C1631 _215_.A a_4816_4870# 0.01302f
C1632 _185_.Y _183_.Y 0.13325f
C1633 a_6182_4650# a_6885_4629# 0.02454f
C1634 _168_.A a_7739_9484# 0.01022f
C1635 a_11338_16969# _241_.Y 0.13427f
C1636 _157_.B a_13775_5782# 0.02071f
C1637 _243_.Q a_11274_4948# 0.01015f
C1638 a_3014_5850# a_3300_5416# 0.21832f
C1639 _145_.X _138_.Y 0.0168f
C1640 _228_.Y a_10437_9165# 0.02692f
C1641 _119_.A0 a_5084_12972# 0.01008f
C1642 _250_.RESET_B _222_.Y 0.14402f
C1643 a_16650_12508# VDD 0.24129f
C1644 _120_.A0 a_2244_12528# 0.0625f
C1645 _225_.A _237_.Y 0.02609f
C1646 _148_.B a_4913_13330# 0.23244f
C1647 _145_.X _159_.Y 0.08531f
C1648 a_2667_16007# VDD 0.21081f
C1649 _173_.A a_2150_9186# 0.03671f
C1650 _250_.Q a_3407_16823# 0.02316f
C1651 _160_.X a_12328_8522# 0.01251f
C1652 a_10539_9308# _168_.A 0.01983f
C1653 a_14572_16746# VDD 0.12602f
C1654 a_9765_4629# VDD 0.2612f
C1655 a_15599_15311# a_16266_15532# 0.06982f
C1656 a_14724_5416# a_15243_5423# 0.18362f
C1657 a_15141_5423# a_15012_5837# 0.01562f
C1658 a_3045_3911# a_3793_4261# 0.01058f
C1659 _136_.A _154_.X 0.06322f
C1660 fanout7.A _251_.CLK 0.03146f
C1661 a_11338_16969# a_11781_16725# 0.02242f
C1662 a_6442_4873# VDD 0.09586f
C1663 _241_.Y a_11364_17064# 0.24377f
C1664 _225_.A a_8538_5375# 0.04184f
C1665 a_14534_8874# VDD 0.44684f
C1666 _250_.RESET_B _247_.CLK 0.02593f
C1667 _148_.B _171_.Y 0.0527f
C1668 _260_.CLK a_12923_11460# 0.04645f
C1669 _179_.Y _184_.Y 0.01458f
C1670 _184_.Y a_7336_9318# 0.01018f
C1671 _205_.Y VDD 0.50314f
C1672 a_11946_9484# VDD 0.24319f
C1673 _122_.A0 _148_.A 0.18189f
C1674 _219_.Y a_2853_9165# 0.02692f
C1675 a_8990_5412# VDD 0.01094f
C1676 _225_.A a_14859_15356# 0.06927f
C1677 _210_.B _136_.B 0.02896f
C1678 _164_.Y _145_.X 0.06789f
C1679 a_15237_9165# VDD 0.24215f
C1680 _148_.X a_12572_4948# 0.07789f
C1681 _266_.CLK a_13092_16421# 0.01461f
C1682 a_11364_17064# a_11781_16725# 0.22605f
C1683 a_11078_16746# a_11883_16868# 0.06896f
C1684 _215_.A a_3300_4968# 0.04481f
C1685 _131_.A2 a_13391_12287# 0.02926f
C1686 _191_.Y a_7232_14570# 0.01769f
C1687 _168_.B _168_.Y 0.04325f
C1688 _225_.A _180_.X 0.03129f
C1689 a_3717_4629# a_4465_4727# 0.01058f
C1690 _148_.X VDD 0.53793f
C1691 _164_.B1 VDD 0.64688f
C1692 _157_.Y a_13019_6460# 0.02762f
C1693 _221_.Y a_2148_12976# 0.22195f
C1694 a_14724_12528# VDD 0.07224f
C1695 a_2232_13916# _120_.A0 0.06334f
C1696 _225_.A _149_.A 0.02979f
C1697 a_2232_11722# _173_.A 0.09983f
C1698 _176_.A a_11456_12342# 0.01526f
C1699 _251_.CLK a_9867_4772# 0.05483f
C1700 _172_.Y VDD 0.27248f
C1701 _261_.RESET_B VDD 1.09068f
C1702 _250_.Q a_2148_17064# 0.02042f
C1703 _160_.X a_10989_8784# 0.02017f
C1704 _128_.B1 _260_.CLK 0.20814f
C1705 a_7985_7728# VDD 0.16912f
C1706 _157_.Y _157_.B 0.43552f
C1707 a_7739_9484# VDD 0.17778f
C1708 _207_.A1 _208_.X 0.8214f
C1709 a_3407_16823# a_3313_16823# 0.15029f
C1710 a_14340_15552# a_15599_15311# 0.01303f
C1711 a_14698_5380# a_14724_5416# 0.21121f
C1712 a_2342_4338# a_3147_3911# 0.06896f
C1713 a_2232_15428# VDD 0.53005f
C1714 a_8709_16725# a_9457_16823# 0.01058f
C1715 a_3952_8678# a_3695_8797# 0.20069f
C1716 _158_.Y a_13403_8436# 0.09026f
C1717 a_6810_3863# VDD 0.17006f
C1718 _242_.RESET_B a_4816_4870# 0.06198f
C1719 a_10607_4727# a_10513_4727# 0.15029f
C1720 _164_.Y _170_.B 0.02526f
C1721 a_3407_16823# VDD 0.18969f
C1722 _119_.A0 a_4074_12972# 0.08526f
C1723 _173_.Y a_6483_9212# 0.01284f
C1724 _187_.Y a_5297_12264# 0.01316f
C1725 a_12651_12332# VDD 0.20462f
C1726 a_10539_9308# VDD 0.20554f
C1727 _182_.Y _181_.Y 0.03433f
C1728 fanout6.A _214_.A 0.24742f
C1729 a_9156_14040# a_10321_13799# 0.22369f
C1730 clkbuf_1_0__f_sclk.A _174_.Y 0.02499f
C1731 a_9675_13844# a_9444_13735# 0.06628f
C1732 a_6747_5468# a_6949_5782# 0.01117f
C1733 _210_.B a_6656_5498# 0.01295f
C1734 _165_.Y _170_.B 0.44283f
C1735 a_16079_8797# a_16746_8436# 0.06982f
C1736 _224_.Y VDD 1.0908f
C1737 _184_.Y _171_.A 0.34539f
C1738 fanout7.A a_16746_8436# 0.04984f
C1739 _148_.A a_2494_6166# 0.08909f
C1740 _160_.B a_13824_7989# 0.11854f
C1741 _124_.S a_2667_16868# 0.04055f
C1742 _176_.A a_10415_12287# 0.02138f
C1743 _225_.A _131_.A2 0.03945f
C1744 a_10672_12430# VDD 0.12701f
C1745 _148_.B _166_.A 0.03119f
C1746 _122_.A0 _168_.A 0.03421f
C1747 a_2148_17064# a_3313_16823# 0.22369f
C1748 a_6987_4772# VDD 0.20927f
C1749 a_2667_16868# a_2436_16759# 0.06628f
C1750 a_14314_15457# a_14340_15552# 0.21121f
C1751 _133_.Y a_13391_12287# 0.01432f
C1752 _148_.B _120_.A0 0.31111f
C1753 _136_.A a_6468_4968# 0.01478f
C1754 _201_.Y _199_.Y 0.13085f
C1755 a_2436_8440# a_2724_8861# 0.22255f
C1756 _162_.B VDD 0.92665f
C1757 a_3887_4261# VDD 0.20005f
C1758 a_15767_17137# _211_.Y 0.16513f
C1759 _242_.RESET_B a_3300_4968# 0.23331f
C1760 a_10220_18222# _236_.A 0.14297f
C1761 _148_.A _147_.Y 0.05212f
C1762 a_9348_4968# a_9636_4663# 0.22255f
C1763 a_11279_17869# a_11185_17869# 0.15029f
C1764 a_10607_4727# a_10864_4870# 0.20069f
C1765 a_14359_16710# a_14830_16746# 0.15029f
C1766 a_2148_17064# VDD 0.07863f
C1767 _145_.X _153_.Y 0.01783f
C1768 _243_.RESET_B a_4144_4142# 0.06071f
C1769 _171_.A _136_.A 0.15097f
C1770 _128_.B1 _129_.B1 0.21459f
C1771 _157_.Y a_13244_7972# 0.02445f
C1772 _215_.A a_1568_12342# 0.01317f
C1773 a_15237_8447# a_15339_8447# 0.27006f
C1774 a_5226_4948# VDD 0.24163f
C1775 a_14534_11898# a_15237_11471# 0.02432f
C1776 a_5201_9240# VDD 0.16459f
C1777 _210_.A a_5608_4782# 0.02662f
C1778 a_8006_16746# a_8292_17064# 0.21832f
C1779 a_8266_16969# a_8709_16725# 0.02242f
C1780 _147_.A1 a_11661_4696# 0.04593f
C1781 a_3274_4873# a_3300_4968# 0.21121f
C1782 _210_.A a_2398_4654# 0.27941f
C1783 _131_.A2 _131_.Y 0.02221f
C1784 a_9573_12189# a_9444_12223# 0.01562f
C1785 a_12992_15437# VDD 0.26576f
C1786 _151_.B a_13184_7183# 0.11942f
C1787 _173_.Y _168_.Y 0.01462f
C1788 _189_.X _192_.C 0.04002f
C1789 _208_.X a_6720_17061# 0.20261f
C1790 _243_.Q a_4144_4142# 0.0108f
C1791 _236_.A _214_.A 0.04842f
C1792 _187_.Y _192_.B 0.45707f
C1793 a_13883_11460# VDD 0.16593f
C1794 _236_.Y a_16079_11821# 0.07576f
C1795 _190_.A a_11082_14020# 0.07007f
C1796 a_3664_16238# a_3407_16357# 0.20069f
C1797 a_6048_13011# _192_.C 0.12413f
C1798 _236_.A a_10415_13799# 0.01138f
C1799 _210_.A a_6468_4968# 0.02489f
C1800 _236_.A fanout6.A 0.0846f
C1801 _162_.Y a_12549_7996# 0.03305f
C1802 a_7616_15437# _193_.Y 0.07828f
C1803 a_14757_15213# VDD 0.25553f
C1804 _207_.A1 VDD 0.78279f
C1805 a_15071_17016# a_15767_17137# 0.02432f
C1806 _131_.A2 a_14820_11464# 0.01716f
C1807 a_2602_3868# VDD 0.09944f
C1808 a_16336_9406# a_16746_9484# 0.05221f
C1809 a_10020_17512# a_11279_17869# 0.01303f
C1810 _196_.Y _199_.Y 0.27839f
C1811 _122_.A0 VDD 1.62429f
C1812 _243_.CLK a_3147_3911# 0.01615f
C1813 _247_.CLK clkload0.Y 0.0773f
C1814 fanout6.A a_4755_17508# 0.0138f
C1815 fanout7.A _135_.A 0.01388f
C1816 _207_.Y _207_.B1 0.13736f
C1817 _239_.Y a_14340_15552# 0.23747f
C1818 _118_.A0 a_2298_17532# 0.01292f
C1819 _151_.B _166_.A 0.02958f
C1820 a_13323_16007# a_14320_16238# 0.01569f
C1821 a_14534_8874# a_14820_8440# 0.21832f
C1822 a_3717_4629# VDD 0.25578f
C1823 a_11974_8436# _166_.A 0.01009f
C1824 _131_.A2 a_14651_10996# 0.07183f
C1825 a_2126_17774# _124_.S 0.07858f
C1826 _218_.Y a_3695_8797# 0.07576f
C1827 _259_.RESET_B a_9808_16966# 0.06212f
C1828 _236_.A a_14794_11428# 0.02365f
C1829 _266_.CLK a_14757_15213# 0.15785f
C1830 _210_.A a_4559_4727# 0.01497f
C1831 _148_.A _147_.B1 0.01861f
C1832 _250_.RESET_B rst 0.01556f
C1833 a_6862_15532# VDD 0.13876f
C1834 a_2494_6166# a_2671_6460# 0.01057f
C1835 a_2171_6204# _244_.D 0.01321f
C1836 a_7008_16035# a_7157_16366# 0.17527f
C1837 _214_.Y a_9994_17476# 0.01845f
C1838 a_2126_7864# a_2558_7972# 0.02903f
C1839 _126_.B1 a_13366_13350# 0.04497f
C1840 _189_.X a_4913_13330# 0.13008f
C1841 _151_.B a_13740_5678# 0.02971f
C1842 a_15141_12189# a_15012_12223# 0.01562f
C1843 _230_.Y a_10415_13799# 0.07574f
C1844 _176_.B _176_.A 0.3623f
C1845 _246_.D a_2150_9186# 0.14963f
C1846 _120_.A0 _215_.A 0.01934f
C1847 a_14534_11898# VDD 0.44687f
C1848 _190_.A a_9156_14040# 0.01198f
C1849 a_2148_16000# a_2436_16421# 0.22255f
C1850 _222_.A _205_.Y 0.03702f
C1851 _243_.Q _139_.X 0.06343f
C1852 a_2218_12433# VDD 0.09846f
C1853 _135_.X a_12416_16082# 0.01868f
C1854 _199_.B1 VDD 0.63245f
C1855 _259_.RESET_B a_8709_16725# 0.02875f
C1856 a_12886_13350# VDD 0.01105f
C1857 a_8156_7972# _154_.X 0.05579f
C1858 a_13617_4972# VDD 0.01089f
C1859 _243_.Q a_3300_4968# 0.03444f
C1860 _252_.D a_9062_4650# 0.14363f
C1861 a_14820_9504# a_16079_9263# 0.01303f
C1862 a_9734_17946# a_10437_17519# 0.02432f
C1863 a_9322_4873# a_9062_4650# 0.39302f
C1864 _178_.B1 _184_.Y 0.0167f
C1865 _251_.CLK _180_.X 0.79184f
C1866 a_10437_17519# VDD 0.2562f
C1867 _195_.Y VDD 0.43008f
C1868 _135_.A a_13323_16007# 0.02741f
C1869 _162_.B a_13073_7728# 0.21956f
C1870 a_14698_12433# a_15141_12189# 0.02242f
C1871 _235_.Y a_14724_12528# 0.23511f
C1872 a_5297_12264# a_5468_12508# 0.19823f
C1873 _251_.CLK _149_.A 0.08815f
C1874 fanout8.A _207_.A2 0.03874f
C1875 _260_.RESET_B a_16079_9263# 0.07574f
C1876 _176_.B a_6485_11830# 0.02636f
C1877 _122_.A0 a_6528_8475# 0.01665f
C1878 _124_.S a_1864_5498# 0.01205f
C1879 a_2398_5782# a_2301_5782# 0.01625f
C1880 a_2494_6166# VDD 0.10548f
C1881 _210_.A a_3014_4650# 0.02415f
C1882 _148_.B _187_.Y 0.41763f
C1883 _243_.CLK a_3014_4650# 0.02794f
C1884 _124_.S a_2436_16759# 0.02635f
C1885 _238_.Y a_15767_17137# 0.07661f
C1886 _149_.A a_13019_6460# 0.02391f
C1887 _252_.RESET_B a_10864_4870# 0.06208f
C1888 _149_.A a_16240_5654# 0.01544f
C1889 _148_.B _179_.Y 0.34414f
C1890 _256_.RESET_B a_9130_12433# 0.16101f
C1891 a_2232_15428# a_2298_15532# 0.03308f
C1892 a_15141_12189# a_15243_12332# 0.26919f
C1893 _213_.Y a_14534_9186# 0.16057f
C1894 fanout6.A _240_.Y 0.10812f
C1895 _149_.A _157_.B 0.09241f
C1896 a_10888_16878# VDD 0.14969f
C1897 _230_.Y a_9130_13945# 0.16101f
C1898 a_10437_9165# a_11185_9263# 0.01058f
C1899 _190_.A VDD 0.81917f
C1900 _148_.B a_12328_8522# 0.01593f
C1901 clkbuf_1_0__f_sclk.A _176_.B 0.02917f
C1902 a_10737_3900# VDD 0.01074f
C1903 a_2075_5468# VDD 0.51727f
C1904 _205_.Y _199_.Y 0.26143f
C1905 _225_.A _264_.Q 0.08606f
C1906 a_2126_13912# VDD 0.10471f
C1907 _247_.CLK _221_.Y 0.03203f
C1908 a_6720_17061# VDD 0.17423f
C1909 _153_.Y _157_.Y 0.4774f
C1910 _129_.Y a_13883_11460# 0.0857f
C1911 _148_.B a_12132_12528# 0.05098f
C1912 _186_.Y _181_.Y 0.03282f
C1913 _145_.X a_11381_3900# 0.01131f
C1914 _147_.Y VDD 0.58412f
C1915 _243_.Q a_2171_6204# 0.06352f
C1916 _263_.CLK a_16240_12430# 0.04387f
C1917 _178_.B1 a_6124_9945# 0.13736f
C1918 _149_.A _151_.X 0.05362f
C1919 _118_.A0 a_2232_15428# 0.04017f
C1920 a_5888_13854# VDD 0.07244f
C1921 _247_.CLK a_2667_16007# 0.04035f
C1922 _236_.A _256_.RESET_B 0.10373f
C1923 _220_.Y VDD 1.08478f
C1924 _236_.A _230_.Y 0.06598f
C1925 _261_.RESET_B a_13391_12287# 0.07574f
C1926 _151_.B a_13403_8436# 0.07868f
C1927 _122_.A0 a_4362_8436# 0.08686f
C1928 a_10769_4258# a_10940_3900# 0.19823f
C1929 _136_.A _210_.A 0.01858f
C1930 a_2853_9165# a_2724_9199# 0.01562f
C1931 _164_.Y a_9120_9501# 0.10819f
C1932 a_9167_16357# a_9834_15996# 0.06982f
C1933 a_8488_8436# VDD 0.16672f
C1934 _138_.Y a_8538_5375# 0.05914f
C1935 a_2667_12983# VDD 0.20996f
C1936 _252_.RESET_B a_9062_4650# 0.08054f
C1937 _149_.A a_14724_5416# 0.02807f
C1938 clkbuf_1_0__f_sclk.A a_4913_13330# 0.01451f
C1939 _162_.B _162_.Y 0.12819f
C1940 a_3664_16966# a_4074_17044# 0.05221f
C1941 fanout7.A a_10415_13799# 0.02576f
C1942 _151_.X a_13820_4948# 0.05498f
C1943 a_2763_12332# VDD 0.21341f
C1944 fanout6.A fanout7.A 0.73559f
C1945 _237_.Y a_14320_16238# 0.0605f
C1946 a_12651_12332# a_13391_12287# 0.15395f
C1947 a_14534_9186# a_14820_9504# 0.21832f
C1948 _222_.A a_2148_17064# 0.03077f
C1949 _220_.Y a_3760_12430# 0.06198f
C1950 a_14794_9409# a_15237_9165# 0.02242f
C1951 _181_.Y _164_.Y 0.12703f
C1952 a_3664_13214# a_4074_12972# 0.05221f
C1953 _225_.A a_14534_8874# 0.04429f
C1954 _124_.S a_2150_9186# 0.03844f
C1955 _148_.B _171_.A 0.1291f
C1956 _120_.X _173_.A 0.02533f
C1957 _258_.RESET_B _258_.D 0.04978f
C1958 _250_.Q a_4462_16052# 0.04602f
C1959 _126_.B1 a_14357_12972# 0.07735f
C1960 _176_.A a_8870_12210# 0.0214f
C1961 a_14534_9186# _260_.RESET_B 0.09166f
C1962 a_9156_12528# VDD 0.07699f
C1963 a_2232_17770# a_2298_17532# 0.03308f
C1964 a_2126_17774# a_2558_17532# 0.02903f
C1965 _236_.A _240_.Y 0.48248f
C1966 _222_.Y a_3407_16823# 0.07574f
C1967 _250_.RESET_B a_3407_16357# 0.07584f
C1968 a_6958_13764# _192_.Y 0.15564f
C1969 a_2763_12332# a_3760_12430# 0.01528f
C1970 _207_.A2 a_4796_17044# 0.01422f
C1971 _186_.Y a_7074_15532# 0.01277f
C1972 a_13649_4704# a_13820_4948# 0.19823f
C1973 clkbuf_1_0__f_sclk.A a_5704_13854# 0.01112f
C1974 _122_.A0 a_2410_8404# 0.04832f
C1975 _202_.Y VDD 0.39469f
C1976 _260_.CLK _132_.Y 0.08919f
C1977 _243_.CLK _210_.A 0.1041f
C1978 _153_.Y _161_.Y 0.41423f
C1979 _144_.B a_10592_5498# 0.01168f
C1980 a_7908_16000# a_9167_16357# 0.01303f
C1981 _225_.A _164_.B1 0.01197f
C1982 _147_.B1 VDD 0.23047f
C1983 _225_.A a_14724_12528# 0.02371f
C1984 _193_.Y a_8156_14020# 0.02669f
C1985 _118_.A0 a_2148_17064# 0.04791f
C1986 _256_.RESET_B a_9675_12332# 0.21556f
C1987 a_5376_17061# _208_.X 0.02957f
C1988 _173_.A _173_.Y 0.20005f
C1989 _135_.A _237_.Y 0.0265f
C1990 a_11883_16868# VDD 0.20211f
C1991 _263_.CLK a_12549_12189# 0.15136f
C1992 _224_.Y a_7727_4727# 0.07574f
C1993 _162_.B a_10752_7989# 0.11158f
C1994 fanout6.A a_13323_16007# 0.01338f
C1995 a_2667_16868# a_3664_16966# 0.01528f
C1996 _222_.A _207_.A1 0.05803f
C1997 a_9734_9186# a_10020_9504# 0.21832f
C1998 _173_.Y _178_.Y 0.42503f
C1999 a_11846_12210# a_12132_12528# 0.21832f
C2000 _148_.B _160_.X 0.07048f
C2001 _244_.RESET_B a_4816_5654# 0.0605f
C2002 _135_.A _134_.Y 0.10182f
C2003 _124_.S a_2232_11722# 0.13509f
C2004 a_2565_12983# a_2436_13397# 0.01562f
C2005 a_2148_12976# a_2667_12983# 0.18362f
C2006 _164_.Y _180_.X 0.15916f
C2007 a_12712_5498# VDD 0.14615f
C2008 _250_.D a_2148_17064# 0.05045f
C2009 a_9573_12189# _251_.CLK 0.15509f
C2010 _263_.CLK _260_.CLK 0.11899f
C2011 _215_.A a_5608_4782# 0.01181f
C2012 _207_.A1 a_5147_15996# 0.03226f
C2013 a_6987_4772# a_7727_4727# 0.15395f
C2014 _215_.A a_2398_4654# 0.01166f
C2015 a_9808_16966# VDD 0.12654f
C2016 _228_.Y a_11279_9263# 0.07574f
C2017 a_2122_16969# a_2565_16725# 0.02242f
C2018 _222_.Y a_2148_17064# 0.22683f
C2019 a_1192_11460# VDD 0.1652f
C2020 a_1958_12210# a_2661_12189# 0.02454f
C2021 _120_.A0 a_4170_12508# 0.09295f
C2022 _181_.Y _183_.Y 0.04918f
C2023 _236_.A fanout7.A 0.12391f
C2024 a_4462_16052# VDD 0.15303f
C2025 _136_.A _145_.B1 0.05452f
C2026 _122_.A0 a_7712_7806# 0.0124f
C2027 a_2075_4692# a_2398_4654# 0.22783f
C2028 _235_.Y a_14534_11898# 0.0251f
C2029 a_7882_15964# a_7908_16000# 0.21121f
C2030 a_2410_9409# a_2436_9504# 0.21121f
C2031 _126_.B1 _131_.B1 0.01231f
C2032 a_11536_9406# _168_.A 0.01216f
C2033 _211_.Y VDD 0.33795f
C2034 a_16266_15532# _263_.CLK 0.07035f
C2035 a_11274_4948# VDD 0.24356f
C2036 _143_.A _145_.A2 0.28791f
C2037 _174_.Y _168_.A 0.60943f
C2038 _236_.A _126_.Y 0.0854f
C2039 _148_.B a_5468_12508# 0.03227f
C2040 _129_.B1 a_13648_12430# 0.03515f
C2041 _207_.Y _207_.A1 0.06567f
C2042 fanout8.A _215_.A 0.16415f
C2043 _222_.A _199_.B1 0.02542f
C2044 a_15339_8447# VDD 0.20442f
C2045 _118_.A0 a_2298_17878# 0.01667f
C2046 fanout6.A a_12518_16434# 0.05767f
C2047 a_2148_17064# _247_.CLK 0.06601f
C2048 a_2565_16725# a_2667_16868# 0.26919f
C2049 a_8709_16725# VDD 0.24747f
C2050 _201_.Y _200_.Y 0.07093f
C2051 _260_.CLK a_16336_11702# 0.01174f
C2052 a_17120_10034# VDD 0.07051f
C2053 _120_.A0 a_2298_13726# 0.02012f
C2054 _244_.RESET_B a_3274_5380# 0.13595f
C2055 _120_.A0 clkbuf_1_0__f_sclk.A 0.0498f
C2056 _131_.B1 a_14357_12972# 0.08895f
C2057 _213_.Y VDD 0.23643f
C2058 a_1862_13410# a_2122_12940# 0.39302f
C2059 _129_.B1 _132_.Y 0.02672f
C2060 _258_.RESET_B a_8325_16007# 0.02937f
C2061 _266_.CLK _211_.Y 0.02764f
C2062 a_8705_9212# _180_.X 0.01132f
C2063 _219_.Y a_3695_9263# 0.07574f
C2064 a_13824_7989# VDD 0.16826f
C2065 _148_.A _145_.A2 0.07894f
C2066 a_1580_12936# VDD 0.19604f
C2067 _124_.S a_2150_8874# 0.04436f
C2068 _187_.Y a_6779_12972# 0.03855f
C2069 a_11883_16868# a_12880_16966# 0.01528f
C2070 a_16079_11821# a_16746_11460# 0.06982f
C2071 _215_.A a_4559_4727# 0.02215f
C2072 _210_.B _210_.Y 0.0403f
C2073 _120_.A0 a_2565_12983# 0.01064f
C2074 _131_.A2 a_14698_12433# 0.01326f
C2075 a_6182_4650# a_6468_4968# 0.21832f
C2076 _160_.B a_13184_7183# 0.14164f
C2077 _125_.A1 _210_.A 0.22293f
C2078 _148_.B _136_.A 0.10354f
C2079 fanout7.A _230_.Y 0.03868f
C2080 a_3014_5850# a_3274_5380# 0.39302f
C2081 _228_.Y a_10020_9504# 0.23682f
C2082 a_9994_9409# a_10437_9165# 0.02242f
C2083 a_1192_17508# fanout8.A 0.13495f
C2084 _258_.D VDD 0.27717f
C2085 a_16240_12430# VDD 0.12607f
C2086 _120_.A0 a_1958_12210# 0.06639f
C2087 _160_.X _151_.B 0.01201f
C2088 _145_.X _157_.Y 0.06917f
C2089 _173_.A a_2410_9409# 0.01519f
C2090 _263_.CLK _129_.B1 0.02956f
C2091 _160_.X a_11974_8436# 0.03046f
C2092 _191_.Y VDD 0.71364f
C2093 a_10437_9165# _168_.A 0.01574f
C2094 a_15071_17016# VDD 0.25014f
C2095 a_15599_15311# a_15856_15454# 0.20069f
C2096 a_14757_15213# a_15505_15311# 0.01058f
C2097 a_9348_4968# VDD 0.08005f
C2098 a_14724_5416# a_15012_5837# 0.22255f
C2099 a_2916_4325# a_3147_3911# 0.06628f
C2100 _131_.A2 a_15243_12332# 0.02024f
C2101 a_2628_3904# a_3793_4261# 0.22369f
C2102 _148_.B a_5297_12264# 0.20849f
C2103 _243_.CLK a_2853_8447# 0.18437f
C2104 _136_.A a_8156_7972# 0.0324f
C2105 _241_.Y a_11078_16746# 0.07701f
C2106 a_11338_16969# a_11364_17064# 0.21121f
C2107 _199_.B1 _199_.Y 0.12536f
C2108 _222_.A a_6720_17061# 0.01048f
C2109 a_14144_8522# VDD 0.09269f
C2110 _147_.A1 _147_.Y 0.27643f
C2111 _260_.CLK a_15237_11471# 0.02223f
C2112 a_5376_17061# VDD 0.16885f
C2113 _184_.Y a_7064_9194# 0.01426f
C2114 _136_.A _143_.Y 0.02627f
C2115 _119_.A0 a_4640_13058# 0.01221f
C2116 a_11536_9406# VDD 0.12608f
C2117 _166_.A _160_.B 0.02476f
C2118 a_8538_5375# _144_.B 0.18478f
C2119 _153_.Y _149_.A 0.05907f
C2120 _145_.B1 a_8557_4248# 0.17403f
C2121 _196_.Y _200_.Y 0.11833f
C2122 _266_.CLK a_15071_17016# 0.153f
C2123 _122_.A0 a_2232_7868# 0.044f
C2124 _148_.A _139_.X 0.04439f
C2125 _195_.Y _199_.Y 0.10332f
C2126 _174_.Y VDD 0.57626f
C2127 _219_.Y a_2436_9504# 0.25103f
C2128 _124_.S a_1862_16434# 0.02893f
C2129 _225_.A a_14757_15213# 0.04038f
C2130 a_8564_5412# VDD 0.11835f
C2131 _225_.A _207_.A1 0.02358f
C2132 a_14820_9504# VDD 0.07212f
C2133 fanout6.A a_13100_13686# 0.15787f
C2134 a_11078_16746# a_11781_16725# 0.02454f
C2135 a_15237_11471# a_15985_11821# 0.01058f
C2136 _124_.S _119_.A0 0.20738f
C2137 a_13073_5770# a_13244_5412# 0.19823f
C2138 _215_.A a_3014_4650# 0.05306f
C2139 fanout6.A _237_.Y 0.0551f
C2140 a_9551_16823# a_9457_16823# 0.15029f
C2141 a_3819_4772# a_3588_4663# 0.06628f
C2142 a_3300_4968# a_4465_4727# 0.22369f
C2143 _260_.RESET_B VDD 1.10231f
C2144 _187_.Y _176_.A 0.02023f
C2145 a_14438_12210# VDD 0.44656f
C2146 _221_.Y a_2122_12940# 0.14917f
C2147 fanout6.A _134_.Y 0.21603f
C2148 a_2126_11726# _173_.A 0.27488f
C2149 _251_.CLK a_9765_4629# 0.18285f
C2150 a_17120_16878# VDD 0.07952f
C2151 a_11456_12342# VDD 0.08271f
C2152 _179_.Y a_8352_11013# 0.09545f
C2153 _250_.Q a_1862_16746# 0.04067f
C2154 _160_.X a_10784_8522# 0.01326f
C2155 _124_.S _218_.Y 0.01138f
C2156 a_7520_9318# VDD 0.06507f
C2157 a_4625_16800# _208_.X 0.13313f
C2158 _251_.CLK a_14534_8874# 0.01372f
C2159 a_1864_15366# VDD 0.14799f
C2160 _126_.B1 a_14058_12508# 0.09267f
C2161 a_2342_4338# a_2916_4325# 0.16388f
C2162 a_2628_3904# a_3045_3911# 0.22698f
C2163 _162_.Y a_12652_6924# 0.01398f
C2164 a_8811_16868# a_8580_16759# 0.06628f
C2165 a_8292_17064# a_9457_16823# 0.22369f
C2166 a_12512_8522# VDD 0.07071f
C2167 a_2955_8447# a_3695_8797# 0.15395f
C2168 _225_.A a_14534_11898# 0.04327f
C2169 _124_.S _243_.D 0.03663f
C2170 _148_.B a_12328_7010# 0.01596f
C2171 a_11946_9484# _251_.CLK 0.01157f
C2172 _242_.RESET_B a_4559_4727# 0.07574f
C2173 _119_.A0 a_3407_13333# 0.01867f
C2174 a_12549_12189# VDD 0.25149f
C2175 a_10437_9165# VDD 0.25016f
C2176 _159_.Y a_13973_7678# 0.02071f
C2177 _173_.A _219_.Y 0.0337f
C2178 _122_.A0 _168_.Y 0.38894f
C2179 _238_.Y VDD 1.11902f
C2180 a_9573_13701# a_9444_13735# 0.01562f
C2181 a_15237_8447# _166_.A 0.01348f
C2182 a_16336_8678# a_16746_8436# 0.05221f
C2183 a_8156_14020# _194_.X 0.05498f
C2184 a_14534_11898# a_15339_11471# 0.06896f
C2185 a_5792_4782# VDD 0.06892f
C2186 fanout8.A a_9352_17508# 0.15774f
C2187 _225_.A a_10437_17519# 0.0173f
C2188 _201_.Y _205_.B1 0.09835f
C2189 fanout7.A a_16079_8797# 0.01776f
C2190 _148_.A a_2171_6204# 0.04611f
C2191 a_8325_16007# VDD 0.23777f
C2192 _260_.CLK VDD 1.79474f
C2193 _147_.A1 _147_.B1 0.03141f
C2194 _148_.B _192_.B 0.31724f
C2195 _148_.X a_13019_6460# 0.05588f
C2196 _215_.A a_1864_10034# 0.01184f
C2197 _153_.Y _152_.X 0.11818f
C2198 _143_.Y a_8557_4248# 0.01857f
C2199 _250_.Q a_4625_16800# 0.05431f
C2200 _266_.CLK _238_.Y 0.21904f
C2201 clkbuf_1_0__f_sclk.A _187_.Y 0.04021f
C2202 _124_.S a_2565_16725# 0.01488f
C2203 a_10415_12287# VDD 0.17755f
C2204 _148_.X _157_.B 0.05745f
C2205 a_2565_16725# a_2436_16759# 0.01562f
C2206 a_6885_4629# VDD 0.24859f
C2207 a_14314_15457# a_14054_15234# 0.39302f
C2208 a_2126_17774# a_2620_17878# 0.01625f
C2209 _131_.Y a_14534_11898# 0.15032f
C2210 _205_.Y _200_.Y 0.2295f
C2211 _151_.B _158_.Y 0.10088f
C2212 _236_.A _237_.Y 0.05858f
C2213 a_14940_16710# _211_.Y 0.0161f
C2214 a_16266_15532# VDD 0.24204f
C2215 _263_.CLK _236_.Y 0.05175f
C2216 a_4144_4142# VDD 0.13372f
C2217 a_10539_9308# _251_.CLK 0.03031f
C2218 _242_.RESET_B a_3014_4650# 0.07304f
C2219 a_9062_4650# a_9636_4663# 0.16388f
C2220 _210_.A a_6060_4166# 0.096f
C2221 a_11279_17869# a_11946_17508# 0.06982f
C2222 a_1862_16746# VDD 0.44963f
C2223 _243_.Q a_2398_4654# 0.09196f
C2224 _243_.RESET_B a_3147_3911# 0.21624f
C2225 _247_.CLK _220_.Y 0.02709f
C2226 _236_.A _134_.Y 0.07511f
C2227 _128_.B1 a_13366_13350# 0.0298f
C2228 _251_.CLK _224_.Y 0.01291f
C2229 a_9573_13701# a_9675_13844# 0.26919f
C2230 _145_.A2 VDD 0.58061f
C2231 _239_.Y a_15856_15454# 0.06203f
C2232 _215_.A _210_.A 0.42004f
C2233 a_14820_8440# a_15339_8447# 0.18362f
C2234 a_15237_8447# a_15108_8861# 0.01562f
C2235 _215_.A _243_.CLK 0.43732f
C2236 a_14534_11898# a_14820_11464# 0.21832f
C2237 a_4816_4870# VDD 0.12996f
C2238 _202_.Y _199_.Y 0.11227f
C2239 _247_.CLK a_2667_12983# 0.04344f
C2240 a_8266_16969# a_8292_17064# 0.21121f
C2241 _147_.A1 a_11274_4948# 0.08738f
C2242 a_3274_4873# a_3014_4650# 0.39302f
C2243 _210_.A a_2075_4692# 0.0996f
C2244 a_12424_15366# VDD 0.16424f
C2245 a_9156_12528# a_9444_12223# 0.22255f
C2246 _173_.Y a_6389_9484# 0.0414f
C2247 _247_.CLK a_2763_12332# 0.03606f
C2248 _214_.A _212_.Y 0.22262f
C2249 _153_.Y a_12904_7010# 0.03091f
C2250 _124_.S _250_.RESET_B 0.0172f
C2251 a_15983_12287# a_15889_12287# 0.15029f
C2252 _251_.CLK a_6987_4772# 0.02197f
C2253 _243_.Q a_3147_3911# 0.01034f
C2254 _129_.Y a_14438_12210# 0.15458f
C2255 fanout6.A _212_.Y 0.09866f
C2256 a_6048_13011# a_6197_13342# 0.17527f
C2257 a_2667_16007# a_3407_16357# 0.15395f
C2258 _236_.Y a_16336_11702# 0.0605f
C2259 _145_.A2 a_8386_3900# 0.04978f
C2260 _251_.CLK _162_.B 0.01476f
C2261 _205_.Y _186_.Y 0.13528f
C2262 _210_.A a_6182_4650# 0.07283f
C2263 _159_.Y a_14534_8874# 0.14499f
C2264 _129_.B1 VDD 0.36619f
C2265 _242_.D a_3014_4650# 0.15065f
C2266 _131_.A2 a_14794_11428# 0.0266f
C2267 a_14340_15552# VDD 0.07756f
C2268 a_15071_17016# a_14940_16710# 0.22698f
C2269 a_4625_16800# VDD 0.16674f
C2270 _143_.Y _145_.B1 0.11935f
C2271 a_16079_9263# a_16746_9484# 0.06982f
C2272 a_15237_9165# a_15985_9263# 0.01058f
C2273 _118_.A0 a_4462_16052# 0.17844f
C2274 _151_.B a_13244_5412# 0.0547f
C2275 _196_.Y a_5333_15532# 0.05201f
C2276 a_10437_17519# a_10539_17519# 0.27006f
C2277 _182_.Y a_8501_10702# 0.02071f
C2278 a_10437_17519# freq_in 0.14833f
C2279 _139_.X VDD 0.47698f
C2280 a_2232_10210# VDD 0.52999f
C2281 _243_.RESET_B a_2342_4338# 0.08342f
C2282 _235_.Y a_16240_12430# 0.06198f
C2283 _239_.Y a_14054_15234# 0.09733f
C2284 a_1952_17594# VDD 0.09122f
C2285 a_5372_9484# VDD 0.11744f
C2286 a_13221_16007# a_13969_16357# 0.01058f
C2287 a_14534_8874# a_14794_8404# 0.39302f
C2288 _122_.A0 _170_.Y 0.04443f
C2289 a_10895_8436# _166_.A 0.02993f
C2290 a_3300_4968# VDD 0.09234f
C2291 _124_.S _120_.X 0.04041f
C2292 _218_.Y a_3952_8678# 0.0605f
C2293 _259_.RESET_B a_9551_16823# 0.07582f
C2294 _266_.CLK a_14340_15552# 0.04455f
C2295 _209_.Y a_8006_16746# 0.15543f
C2296 _192_.C a_6272_12342# 0.01217f
C2297 _192_.C VDD 0.5086f
C2298 _171_.Y _168_.A 0.58234f
C2299 _149_.A a_17032_5498# 0.02925f
C2300 _145_.X _149_.A 0.10442f
C2301 a_2171_6204# a_2671_6460# 0.03308f
C2302 a_2494_6166# a_2397_6460# 0.02903f
C2303 a_1864_6294# a_2048_6294# 0.0262f
C2304 a_2126_7864# a_2298_7972# 0.01057f
C2305 _151_.B a_13073_5770# 0.12922f
C2306 _260_.CLK _129_.Y 0.01223f
C2307 a_14724_12528# a_15012_12223# 0.22255f
C2308 _171_.Y a_8236_8436# 0.01409f
C2309 fanout6.A a_11652_16759# 0.011f
C2310 _176_.B VDD 0.5037f
C2311 a_11279_9263# a_11185_9263# 0.15029f
C2312 _192_.Y a_6760_13854# 0.0247f
C2313 _236_.Y a_15237_11471# 0.0283f
C2314 a_4456_13058# a_4640_13058# 0.0262f
C2315 _192_.B a_6970_12214# 0.01548f
C2316 _259_.RESET_B a_8292_17064# 0.23987f
C2317 _161_.Y _157_.Y 0.18271f
C2318 _210_.A _242_.RESET_B 0.09376f
C2319 fanout6.A _201_.Y 0.0478f
C2320 _215_.A _122_.X 0.08085f
C2321 _243_.CLK _242_.RESET_B 0.05957f
C2322 a_13376_4782# VDD 0.08329f
C2323 _118_.A0 a_2436_16421# 0.01341f
C2324 _236_.A _131_.A2 0.5182f
C2325 a_9734_17946# a_10020_17512# 0.21832f
C2326 _215_.A _125_.A1 0.16689f
C2327 a_10020_17512# VDD 0.07505f
C2328 _164_.Y _164_.B1 0.12765f
C2329 a_6747_5468# _210_.B 0.11265f
C2330 _128_.B1 _126_.B1 0.19361f
C2331 a_14698_12433# a_14724_12528# 0.21121f
C2332 _145_.X a_13820_4948# 0.02692f
C2333 _170_.B _180_.X 0.01572f
C2334 _235_.Y a_14438_12210# 0.07718f
C2335 _122_.A0 a_2436_9504# 0.05011f
C2336 _172_.Y _164_.Y 0.03323f
C2337 _176_.B a_6336_11499# 0.21593f
C2338 _205_.Y _205_.B1 0.16798f
C2339 a_12518_16434# a_13323_16007# 0.06896f
C2340 _236_.A _212_.Y 0.02296f
C2341 _124_.S a_2398_5782# 0.11494f
C2342 a_2171_6204# VDD 0.51847f
C2343 _210_.A a_3274_4873# 0.0125f
C2344 _218_.Y a_2150_8874# 0.11534f
C2345 _173_.A a_5201_9240# 0.10932f
C2346 _199_.Y _191_.Y 0.03197f
C2347 _243_.CLK a_3274_4873# 0.017f
C2348 _238_.Y a_14940_16710# 0.24462f
C2349 _118_.X a_1864_15366# 0.03499f
C2350 _252_.RESET_B a_10607_4727# 0.07583f
C2351 _177_.X VDD 0.24039f
C2352 a_4913_13330# VDD 0.16479f
C2353 _149_.A a_15243_5423# 0.02588f
C2354 a_2126_15424# a_2558_15532# 0.02903f
C2355 _153_.Y a_12549_7996# 0.01304f
C2356 _165_.Y a_7739_9484# 0.02422f
C2357 _162_.B a_13244_7972# 0.01232f
C2358 a_14724_12528# a_15243_12332# 0.18372f
C2359 fanout7.A a_13100_13686# 0.01108f
C2360 a_10020_9504# a_11185_9263# 0.22369f
C2361 a_10539_9308# a_10308_9199# 0.06628f
C2362 _176_.A _178_.B1 0.03742f
C2363 _148_.B a_11974_8436# 0.01159f
C2364 _227_.Y a_15237_8447# 0.02707f
C2365 a_1192_11460# en 0.15783f
C2366 clkbuf_1_0__f_sclk.A a_5468_12508# 0.02017f
C2367 a_7451_14484# VDD 0.17388f
C2368 _210_.A _242_.D 0.04062f
C2369 _171_.Y VDD 0.68709f
C2370 a_15071_17016# a_15722_16904# 0.01562f
C2371 _148_.B a_11846_12210# 0.03599f
C2372 _136_.A _243_.Q 2.33737f
C2373 fanout7.A _134_.Y 0.03505f
C2374 a_9130_12433# a_9573_12189# 0.02242f
C2375 _252_.D a_8394_4948# 0.01555f
C2376 _263_.CLK a_15983_12287# 0.03333f
C2377 _134_.Y a_12984_12952# 0.01075f
C2378 _260_.CLK _235_.Y 0.26788f
C2379 _129_.B1 _129_.Y 0.31029f
C2380 _149_.A a_13775_5782# 0.01312f
C2381 _192_.B a_6779_12972# 0.0741f
C2382 _173_.A _122_.A0 0.50526f
C2383 _160_.X _160_.B 0.02045f
C2384 _246_.D _219_.Y 0.11795f
C2385 a_5704_13854# VDD 0.13548f
C2386 fanout6.A a_10218_17044# 0.07572f
C2387 _236_.Y VDD 1.0573f
C2388 a_1568_12342# VDD 0.09263f
C2389 _136_.B a_6810_3863# 0.18571f
C2390 a_6485_11830# _178_.B1 0.02245f
C2391 _122_.A0 a_3695_8797# 0.02143f
C2392 clkbuf_1_0__f_sclk.A _136_.A 0.07611f
C2393 a_2436_9504# a_2724_9199# 0.22255f
C2394 _196_.Y a_5906_15242# 0.01069f
C2395 a_9424_16238# a_9834_15996# 0.05221f
C2396 fanout6.A _207_.B1 0.19792f
C2397 a_8014_8492# VDD 0.15154f
C2398 _243_.CLK _243_.RESET_B 0.01097f
C2399 _252_.D _252_.RESET_B 0.23705f
C2400 _258_.D a_7622_16434# 0.16215f
C2401 _236_.A _133_.Y 0.05728f
C2402 _252_.RESET_B a_9322_4873# 0.1505f
C2403 _119_.A0 a_4744_15366# 0.02077f
C2404 _149_.A a_14698_5380# 0.0179f
C2405 a_14359_16710# VDD 0.17422f
C2406 a_3407_16823# a_4074_17044# 0.06982f
C2407 _199_.B1 _200_.Y 0.02998f
C2408 a_2661_12189# VDD 0.25577f
C2409 _125_.A1 _242_.RESET_B 0.01175f
C2410 _237_.Y a_13323_16007# 0.21432f
C2411 clkbuf_1_0__f_sclk.A a_5297_12264# 0.07343f
C2412 _118_.X a_1862_16746# 0.15393f
C2413 a_7262_3900# VDD 0.01082f
C2414 _220_.Y a_3503_12287# 0.07574f
C2415 a_3664_13214# a_3407_13333# 0.20069f
C2416 _222_.A a_1862_16746# 0.01469f
C2417 a_14794_9409# a_14820_9504# 0.21121f
C2418 _124_.S clkload0.Y 0.01003f
C2419 _225_.A a_14144_8522# 0.01269f
C2420 clkbuf_1_0__f_sclk.A _178_.B1 0.03025f
C2421 _124_.S a_2410_9409# 0.02451f
C2422 _120_.X a_2232_11722# 0.01321f
C2423 a_13184_7183# VDD 0.26457f
C2424 a_2126_13912# a_2558_14020# 0.02903f
C2425 _152_.X a_12800_6294# 0.01177f
C2426 _195_.Y _200_.Y 0.19599f
C2427 _243_.Q _210_.A 0.55152f
C2428 _243_.CLK _243_.Q 0.04207f
C2429 a_14359_16710# _266_.CLK 0.01007f
C2430 a_14794_9409# _260_.RESET_B 0.1524f
C2431 _124_.S a_1862_13410# 0.03218f
C2432 a_8870_12210# VDD 0.44679f
C2433 _241_.Y VDD 1.03648f
C2434 a_3717_5423# a_4465_5773# 0.01058f
C2435 a_3588_5837# a_3819_5423# 0.06628f
C2436 _225_.A a_14820_9504# 0.05026f
C2437 a_2126_17774# a_2298_17532# 0.01057f
C2438 _250_.RESET_B a_3664_16238# 0.06055f
C2439 a_2763_12332# a_3503_12287# 0.15395f
C2440 _147_.Y _157_.B 0.12881f
C2441 _120_.A0 a_4552_12342# 0.05121f
C2442 _192_.B _176_.A 0.14602f
C2443 _157_.Y _149_.A 0.28842f
C2444 a_8325_16007# a_8427_16007# 0.27006f
C2445 a_2955_9308# _243_.CLK 0.01625f
C2446 _225_.A _260_.RESET_B 0.37959f
C2447 a_2232_7868# a_2558_7972# 0.02726f
C2448 _205_.Y a_6869_16750# 0.01678f
C2449 _181_.Y a_8603_9484# 0.08529f
C2450 _225_.A a_14438_12210# 0.0536f
C2451 _256_.RESET_B a_9573_12189# 0.02875f
C2452 _118_.A0 a_1862_16746# 0.03292f
C2453 _166_.A VDD 1.27293f
C2454 _263_.CLK a_12132_12528# 0.0629f
C2455 a_11781_16725# VDD 0.25124f
C2456 fanout6.A a_13092_16421# 0.02293f
C2457 a_2667_16868# a_3407_16823# 0.15395f
C2458 _260_.CLK a_17120_11546# 0.0143f
C2459 _120_.A0 VDD 1.06665f
C2460 _237_.Y a_12518_16434# 0.09834f
C2461 _244_.RESET_B a_3819_5423# 0.21621f
C2462 _243_.CLK a_3717_5423# 0.17741f
C2463 _135_.A a_12992_15437# 0.07875f
C2464 a_2148_12976# a_2436_13397# 0.22255f
C2465 _124_.S a_2126_11726# 0.1141f
C2466 _139_.X _147_.A1 0.68425f
C2467 fanout6.A _205_.Y 0.03437f
C2468 a_13740_5678# VDD 0.17495f
C2469 fanout7.A _131_.A2 0.14979f
C2470 a_9573_12189# a_9675_12332# 0.26919f
C2471 _250_.D a_1862_16746# 0.03712f
C2472 a_9156_12528# _251_.CLK 0.07656f
C2473 _122_.A0 _165_.Y 0.17826f
C2474 _243_.CLK a_3956_6888# 0.95027f
C2475 _145_.X a_13973_7678# 0.01234f
C2476 _148_.B _189_.X 0.05196f
C2477 _225_.A _238_.Y 0.12f
C2478 a_3014_5850# a_3819_5423# 0.06896f
C2479 a_9551_16823# VDD 0.17401f
C2480 _222_.Y a_1862_16746# 0.07152f
C2481 a_2122_16969# a_2148_17064# 0.21121f
C2482 _250_.RESET_B a_1862_16434# 0.0797f
C2483 a_1958_12210# a_2244_12528# 0.21832f
C2484 _120_.A0 a_3760_12430# 0.01591f
C2485 a_17032_12342# VDD 0.12787f
C2486 _148_.B _128_.B1 0.16695f
C2487 a_14438_5850# VDD 0.45685f
C2488 _225_.A _260_.CLK 0.15167f
C2489 _118_.A0 a_4625_16800# 0.03829f
C2490 _162_.B _153_.Y 0.28892f
C2491 a_7622_16434# a_8325_16007# 0.02432f
C2492 a_2410_9409# a_2150_9186# 0.39302f
C2493 a_11279_9263# _168_.A 0.01286f
C2494 a_10864_4870# VDD 0.12763f
C2495 _207_.A1 a_5525_16750# 0.02532f
C2496 _158_.Y _160_.B 0.21842f
C2497 _145_.A2 a_7727_4727# 0.01615f
C2498 a_3887_4261# a_3793_4261# 0.15029f
C2499 a_15012_5837# a_15243_5423# 0.06628f
C2500 _180_.X a_8603_9484# 0.02382f
C2501 _124_.S _221_.Y 0.02853f
C2502 _186_.Y _190_.A 0.03593f
C2503 _168_.Y a_7520_9318# 0.01071f
C2504 _236_.A a_12106_12433# 0.03039f
C2505 _129_.B1 a_13391_12287# 0.0301f
C2506 _241_.Y a_12880_16966# 0.06211f
C2507 _207_.Y a_4625_16800# 0.17427f
C2508 a_2148_17064# a_2667_16868# 0.18372f
C2509 a_8292_17064# VDD 0.07209f
C2510 _260_.CLK a_15339_11471# 0.04825f
C2511 _125_.A1 _243_.Q 0.07048f
C2512 _145_.B1 a_9290_3900# 0.01545f
C2513 a_14056_9318# VDD 0.16476f
C2514 _157_.Y _152_.X 0.18717f
C2515 _173_.A a_2298_11484# 0.01192f
C2516 a_2232_11722# a_2558_11484# 0.02726f
C2517 _258_.RESET_B a_7908_16000# 0.25086f
C2518 _124_.S a_2667_16007# 0.03918f
C2519 _193_.Y VDD 0.76168f
C2520 _243_.Q _145_.B1 0.07217f
C2521 _148_.B a_8352_11013# 0.02672f
C2522 a_16746_9484# VDD 0.23758f
C2523 _148_.B _176_.A 0.81943f
C2524 a_7616_5498# VDD 0.09518f
C2525 a_16336_11702# a_16746_11460# 0.05221f
C2526 a_11883_16868# a_12623_16823# 0.15395f
C2527 _210_.B a_6442_4873# 0.02277f
C2528 _120_.A0 a_2148_12976# 0.05118f
C2529 _179_.Y _168_.A 0.02003f
C2530 _250_.D a_1952_17594# 0.01466f
C2531 _225_.A _145_.A2 0.04846f
C2532 a_4559_4727# a_4465_4727# 0.15029f
C2533 a_9994_9409# a_10020_9504# 0.21121f
C2534 _228_.Y a_9734_9186# 0.07323f
C2535 _134_.Y a_13100_13686# 0.04926f
C2536 a_2398_4654# a_2512_4654# 0.0308f
C2537 a_15983_12287# VDD 0.17369f
C2538 _260_.CLK _131_.Y 0.09444f
C2539 _221_.Y a_3407_13333# 0.07584f
C2540 fanout8.A _208_.X 0.01829f
C2541 _199_.B1 a_5525_16750# 0.03237f
C2542 _160_.X a_10895_8436# 0.21219f
C2543 a_6286_15276# VDD 0.15386f
C2544 _154_.X VDD 0.63512f
C2545 a_10020_9504# _168_.A 0.01353f
C2546 a_9062_4650# VDD 0.45102f
C2547 _251_.CLK a_15339_8447# 0.05502f
C2548 _147_.A1 a_11475_4248# 0.012f
C2549 a_14340_15552# a_15505_15311# 0.22369f
C2550 a_14859_15356# a_14628_15247# 0.06628f
C2551 _131_.A2 a_15141_12189# 0.01363f
C2552 _180_.X a_9120_9501# 0.01482f
C2553 _243_.CLK a_2436_8440# 0.08351f
C2554 _240_.Y a_10218_17044# 0.02523f
C2555 a_11338_16969# a_11078_16746# 0.39302f
C2556 _215_.A _242_.RESET_B 1.03294f
C2557 _138_.Y a_8042_3900# 0.01284f
C2558 a_12416_16082# VDD 0.08255f
C2559 a_13403_8436# VDD 0.17784f
C2560 _213_.Y _251_.CLK 0.10533f
C2561 _260_.CLK a_14820_11464# 0.06367f
C2562 _226_.Y VDD 1.1186f
C2563 _136_.A a_6836_3900# 0.0135f
C2564 _119_.A0 a_4456_13058# 0.03214f
C2565 _242_.RESET_B a_2075_4692# 0.06435f
C2566 a_11279_9263# VDD 0.17436f
C2567 _235_.Y _236_.Y 0.04329f
C2568 _195_.Y a_5333_15532# 0.03086f
C2569 _148_.A a_10764_5678# 0.01549f
C2570 a_14359_16710# a_14940_16710# 0.01303f
C2571 _219_.Y a_2150_9186# 0.11562f
C2572 _157_.Y a_12904_7010# 0.01014f
C2573 a_10408_7806# VDD 0.15239f
C2574 _225_.A a_14340_15552# 0.03387f
C2575 a_10415_13799# a_10321_13799# 0.15029f
C2576 _193_.Y a_7985_13776# 0.20871f
C2577 _181_.Y _180_.X 0.05698f
C2578 a_4661_17878# _207_.A2 0.02071f
C2579 _236_.A _261_.RESET_B 0.1191f
C2580 _266_.CLK a_12416_16082# 0.01246f
C2581 a_14820_11464# a_15985_11821# 0.22369f
C2582 a_11078_16746# a_11364_17064# 0.21832f
C2583 _215_.A a_3274_4873# 0.01395f
C2584 _124_.S a_2232_15428# 0.12599f
C2585 _148_.B clkbuf_1_0__f_sclk.A 0.13113f
C2586 _260_.CLK a_14651_10996# 0.04012f
C2587 _215_.A _244_.D 0.13604f
C2588 _202_.Y _186_.Y 0.22119f
C2589 _168_.B a_5800_9318# 0.04794f
C2590 _119_.A0 _119_.X 0.01568f
C2591 a_9834_15996# VDD 0.24268f
C2592 fanout8.A _250_.Q 0.02466f
C2593 a_3717_4629# a_3588_4663# 0.01562f
C2594 _210_.B a_6810_3863# 0.13092f
C2595 a_8156_9928# VDD 0.01841f
C2596 _122_.A0 _246_.D 0.01349f
C2597 _187_.Y VDD 0.49901f
C2598 fanout6.A a_12992_15437# 0.02899f
C2599 a_2126_11726# a_2232_11722# 0.22783f
C2600 _171_.A _168_.A 0.11008f
C2601 _251_.CLK a_9348_4968# 0.07072f
C2602 _145_.X _148_.X 0.05444f
C2603 _243_.Q _143_.Y 0.01363f
C2604 _160_.X a_11731_8698# 0.01482f
C2605 _145_.X _164_.B1 0.17846f
C2606 _236_.A a_12651_12332# 0.03724f
C2607 _191_.Y a_6958_13764# 0.07882f
C2608 _179_.Y VDD 0.46298f
C2609 a_7336_9318# VDD 0.12222f
C2610 _215_.A _242_.D 0.19593f
C2611 _133_.Y a_13297_12287# 0.01877f
C2612 a_14438_5850# a_15141_5423# 0.02432f
C2613 _210_.B _224_.Y 0.0438f
C2614 a_2126_15424# VDD 0.10495f
C2615 a_2602_3868# a_3045_3911# 0.02242f
C2616 _136_.A _143_.A 0.78002f
C2617 _136_.A a_7984_4870# 0.01226f
C2618 a_2853_8447# a_3601_8797# 0.01058f
C2619 a_8709_16725# a_8580_16759# 0.01562f
C2620 a_12328_8522# VDD 0.12674f
C2621 a_2955_8447# a_3952_8678# 0.01569f
C2622 a_11536_9406# _251_.CLK 0.01238f
C2623 fanout6.A _207_.A1 0.31514f
C2624 _126_.B1 _132_.Y 0.02177f
C2625 _119_.A0 a_3664_13214# 0.01301f
C2626 _122_.X a_2126_7864# 0.116f
C2627 a_10020_9504# VDD 0.07331f
C2628 a_12132_12528# VDD 0.07483f
C2629 _251_.CLK a_14820_9504# 0.01502f
C2630 a_14048_16878# VDD 0.08983f
C2631 a_9156_14040# a_9444_13735# 0.22255f
C2632 _226_.Y a_15983_5773# 0.07576f
C2633 a_16336_8678# a_16079_8797# 0.20069f
C2634 a_14820_8440# _166_.A 0.01408f
C2635 _228_.Y a_9928_8522# 0.02206f
C2636 a_5608_4782# VDD 0.12994f
C2637 _136_.A _148_.A 0.0395f
C2638 a_14534_11898# a_15108_11885# 0.16388f
C2639 _178_.B1 a_3886_10702# 0.01009f
C2640 _225_.A a_10020_17512# 0.04353f
C2641 _215_.A _243_.RESET_B 0.12374f
C2642 _227_.Y VDD 1.02732f
C2643 fanout7.A a_16336_8678# 0.01012f
C2644 _251_.CLK _260_.RESET_B 0.01928f
C2645 a_2398_4654# VDD 0.10375f
C2646 a_7908_16000# VDD 0.07213f
C2647 a_8811_16868# fanout7.A 0.01624f
C2648 _200_.Y _191_.Y 0.06391f
C2649 _124_.S a_2148_17064# 0.01837f
C2650 _243_.Q a_6060_4166# 0.01483f
C2651 _263_.CLK _126_.B1 0.59233f
C2652 _208_.X a_4796_17044# 0.05568f
C2653 _173_.Y _168_.B 0.31432f
C2654 _170_.B a_7739_9484# 0.05164f
C2655 a_16746_11460# VDD 0.24152f
C2656 a_6468_4968# VDD 0.0792f
C2657 a_2148_17064# a_2436_16759# 0.22255f
C2658 _134_.Y _131_.A2 0.02701f
C2659 _210_.A _143_.A 0.0317f
C2660 _202_.Y _205_.B1 0.12057f
C2661 a_2126_17774# a_2298_17878# 0.0308f
C2662 fanout8.A VDD 2.28045f
C2663 _215_.A _243_.Q 1.29466f
C2664 a_2436_8440# a_2853_8447# 0.22698f
C2665 a_2150_8874# a_2955_8447# 0.06896f
C2666 fanout6.A _199_.B1 0.0322f
C2667 a_15856_15454# VDD 0.12731f
C2668 a_15767_17137# a_15861_16904# 0.39302f
C2669 a_3147_3911# VDD 0.23565f
C2670 a_10437_9165# _251_.CLK 0.15733f
C2671 _148_.A a_12128_5498# 0.01253f
C2672 _242_.RESET_B a_3274_4873# 0.138f
C2673 a_11536_17750# a_11946_17508# 0.05221f
C2674 fanout7.A a_16650_12508# 0.04392f
C2675 _171_.A VDD 0.45605f
C2676 _256_.RESET_B a_10672_12430# 0.06212f
C2677 _243_.Q a_2075_4692# 0.04942f
C2678 _119_.A0 a_1862_13410# 0.01024f
C2679 a_7872_5451# a_8021_5782# 0.17527f
C2680 _184_.Y _168_.A 0.02004f
C2681 _145_.X _162_.B 0.02172f
C2682 _159_.Y a_13824_7989# 0.11233f
C2683 fanout6.A _195_.Y 0.01913f
C2684 _148_.X a_13775_5782# 0.02092f
C2685 _157_.Y a_12549_7996# 0.06181f
C2686 a_9156_14040# a_9675_13844# 0.18372f
C2687 _239_.Y a_15599_15311# 0.07581f
C2688 _226_.Y a_15141_5423# 0.02984f
C2689 _148_.A _210_.A 0.09257f
C2690 a_14820_8440# a_15108_8861# 0.22255f
C2691 a_4559_4727# VDD 0.17964f
C2692 a_14534_11898# a_14794_11428# 0.39302f
C2693 _243_.CLK _148_.A 0.07201f
C2694 _174_.Y _178_.Y 0.02539f
C2695 _122_.A0 a_2298_9972# 0.01135f
C2696 a_2232_10210# a_2558_9972# 0.02726f
C2697 _225_.A _236_.Y 0.37308f
C2698 a_8266_16969# a_8006_16746# 0.39302f
C2699 _242_.D _242_.RESET_B 0.05172f
C2700 _191_.Y _186_.Y 0.13658f
C2701 _250_.Q a_4796_17044# 0.01008f
C2702 a_9675_12332# a_10672_12430# 0.01528f
C2703 a_8870_12210# a_9444_12223# 0.16388f
C2704 a_6720_17061# a_6869_16750# 0.17527f
C2705 _138_.Y a_9348_4968# 0.02681f
C2706 _166_.A a_10752_7989# 0.09995f
C2707 _189_.X a_6048_13011# 0.22187f
C2708 _247_.CLK a_2661_12189# 0.16022f
C2709 _119_.A0 _196_.Y 0.01875f
C2710 _251_.CLK a_6885_4629# 0.15354f
C2711 _124_.S _122_.A0 0.74663f
C2712 _148_.X a_12401_4704# 0.14757f
C2713 _194_.X VDD 0.20867f
C2714 a_13413_11460# VDD 0.01352f
C2715 _236_.Y a_15339_11471# 0.21427f
C2716 _120_.A0 sclk 0.01621f
C2717 a_2667_16007# a_3664_16238# 0.01569f
C2718 a_2565_16007# a_3313_16357# 0.01058f
C2719 _136_.A _168_.A 0.13897f
C2720 _160_.X VDD 0.50387f
C2721 _244_.D _242_.D 0.05502f
C2722 a_14572_16746# a_14919_16964# 0.01569f
C2723 a_14054_15234# VDD 0.44822f
C2724 a_2342_4338# VDD 0.45916f
C2725 _138_.Y a_8564_5412# 0.01008f
C2726 a_15339_9308# a_15108_9199# 0.06628f
C2727 a_16079_9263# a_16336_9406# 0.20069f
C2728 _152_.X _149_.A 0.01607f
C2729 _243_.RESET_B _242_.RESET_B 0.01217f
C2730 a_14820_9504# a_15985_9263# 0.22369f
C2731 a_10437_17519# a_10308_17933# 0.01562f
C2732 a_9765_4629# a_9867_4772# 0.26919f
C2733 a_10020_17512# a_10539_17519# 0.18362f
C2734 _251_.CLK _145_.A2 0.0257f
C2735 a_10020_17512# freq_in 0.06682f
C2736 a_2126_10214# VDD 0.10623f
C2737 a_10764_5678# VDD 0.17984f
C2738 a_11946_17508# VDD 0.24354f
C2739 _151_.B _160_.B 0.27867f
C2740 _235_.Y a_15983_12287# 0.07574f
C2741 a_9675_13844# VDD 0.20599f
C2742 a_4913_13330# a_5084_12972# 0.19823f
C2743 _134_.Y _133_.Y 0.14768f
C2744 _239_.Y a_14314_15457# 0.1407f
C2745 a_5169_9508# VDD 0.01058f
C2746 a_12804_16000# a_13969_16357# 0.22369f
C2747 a_13092_16421# a_13323_16007# 0.06628f
C2748 a_3014_4650# VDD 0.47571f
C2749 _131_.Y _236_.Y 0.03283f
C2750 _124_.S a_2218_12433# 0.02223f
C2751 _225_.A _241_.Y 0.01329f
C2752 _218_.Y a_2955_8447# 0.21427f
C2753 _236_.A a_14534_11898# 0.02195f
C2754 _178_.B1 _168_.A 0.2125f
C2755 _261_.RESET_B _126_.Y 0.09218f
C2756 _210_.A a_2512_4654# 0.01717f
C2757 _157_.Y _148_.X 0.04762f
C2758 _184_.Y VDD 0.45407f
C2759 _263_.CLK _131_.B1 0.01297f
C2760 _243_.Q _242_.RESET_B 0.0334f
C2761 a_2171_6204# a_2397_6460# 0.02726f
C2762 _214_.Y a_9734_17946# 0.16657f
C2763 _161_.Y a_12549_7996# 0.07475f
C2764 _247_.CLK _120_.A0 0.03445f
C2765 a_15243_12332# a_16240_12430# 0.01528f
C2766 a_14438_12210# a_15012_12223# 0.16388f
C2767 _214_.Y VDD 0.42243f
C2768 _139_.X a_10769_4258# 0.13872f
C2769 a_5468_12508# VDD 0.11744f
C2770 _219_.Y _218_.Y 0.0676f
C2771 _236_.Y a_14820_11464# 0.26823f
C2772 a_7985_13776# _194_.X 0.13086f
C2773 a_1862_16434# a_2667_16007# 0.06896f
C2774 a_2148_16000# a_2565_16007# 0.22698f
C2775 _225_.A _166_.A 0.16481f
C2776 _124_.S a_2724_9199# 0.01728f
C2777 a_4796_17044# VDD 0.11839f
C2778 _259_.RESET_B a_8006_16746# 0.11496f
C2779 _124_.S a_2494_6166# 0.11739f
C2780 _191_.Y _205_.B1 0.11244f
C2781 _251_.CLK _139_.X 0.01141f
C2782 _148_.B a_12215_7664# 0.04187f
C2783 a_15237_9165# a_15339_9308# 0.26919f
C2784 _122_.A0 _170_.B 0.02486f
C2785 a_9734_17946# a_9994_17476# 0.39302f
C2786 _125_.A1 _148_.A 0.01153f
C2787 _243_.Q _244_.D 0.05299f
C2788 a_9994_17476# VDD 0.0954f
C2789 a_14698_12433# a_14438_12210# 0.39302f
C2790 _122_.A0 a_2150_9186# 0.02454f
C2791 _201_.Y a_7074_15532# 0.02918f
C2792 fanout8.A a_4512_17547# 0.01691f
C2793 _124_.S a_2532_12223# 0.02069f
C2794 a_12804_16000# a_13221_16007# 0.22698f
C2795 a_12518_16434# a_13092_16421# 0.16388f
C2796 _236_.A a_10888_16878# 0.01517f
C2797 _136_.A VDD 2.25076f
C2798 _124_.S a_2075_5468# 0.12572f
C2799 a_2075_5468# a_1864_5498# 0.02132f
C2800 clkbuf_1_0__f_sclk.A _189_.X 0.12753f
C2801 _236_.A _190_.A 0.3244f
C2802 _207_.A2 _208_.X 0.0742f
C2803 _124_.S a_2126_13912# 0.09044f
C2804 fanout6.A _202_.Y 0.02188f
C2805 _154_.X a_10752_7989# 0.20259f
C2806 _243_.Q _242_.D 0.06847f
C2807 _199_.Y a_6286_15276# 0.0416f
C2808 _118_.X a_2126_15424# 0.11416f
C2809 a_6124_9945# VDD 0.44712f
C2810 _214_.A a_11883_16868# 0.0734f
C2811 a_1864_10034# VDD 0.1478f
C2812 a_5376_17061# a_5525_16750# 0.17527f
C2813 _225_.A a_14438_5850# 0.02528f
C2814 _147_.Y a_11381_3900# 0.0865f
C2815 a_2126_15424# a_2298_15532# 0.01057f
C2816 a_14438_12210# a_15243_12332# 0.06896f
C2817 a_14724_12528# a_15141_12189# 0.22605f
C2818 fanout6.A a_11883_16868# 0.01102f
C2819 _224_.Y _210_.Y 0.10949f
C2820 a_5297_12264# VDD 0.16581f
C2821 a_13648_12430# a_14058_12508# 0.05221f
C2822 _176_.A a_6485_11830# 0.01634f
C2823 a_10437_9165# a_10308_9199# 0.01562f
C2824 _227_.Y a_14820_8440# 0.25011f
C2825 _178_.B1 VDD 0.84478f
C2826 _124_.S _220_.Y 0.01901f
C2827 _126_.B1 VDD 0.80584f
C2828 _136_.A a_8386_3900# 0.01167f
C2829 _209_.Y _259_.RESET_B 0.09334f
C2830 _162_.B _157_.Y 0.44717f
C2831 a_12128_5498# VDD 0.08163f
C2832 _143_.A _252_.D 0.10564f
C2833 _243_.Q _243_.RESET_B 0.02663f
C2834 _145_.A2 _138_.Y 0.03595f
C2835 _124_.S a_2667_12983# 0.03918f
C2836 _182_.Y a_8870_12210# 0.15691f
C2837 a_9130_12433# a_9156_12528# 0.21121f
C2838 _252_.D a_7984_4870# 0.03021f
C2839 _148_.B _148_.A 0.30146f
C2840 _260_.CLK a_14698_12433# 0.03493f
C2841 a_2232_15428# _119_.A0 0.06353f
C2842 _133_.Y _131_.A2 0.18798f
C2843 a_4559_5773# a_4465_5773# 0.15029f
C2844 _145_.X _147_.Y 0.0344f
C2845 _160_.X a_13073_7728# 0.01638f
C2846 _173_.A a_2232_10210# 0.03793f
C2847 _118_.A0 a_2126_15424# 0.07391f
C2848 _158_.Y VDD 0.45927f
C2849 _124_.S a_2763_12332# 0.02331f
C2850 a_14357_12972# VDD 0.1613f
C2851 _157_.B a_13376_4782# 0.01178f
C2852 _210_.A VDD 1.09296f
C2853 _143_.A _143_.Y 0.07059f
C2854 _243_.CLK VDD 2.61602f
C2855 _122_.A0 a_3952_8678# 0.01544f
C2856 _173_.A a_5372_9484# 0.01577f
C2857 a_6336_11499# _178_.B1 0.11457f
C2858 a_2150_9186# a_2724_9199# 0.16388f
C2859 a_12730_8806# _161_.Y 0.01534f
C2860 a_9424_16238# a_9167_16357# 0.20069f
C2861 fanout6.A a_4462_16052# 0.03671f
C2862 _129_.B1 a_13464_12952# 0.01075f
C2863 _174_.Y a_6106_9190# 0.01562f
C2864 _207_.A1 fanout7.A 0.06407f
C2865 _148_.A _252_.D 0.03604f
C2866 _136_.A a_6528_8475# 0.01326f
C2867 _240_.Y a_10437_17519# 0.02707f
C2868 fanout8.A _118_.X 0.05048f
C2869 fanout8.A _222_.A 0.36918f
C2870 a_14240_16921# VDD 0.24167f
C2871 a_8014_8492# _170_.Y 0.19713f
C2872 _196_.Y a_6106_13726# 0.01569f
C2873 _162_.B a_10901_7678# 0.03349f
C2874 _192_.Y a_6584_12218# 0.01426f
C2875 _225_.A _154_.X 0.02492f
C2876 a_3407_16823# a_3664_16966# 0.20069f
C2877 a_2244_12528# VDD 0.08409f
C2878 a_12132_12528# a_13391_12287# 0.01303f
C2879 a_8557_4248# VDD 0.28745f
C2880 a_2667_12983# a_3407_13333# 0.15395f
C2881 _120_.X a_2126_11726# 0.13438f
C2882 a_12328_7010# VDD 0.14503f
C2883 a_2126_13912# a_2298_14020# 0.01057f
C2884 _172_.Y a_9120_9501# 0.11772f
C2885 _144_.B a_9348_4968# 0.06388f
C2886 _225_.A _226_.Y 0.33913f
C2887 a_7984_4870# a_8394_4948# 0.05221f
C2888 _119_.X a_1862_13410# 0.15732f
C2889 a_11338_16969# VDD 0.09669f
C2890 a_3300_5416# a_4465_5773# 0.22369f
C2891 _250_.RESET_B a_2667_16007# 0.21477f
C2892 fanout8.A _118_.A0 0.17186f
C2893 _147_.B1 a_12128_4782# 0.0171f
C2894 fanout6.A _258_.D 0.03003f
C2895 a_4928_16082# VDD 0.07693f
C2896 _122_.A0 a_2150_8874# 0.03889f
C2897 _170_.B a_8488_8436# 0.01036f
C2898 a_13244_5412# VDD 0.11901f
C2899 _144_.B a_8564_5412# 0.01436f
C2900 _209_.Y _258_.RESET_B 0.07348f
C2901 a_8557_4248# a_8386_3900# 0.07344f
C2902 _192_.B VDD 0.49274f
C2903 _162_.B _161_.Y 0.07609f
C2904 a_8325_16007# a_8196_16421# 0.01562f
C2905 a_7908_16000# a_8427_16007# 0.18362f
C2906 a_2853_9165# _243_.CLK 0.154f
C2907 _193_.Y a_7180_14020# 0.01455f
C2908 a_2232_7868# a_2298_7972# 0.03308f
C2909 _208_.X _209_.Y 0.10805f
C2910 _145_.A2 _136_.B 0.11013f
C2911 _256_.RESET_B a_9156_12528# 0.23987f
C2912 a_15983_5773# a_15889_5773# 0.15029f
C2913 _207_.A2 VDD 0.72348f
C2914 a_11364_17064# VDD 0.0748f
C2915 _125_.A1 a_2512_5782# 0.01923f
C2916 _148_.B _168_.A 0.0655f
C2917 _177_.X _178_.Y 0.08971f
C2918 fanout8.A _250_.D 0.05894f
C2919 _131_.B1 VDD 0.26518f
C2920 _210_.A a_3300_5416# 0.01062f
C2921 a_2232_13916# VDD 0.49833f
C2922 _243_.CLK a_3300_5416# 0.07345f
C2923 _124_.S a_1192_11460# 0.13825f
C2924 a_10764_5678# _147_.A1 0.08275f
C2925 _258_.RESET_B a_9167_16357# 0.07601f
C2926 a_10672_12430# a_11082_12508# 0.05221f
C2927 a_15980_7638# VDD 0.19951f
C2928 a_13073_5770# VDD 0.17019f
C2929 _215_.A _148_.A 0.08123f
C2930 _174_.Y a_6389_9484# 0.06359f
C2931 clkbuf_1_0__f_sclk.A a_3956_6888# 0.39741f
C2932 _148_.A _252_.RESET_B 0.03583f
C2933 a_9156_12528# a_9675_12332# 0.18372f
C2934 _124_.S a_2724_8861# 0.01728f
C2935 _122_.X VDD 0.37232f
C2936 a_11781_16725# a_12529_16823# 0.01058f
C2937 fanout8.A _222_.Y 0.01214f
C2938 _125_.A1 VDD 0.62721f
C2939 _126_.B1 _129_.Y 0.07958f
C2940 a_6468_4968# a_7727_4727# 0.01303f
C2941 _205_.Y a_7074_15532# 0.09142f
C2942 a_3014_5850# a_3588_5837# 0.16388f
C2943 a_2122_16969# a_1862_16746# 0.39302f
C2944 _145_.B1 VDD 0.34394f
C2945 _135_.A a_14340_15552# 0.02338f
C2946 fanout7.A _190_.A 0.05284f
C2947 _180_.X _164_.B1 0.07107f
C2948 _147_.Y a_12401_4704# 0.02636f
C2949 _120_.A0 a_3503_12287# 0.02139f
C2950 _225_.A _227_.Y 0.20581f
C2951 _149_.A _148_.X 0.68459f
C2952 a_11731_8698# a_11974_8436# 0.07046f
C2953 _172_.Y _180_.X 0.03918f
C2954 a_7622_16434# a_7908_16000# 0.21832f
C2955 _126_.B1 a_14240_13058# 0.01323f
C2956 a_2853_8447# VDD 0.25399f
C2957 a_15861_16904# VDD 0.09768f
C2958 a_10607_4727# VDD 0.17887f
C2959 _251_.CLK _166_.A 0.12399f
C2960 a_15141_5423# a_15889_5773# 0.01058f
C2961 a_3887_4261# a_4554_3900# 0.06982f
C2962 _131_.A2 a_16650_12508# 0.07981f
C2963 _241_.Y a_12623_16823# 0.07595f
C2964 _186_.Y a_7451_14484# 0.04613f
C2965 _119_.X _221_.Y 0.05709f
C2966 a_8006_16746# VDD 0.44707f
C2967 a_2148_17064# a_2565_16725# 0.22605f
C2968 a_1862_16746# a_2667_16868# 0.06896f
C2969 _244_.RESET_B a_3014_5850# 0.07461f
C2970 _122_.A0 _218_.Y 0.13854f
C2971 _145_.B1 a_8386_3900# 0.03671f
C2972 _148_.B a_12572_4948# 0.02806f
C2973 a_2232_11722# a_2298_11484# 0.03308f
C2974 _258_.RESET_B a_7882_15964# 0.14253f
C2975 a_2126_11726# a_2558_11484# 0.02903f
C2976 _124_.S a_2436_16421# 0.02635f
C2977 a_7616_15437# VDD 0.26674f
C2978 a_16336_9406# VDD 0.12748f
C2979 _157_.Y _147_.Y 0.40815f
C2980 _148_.B VDD 4.17694f
C2981 _136_.A _147_.A1 0.0163f
C2982 a_16336_11702# a_16079_11821# 0.20069f
C2983 _120_.A0 a_2122_12940# 0.03081f
C2984 _145_.X a_13824_7989# 0.0188f
C2985 _135_.X VDD 0.40988f
C2986 _157_.B a_13740_5678# 0.11226f
C2987 a_9994_9409# a_9734_9186# 0.39302f
C2988 fanout6.A a_8325_16007# 0.01542f
C2989 a_5201_9240# _168_.B 0.12756f
C2990 a_7008_16035# VDD 0.17516f
C2991 _221_.Y a_3664_13214# 0.06055f
C2992 a_2398_4654# a_2301_4654# 0.01625f
C2993 a_2565_16007# VDD 0.24657f
C2994 _145_.A2 _144_.B 0.06328f
C2995 _236_.A a_12420_12223# 0.02526f
C2996 _119_.A0 _195_.Y 0.15744f
C2997 a_9734_9186# _168_.A 0.01792f
C2998 a_8156_7972# VDD 0.11752f
C2999 _252_.D VDD 0.37007f
C3000 _207_.Y a_4796_17044# 0.01265f
C3001 a_14757_15213# a_14628_15247# 0.01562f
C3002 _251_.CLK a_15108_8861# 0.0146f
C3003 a_9322_4873# VDD 0.09595f
C3004 _164_.Y _171_.Y 0.32149f
C3005 a_2628_3904# a_3887_4261# 0.01303f
C3006 _131_.A2 a_14724_12528# 0.01549f
C3007 a_2853_9165# a_2853_8447# 0.01653f
C3008 _266_.CLK _135_.X 0.05315f
C3009 a_12992_15437# _134_.Y 0.14949f
C3010 a_13740_5678# _151_.X 0.01297f
C3011 a_13221_16007# VDD 0.25205f
C3012 _131_.A2 _261_.RESET_B 0.02167f
C3013 _209_.Y VDD 0.28914f
C3014 a_14056_9318# _251_.CLK 0.02632f
C3015 _143_.Y VDD 0.35074f
C3016 _260_.CLK a_14794_11428# 0.02712f
C3017 _148_.B a_12237_5760# 0.17464f
C3018 _171_.A _168_.Y 0.17871f
C3019 _152_.X _148_.X 0.03108f
C3020 a_14058_12508# VDD 0.24247f
C3021 _120_.A0 _173_.A 0.22472f
C3022 _219_.Y a_2410_9409# 0.13844f
C3023 _225_.A _160_.X 0.05737f
C3024 _131_.B1 _129_.Y 0.02626f
C3025 _225_.A a_14054_15234# 0.02807f
C3026 _193_.Y a_6958_13764# 0.1346f
C3027 _210_.B a_6756_4663# 0.01179f
C3028 _236_.A a_11456_12342# 0.01225f
C3029 _122_.A0 _168_.B 0.38215f
C3030 a_4512_17547# _207_.A2 0.11237f
C3031 _266_.CLK a_13221_16007# 0.17109f
C3032 a_16746_8436# _166_.A 0.0797f
C3033 _225_.A a_11946_17508# 0.0123f
C3034 _151_.X a_14438_5850# 0.15923f
C3035 _131_.A2 a_12651_12332# 0.01169f
C3036 _148_.B a_3380_13690# 0.05332f
C3037 _148_.A _244_.D 0.0539f
C3038 _119_.A0 a_2126_13912# 0.10227f
C3039 a_9167_16357# VDD 0.17513f
C3040 a_3300_4968# a_3588_4663# 0.22255f
C3041 fanout8.A a_2232_17770# 0.02208f
C3042 _221_.Y a_1862_13410# 0.08168f
C3043 _144_.B _139_.X 0.0387f
C3044 _143_.Y a_8386_3900# 0.07257f
C3045 _251_.CLK _154_.X 0.03087f
C3046 _251_.CLK a_9062_4650# 0.02083f
C3047 _236_.A a_12549_12189# 0.02164f
C3048 _166_.A a_17120_8522# 0.01342f
C3049 a_3592_10830# VDD 0.17281f
C3050 _205_.Y _201_.Y 0.16792f
C3051 a_8394_4948# VDD 0.24221f
C3052 a_14757_15213# a_14859_15356# 0.26919f
C3053 a_14438_5850# a_14724_5416# 0.21832f
C3054 a_17032_16082# VDD 0.13516f
C3055 a_2602_3868# a_2628_3904# 0.21121f
C3056 _159_.Y _166_.A 0.03509f
C3057 _162_.Y a_12328_7010# 0.01072f
C3058 _136_.A a_7727_4727# 0.03595f
C3059 _225_.A _214_.Y 0.21499f
C3060 _151_.B VDD 0.87646f
C3061 a_2436_8440# a_3601_8797# 0.22369f
C3062 a_8292_17064# a_8580_16759# 0.22255f
C3063 a_11974_8436# VDD 0.18397f
C3064 a_9994_9409# _228_.Y 0.13224f
C3065 _251_.CLK _226_.Y 0.04939f
C3066 a_11279_9263# _251_.CLK 0.01591f
C3067 a_6060_4166# VDD 0.17088f
C3068 fanout6.A a_4625_16800# 0.0565f
C3069 _251_.CLK a_10408_7806# 0.01104f
C3070 _236_.A _260_.CLK 0.07306f
C3071 _119_.A0 a_2667_12983# 0.01781f
C3072 a_11846_12210# VDD 0.44828f
C3073 a_9734_9186# VDD 0.44694f
C3074 _215_.A VDD 2.74434f
C3075 _228_.Y _168_.A 0.02245f
C3076 a_1192_7712# _125_.A1 0.13284f
C3077 a_9675_13844# a_10672_13942# 0.01528f
C3078 a_8870_13722# a_9444_13735# 0.16388f
C3079 _252_.RESET_B VDD 1.03892f
C3080 _134_.Y a_12886_13350# 0.06003f
C3081 _183_.Y _171_.Y 0.23371f
C3082 _226_.Y a_16240_5654# 0.0605f
C3083 a_15339_8447# a_16079_8797# 0.15395f
C3084 a_14794_8404# _166_.A 0.01304f
C3085 _133_.Y _261_.RESET_B 0.01781f
C3086 _225_.A a_9994_17476# 0.03546f
C3087 _215_.A a_1376_4782# 0.01113f
C3088 _243_.Q _143_.A 0.01504f
C3089 a_2075_4692# VDD 0.49954f
C3090 a_7882_15964# VDD 0.09714f
C3091 a_8709_16725# fanout7.A 0.15393f
C3092 _179_.Y a_7157_9948# 0.02635f
C3093 a_3717_4629# a_3819_4772# 0.26919f
C3094 _164_.Y _166_.A 0.01847f
C3095 _200_.Y a_6286_15276# 0.21186f
C3096 _207_.A2 _222_.A 0.03048f
C3097 _131_.B1 _235_.Y 0.04079f
C3098 _124_.S a_1862_16746# 0.02926f
C3099 _125_.A1 sdata 0.05312f
C3100 _148_.A a_5226_5412# 0.0922f
C3101 a_16079_11821# VDD 0.17281f
C3102 _194_.X a_8870_13722# 0.15513f
C3103 a_6182_4650# VDD 0.44952f
C3104 a_1862_16746# a_2436_16759# 0.16388f
C3105 _151_.X _226_.Y 0.03517f
C3106 clkbuf_1_0__f_sclk.A a_3886_10702# 0.92549f
C3107 _133_.Y a_12651_12332# 0.03249f
C3108 fanout8.A a_9160_17594# 0.02413f
C3109 a_1192_17508# VDD 0.16746f
C3110 a_6862_15532# a_7074_15532# 0.11244f
C3111 _148_.A _243_.Q 0.24279f
C3112 a_10784_8522# VDD 0.08788f
C3113 a_2150_8874# a_2724_8861# 0.16388f
C3114 _207_.A2 a_5147_15996# 0.05188f
C3115 a_2410_8404# a_2853_8447# 0.02242f
C3116 _186_.Y _193_.Y 0.57519f
C3117 a_14940_16710# a_15861_16904# 0.21121f
C3118 a_15599_15311# VDD 0.17667f
C3119 _131_.A2 a_13883_11460# 0.04334f
C3120 a_10020_9504# _251_.CLK 0.10672f
C3121 _243_.Q a_4465_4727# 0.02294f
C3122 a_11536_17750# a_11279_17869# 0.20069f
C3123 _256_.RESET_B a_10415_12287# 0.07583f
C3124 _236_.A a_12424_15366# 0.01484f
C3125 a_9156_14040# a_9573_13701# 0.22605f
C3126 a_8870_13722# a_9675_13844# 0.06896f
C3127 _251_.CLK _227_.Y 0.10994f
C3128 _226_.Y a_14724_5416# 0.21328f
C3129 a_14063_16357# a_13969_16357# 0.15029f
C3130 fanout8.A rst 0.04974f
C3131 a_14058_12508# _129_.Y 0.01929f
C3132 a_4744_9318# a_4928_9318# 0.0262f
C3133 _136_.A _168_.Y 0.10408f
C3134 a_2126_10214# a_2558_9972# 0.02903f
C3135 a_2232_10210# a_2298_9972# 0.03308f
C3136 _225_.A _158_.Y 0.05836f
C3137 _122_.A0 _173_.Y 0.16949f
C3138 _207_.A2 _207_.Y 0.04622f
C3139 _147_.A1 a_10607_4727# 0.01f
C3140 _236_.A _129_.B1 0.02512f
C3141 a_9675_12332# a_10415_12287# 0.15395f
C3142 _228_.Y VDD 1.0005f
C3143 _138_.Y a_9062_4650# 0.05833f
C3144 _247_.CLK a_2244_12528# 0.04475f
C3145 _214_.Y a_10539_17519# 0.04709f
C3146 _214_.Y freq_in 0.03196f
C3147 _251_.CLK a_6468_4968# 0.05962f
C3148 _124_.S a_2232_10210# 0.11913f
C3149 _215_.A a_3300_5416# 0.02732f
C3150 _139_.X a_11381_3900# 0.09643f
C3151 _185_.Y _171_.Y 0.01274f
C3152 _171_.A a_7157_9948# 0.04642f
C3153 a_8156_14020# VDD 0.11751f
C3154 a_12923_11460# VDD 0.16547f
C3155 _236_.Y a_15108_11885# 0.01288f
C3156 a_2148_16000# a_3313_16357# 0.22369f
C3157 _242_.RESET_B VDD 1.02614f
C3158 _148_.A a_3956_6888# 0.0194f
C3159 a_6779_12972# VDD 0.17394f
C3160 fanout7.A a_9073_16357# 0.01746f
C3161 a_9928_8522# VDD 0.15544f
C3162 _179_.Y _178_.Y 0.28868f
C3163 _131_.A2 a_14534_11898# 0.01833f
C3164 a_14314_15457# VDD 0.09587f
C3165 a_15071_17016# a_14919_16964# 0.27006f
C3166 a_16736_4782# VDD 0.08712f
C3167 _148_.B _162_.Y 0.09351f
C3168 a_15237_9165# a_15108_9199# 0.01562f
C3169 a_9348_4968# a_9867_4772# 0.18372f
C3170 a_10020_17512# a_10308_17933# 0.22255f
C3171 a_17032_10830# VDD 0.14777f
C3172 a_11279_17869# VDD 0.17318f
C3173 _151_.B a_13073_7728# 0.01441f
C3174 a_9573_13701# VDD 0.25511f
C3175 a_4928_9318# VDD 0.0715f
C3176 _186_.Y a_8156_9928# 0.01075f
C3177 _189_.X VDD 0.49352f
C3178 a_3274_4873# VDD 0.11334f
C3179 _153_.Y _166_.A 0.02151f
C3180 _244_.D VDD 0.28999f
C3181 _261_.RESET_B a_12106_12433# 0.15784f
C3182 _128_.B1 VDD 0.40634f
C3183 _186_.Y _179_.Y 0.02388f
C3184 a_6048_13011# VDD 0.1782f
C3185 a_2171_6204# a_2048_6294# 0.01108f
C3186 a_15243_12332# a_15983_12287# 0.15395f
C3187 a_9352_17508# VDD 0.18461f
C3188 _222_.A _209_.Y 0.31002f
C3189 a_5265_12532# VDD 0.01064f
C3190 _236_.A a_10020_17512# 0.04429f
C3191 _242_.D VDD 0.40292f
C3192 _236_.Y a_14794_11428# 0.1464f
C3193 a_7985_13776# a_8156_14020# 0.19823f
C3194 a_1862_16434# a_2436_16421# 0.16388f
C3195 a_2122_15964# a_2565_16007# 0.02242f
C3196 _220_.Y _120_.X 0.10342f
C3197 a_14940_16710# a_14830_16746# 0.22369f
C3198 a_4593_17068# VDD 0.01074f
C3199 _259_.RESET_B a_8266_16969# 0.16101f
C3200 fanout7.A _260_.CLK 0.12567f
C3201 fanout7.A a_8325_16007# 0.16009f
C3202 _124_.S a_2171_6204# 0.13628f
C3203 _168_.A a_6677_8806# 0.02596f
C3204 _263_.CLK a_15889_12287# 0.01343f
C3205 a_14820_9504# a_15339_9308# 0.18372f
C3206 _214_.A _241_.Y 0.07058f
C3207 a_2126_7864# _148_.A 0.28346f
C3208 a_8352_11013# VDD 0.17399f
C3209 _260_.CLK _126_.Y 0.06754f
C3210 _176_.A VDD 0.89281f
C3211 _145_.X a_13376_4782# 0.01021f
C3212 a_10888_16878# _212_.Y 0.02017f
C3213 _184_.Y a_7157_9948# 0.07179f
C3214 fanout6.A _241_.Y 0.03663f
C3215 _201_.Y a_6862_15532# 0.03473f
C3216 _122_.A0 a_2410_9409# 0.02637f
C3217 _178_.Y _171_.A 0.05894f
C3218 a_12778_15964# a_13221_16007# 0.02242f
C3219 _260_.RESET_B a_15339_9308# 0.21421f
C3220 a_4362_9484# VDD 0.24273f
C3221 _159_.Y _227_.Y 0.14426f
C3222 _243_.RESET_B VDD 1.18788f
C3223 a_2075_5468# a_2398_5782# 0.22783f
C3224 _210_.Y a_6095_4270# 0.04074f
C3225 _179_.Y _164_.Y 0.29702f
C3226 a_3952_9406# a_4362_9484# 0.05221f
C3227 _154_.X a_9248_7806# 0.01277f
C3228 _238_.Y a_14919_16964# 0.2168f
C3229 _239_.Y VDD 1.0607f
C3230 a_2126_13912# _119_.X 0.11982f
C3231 _215_.A sdata 0.01079f
C3232 _136_.A _170_.Y 0.10882f
C3233 _214_.A a_11781_16725# 0.18176f
C3234 _133_.Y a_12886_13350# 0.02179f
C3235 a_14438_12210# a_15141_12189# 0.02454f
C3236 _152_.X _147_.Y 0.01493f
C3237 fanout6.A a_11781_16725# 0.01182f
C3238 a_5226_5412# VDD 0.24407f
C3239 _202_.Y a_7074_15532# 0.01389f
C3240 _224_.Y a_6442_4873# 0.15864f
C3241 a_10020_9504# _164_.Y 0.014f
C3242 a_4170_12508# VDD 0.24648f
C3243 a_10020_9504# a_10308_9199# 0.22255f
C3244 _176_.A a_6336_11499# 0.09009f
C3245 a_12549_12189# a_13297_12287# 0.01058f
C3246 a_13391_12287# a_14058_12508# 0.06982f
C3247 _227_.Y a_14794_8404# 0.13777f
C3248 _190_.A _192_.Y 0.04783f
C3249 _131_.B1 _131_.Y 0.41689f
C3250 _236_.A _236_.Y 0.38885f
C3251 a_7232_14570# VDD 0.07892f
C3252 _266_.CLK _239_.Y 0.0236f
C3253 _243_.Q VDD 1.24692f
C3254 a_7808_10034# VDD 0.06744f
C3255 _136_.A a_10769_4258# 0.20467f
C3256 _247_.CLK _148_.B 0.10688f
C3257 _147_.A1 _252_.RESET_B 0.01838f
C3258 _207_.A1 a_10218_17044# 0.01521f
C3259 _148_.B a_12808_13854# 0.02187f
C3260 _145_.A2 a_8021_5782# 0.01197f
C3261 a_9130_12433# a_8870_12210# 0.39302f
C3262 _252_.D a_7727_4727# 0.011f
C3263 _124_.S a_2436_13397# 0.02536f
C3264 _207_.A1 _207_.B1 0.03574f
C3265 a_4559_5773# a_5226_5412# 0.06982f
C3266 _173_.A a_2126_10214# 0.10665f
C3267 _251_.CLK _136_.A 0.03681f
C3268 _260_.CLK a_15339_9308# 0.036f
C3269 a_13184_8522# VDD 0.06584f
C3270 _247_.CLK a_2565_16007# 0.17626f
C3271 _225_.A _148_.B 0.02456f
C3272 a_2661_12189# a_3409_12287# 0.01058f
C3273 a_3760_12430# a_4170_12508# 0.05221f
C3274 a_17120_6294# VDD 0.07973f
C3275 clkbuf_1_0__f_sclk.A VDD 3.22317f
C3276 _124_.S a_2661_12189# 0.01465f
C3277 _131_.B1 a_14820_11464# 0.01345f
C3278 _261_.RESET_B a_12651_12332# 0.21421f
C3279 a_2955_9308# VDD 0.22359f
C3280 _122_.A0 a_2955_8447# 0.0257f
C3281 a_16650_5412# VDD 0.24613f
C3282 a_6336_11499# a_6485_11830# 0.17527f
C3283 a_8427_16007# a_9167_16357# 0.15395f
C3284 a_2955_9308# a_3952_9406# 0.01528f
C3285 _135_.A a_14048_16878# 0.01342f
C3286 a_2494_6166# a_2608_6166# 0.0308f
C3287 _207_.A1 a_8811_16868# 0.02768f
C3288 a_2565_12983# VDD 0.25173f
C3289 _186_.Y _194_.X 0.0139f
C3290 a_3592_10830# sclk 0.01905f
C3291 _119_.A0 a_2298_15238# 0.02022f
C3292 _240_.Y a_10020_17512# 0.21759f
C3293 _164_.Y a_10989_8784# 0.14987f
C3294 a_7624_10034# a_7808_10034# 0.0262f
C3295 a_13290_17044# VDD 0.24014f
C3296 _131_.B1 a_14651_10996# 0.02408f
C3297 _122_.A0 _219_.Y 0.11265f
C3298 a_3717_5423# VDD 0.27764f
C3299 _225_.A _252_.D 0.04211f
C3300 _236_.A a_8870_12210# 0.01232f
C3301 _178_.Y _184_.Y 0.09298f
C3302 a_1958_12210# VDD 0.44995f
C3303 fanout6.A a_8292_17064# 0.01345f
C3304 _199_.B1 _196_.Y 0.10872f
C3305 _173_.Y a_5242_8806# 0.01575f
C3306 a_1952_11546# VDD 0.09003f
C3307 _236_.A _241_.Y 0.06104f
C3308 a_2667_12983# a_3664_13214# 0.01569f
C3309 _179_.Y _183_.Y 0.34346f
C3310 a_2565_12983# a_3313_13333# 0.01058f
C3311 _171_.Y _170_.B 0.03681f
C3312 _225_.A a_13221_16007# 0.05325f
C3313 a_3956_6888# VDD 1.65035f
C3314 _263_.CLK _132_.Y 0.08729f
C3315 _171_.A _165_.Y 0.15495f
C3316 _162_.B _148_.X 0.01005f
C3317 _144_.B a_9062_4650# 0.03814f
C3318 _215_.A sclk 0.0391f
C3319 _196_.Y _195_.Y 0.54513f
C3320 a_13290_17044# _266_.CLK 0.06948f
C3321 _174_.Y _168_.B 0.07226f
C3322 _143_.A a_7984_4870# 0.03206f
C3323 a_6885_4629# a_7633_4727# 0.01058f
C3324 a_7727_4727# a_8394_4948# 0.06982f
C3325 a_2244_12528# a_3503_12287# 0.01303f
C3326 a_13000_8522# a_13184_8522# 0.0262f
C3327 _124_.S _120_.A0 0.28075f
C3328 a_3380_13690# clkbuf_1_0__f_sclk.A 0.36217f
C3329 a_13041_5412# VDD 0.0107f
C3330 _173_.A _136_.A 0.33024f
C3331 _170_.B a_8014_8492# 0.01895f
C3332 a_8538_5375# a_8564_5412# 0.19823f
C3333 _209_.Y a_7328_16878# 0.01157f
C3334 a_7908_16000# a_8196_16421# 0.22255f
C3335 a_2436_9504# _243_.CLK 0.06774f
C3336 a_2853_9165# a_2955_9308# 0.26919f
C3337 _160_.B VDD 0.36317f
C3338 a_15983_5773# a_16650_5412# 0.06982f
C3339 _256_.RESET_B a_8870_12210# 0.115f
C3340 _148_.A _143_.A 0.19802f
C3341 _152_.X a_12712_5498# 0.03551f
C3342 _164_.Y _160_.X 0.07078f
C3343 _207_.A1 _205_.Y 0.013f
C3344 a_11078_16746# VDD 0.44854f
C3345 _224_.Y a_6987_4772# 0.21421f
C3346 _196_.Y _190_.A 0.13528f
C3347 a_6528_8475# a_6677_8806# 0.17527f
C3348 a_2148_17064# a_3407_16823# 0.01303f
C3349 _148_.B a_5084_12972# 0.02754f
C3350 a_1864_13854# VDD 0.14536f
C3351 _145_.X _166_.A 0.12502f
C3352 a_1862_13410# a_2667_12983# 0.06896f
C3353 a_2148_12976# a_2565_12983# 0.22698f
C3354 a_10764_5678# a_10799_5782# 0.17527f
C3355 _258_.RESET_B _259_.RESET_B 0.04922f
C3356 a_11536_9406# _180_.X 0.01553f
C3357 _258_.RESET_B a_9424_16238# 0.0605f
C3358 a_10415_12287# a_11082_12508# 0.06982f
C3359 a_8870_12210# a_9675_12332# 0.06896f
C3360 a_9156_12528# a_9573_12189# 0.22605f
C3361 a_17120_9318# VDD 0.06793f
C3362 _178_.B1 _178_.Y 0.26629f
C3363 _148_.B _182_.Y 0.17237f
C3364 a_11364_17064# a_12529_16823# 0.22369f
C3365 a_12880_16966# a_13290_17044# 0.05221f
C3366 a_11883_16868# a_11652_16759# 0.06628f
C3367 _201_.Y _202_.Y 0.36476f
C3368 a_2126_7864# VDD 0.1061f
C3369 _145_.X a_13740_5678# 0.04128f
C3370 _136_.A _138_.Y 0.07987f
C3371 _205_.Y a_6862_15532# 0.22653f
C3372 _225_.A _252_.RESET_B 0.13817f
C3373 a_3300_5416# a_3717_5423# 0.22698f
C3374 _135_.A a_14054_15234# 0.20329f
C3375 _179_.Y _185_.Y 0.03023f
C3376 _147_.Y a_11661_4696# 0.0236f
C3377 _122_.A0 a_7985_7728# 0.06292f
C3378 a_2436_8440# VDD 0.09296f
C3379 _126_.B1 a_13464_12952# 0.01142f
C3380 a_7622_16434# a_7882_15964# 0.39302f
C3381 a_15767_17137# VDD 0.45227f
C3382 _205_.Y _199_.B1 0.02876f
C3383 a_15599_15311# a_15505_15311# 0.15029f
C3384 a_14724_5416# a_15889_5773# 0.22369f
C3385 a_4144_4142# a_4554_3900# 0.05221f
C3386 _186_.Y _178_.B1 0.01642f
C3387 _170_.B _166_.A 0.11967f
C3388 _186_.Y a_7553_14832# 0.0129f
C3389 _119_.X a_1580_12936# 0.02758f
C3390 _157_.B a_13244_5412# 0.04599f
C3391 a_14730_15996# VDD 0.2396f
C3392 a_15237_8447# VDD 0.2408f
C3393 _186_.Y a_8050_10326# 0.054f
C3394 a_1862_16746# a_2565_16725# 0.02454f
C3395 a_8266_16969# VDD 0.09403f
C3396 _251_.CLK a_15980_7638# 0.14914f
C3397 a_2232_13916# a_2558_14020# 0.02726f
C3398 _173_.A a_2298_11830# 0.01668f
C3399 a_2126_11726# a_2298_11484# 0.01057f
C3400 a_10437_9165# _180_.X 0.01109f
C3401 a_16079_9263# VDD 0.17004f
C3402 _266_.CLK a_14730_15996# 0.01675f
C3403 a_11364_17064# a_12623_16823# 0.01303f
C3404 a_15339_11471# a_16079_11821# 0.15395f
C3405 _221_.Y _220_.Y 0.02888f
C3406 a_11944_16082# VDD 0.1574f
C3407 _136_.A _165_.Y 0.16233f
C3408 _157_.B a_13073_5770# 0.22465f
C3409 _173_.Y _174_.Y 0.71883f
C3410 _158_.Y _159_.Y 0.03535f
C3411 fanout6.A a_7908_16000# 0.03186f
C3412 _263_.CLK a_15237_11471# 0.1665f
C3413 _221_.Y a_2667_12983# 0.21477f
C3414 a_2148_16000# VDD 0.07939f
C3415 _145_.A2 a_8538_5375# 0.15812f
C3416 _160_.X _153_.Y 0.045f
C3417 a_7953_7996# VDD 0.01061f
C3418 _191_.Y _192_.Y 0.1747f
C3419 _205_.Y a_6720_17061# 0.12208f
C3420 a_14340_15552# a_14628_15247# 0.22255f
C3421 _164_.Y a_8050_10326# 0.07866f
C3422 a_3045_3911# a_3147_3911# 0.27006f
C3423 _228_.Y _225_.A 0.06627f
C3424 a_14438_5850# a_15243_5423# 0.06896f
C3425 _131_.A2 a_14438_12210# 0.03296f
C3426 _171_.A _185_.Y 0.09749f
C3427 _136_.A _136_.B 0.15292f
C3428 _138_.Y a_8557_4248# 0.02132f
C3429 _243_.Q _147_.A1 0.05902f
C3430 a_13740_5678# a_13775_5782# 0.17527f
C3431 a_12804_16000# VDD 0.0737f
C3432 fanout8.A fanout6.A 0.03136f
C3433 a_13073_7728# _160_.B 0.13212f
C3434 a_6836_3900# VDD 0.11829f
C3435 a_11661_4696# _147_.B1 0.06451f
C3436 _145_.X a_13403_8436# 0.03048f
C3437 _120_.A0 a_2232_11722# 0.0162f
C3438 _119_.A0 a_4913_13330# 0.06673f
C3439 a_13648_12430# VDD 0.12752f
C3440 a_14359_16710# a_14919_16964# 0.15395f
C3441 _157_.Y a_13184_7183# 0.01135f
C3442 _225_.A a_9928_8522# 0.01252f
C3443 _148_.B _251_.CLK 0.0444f
C3444 a_12215_7664# VDD 0.28553f
C3445 _225_.A a_14314_15457# 0.01631f
C3446 _201_.Y _258_.D 0.0121f
C3447 _148_.X _147_.Y 0.20034f
C3448 a_4512_17547# a_4661_17878# 0.17527f
C3449 a_16079_8797# _166_.A 0.01481f
C3450 _266_.CLK a_12804_16000# 0.08524f
C3451 a_14820_11464# a_16079_11821# 0.01303f
C3452 _225_.A a_11279_17869# 0.01337f
C3453 _124_.S a_2126_15424# 0.09153f
C3454 fanout7.A _166_.A 0.1316f
C3455 _132_.Y VDD 0.31092f
C3456 _259_.RESET_B VDD 1.06908f
C3457 _201_.Y _191_.Y 0.01038f
C3458 _168_.B a_5372_9484# 0.05433f
C3459 _186_.Y _192_.B 0.01166f
C3460 a_9808_16966# a_10218_17044# 0.05221f
C3461 a_9424_16238# VDD 0.12553f
C3462 _171_.Y a_8603_9484# 0.05237f
C3463 a_3014_4650# a_3588_4663# 0.16388f
C3464 a_3819_4772# a_4816_4870# 0.01528f
C3465 fanout8.A a_2126_17774# 0.02072f
C3466 a_2126_10214# _246_.D 0.116f
C3467 _187_.Y a_4858_12214# 0.01727f
C3468 _165_.Y a_7258_8806# 0.01842f
C3469 _144_.B a_10764_5678# 0.11194f
C3470 _251_.CLK _252_.D 0.50198f
C3471 _251_.CLK a_9322_4873# 0.01015f
C3472 _170_.B _154_.X 0.11491f
C3473 _131_.A2 _260_.CLK 2.13164f
C3474 _236_.A a_12132_12528# 0.04185f
C3475 _143_.A VDD 0.9093f
C3476 a_3886_10702# VDD 1.66186f
C3477 a_7984_4870# VDD 0.1282f
C3478 a_4462_16052# _207_.B1 0.13756f
C3479 a_14340_15552# a_14859_15356# 0.18372f
C3480 a_2342_4338# a_3045_3911# 0.02432f
C3481 a_14438_5850# a_14698_5380# 0.39302f
C3482 a_13824_7989# a_13973_7678# 0.17527f
C3483 _157_.Y _166_.A 0.05926f
C3484 _225_.A a_9352_17508# 0.13544f
C3485 a_8006_16746# a_8580_16759# 0.16388f
C3486 a_2724_8861# a_2955_8447# 0.06628f
C3487 a_8811_16868# a_9808_16966# 0.01528f
C3488 a_10895_8436# VDD 0.28718f
C3489 _124_.S a_2398_4654# 0.07741f
C3490 _263_.CLK VDD 1.01962f
C3491 a_14534_9186# VDD 0.44676f
C3492 _148_.A a_12572_4948# 0.01008f
C3493 a_11946_17508# _214_.A 0.07055f
C3494 _119_.A0 a_2436_13397# 0.01929f
R0 GND.t583 GND.t456 54728
R1 GND.t1570 GND.n510 46757.2
R2 GND.t507 GND.n857 38023.5
R3 GND.t1391 GND.t29 26307.1
R4 GND.n502 GND.n501 22525.7
R5 GND.n524 GND.t158 21142.7
R6 GND.n868 GND.n867 14780.3
R7 GND.n862 GND.t324 8036.11
R8 GND.n773 GND.t456 7250
R9 GND.n89 GND.n876 4398.56
R10 GND.n765 GND.t1570 4262.19
R11 GND.n516 GND.n514 4232.88
R12 GND.t83 GND.n875 4108.7
R13 GND.t83 GND.n791 4108.7
R14 GND.n791 GND.t217 4108.7
R15 GND.t217 GND.n790 4108.7
R16 GND.n790 GND.t62 4108.7
R17 GND.t62 GND.t358 4108.7
R18 GND.n763 GND.t358 4108.7
R19 GND.t601 GND.n763 4108.7
R20 GND.t601 GND.n524 4108.7
R21 GND.n876 GND.t82 4079.14
R22 GND.t82 GND.n348 4079.14
R23 GND.t72 GND.n348 4079.14
R24 GND.t72 GND.n505 4079.14
R25 GND.t3 GND.n505 4079.14
R26 GND.t3 GND.n771 4079.14
R27 GND.n771 GND.n770 4079.14
R28 GND.n770 GND.t10 4079.14
R29 GND.t10 GND.t158 4079.14
R30 GND.t324 GND.n861 3592.89
R31 GND.n521 GND.t326 3494.97
R32 GND.n858 GND.t141 2371.54
R33 GND.n511 GND.t1416 1562.5
R34 GND.n521 GND.t1406 1140.62
R35 GND.n89 GND.t1278 157.976
R36 GND.t1283 GND.n89 157.976
R37 GND.t1308 GND.n89 157.976
R38 GND.n89 GND.t1326 156.482
R39 GND.t1334 GND.n89 157.976
R40 GND.t1351 GND.n89 156.482
R41 GND.t1364 GND.n89 157.976
R42 GND.t224 GND.n89 22.0347
R43 GND.n875 GND.n89 4425.74
R44 GND.t326 GND.t1407 500
R45 GND.t519 GND.n348 427.779
R46 GND.n219 GND.n505 427.755
R47 GND.t471 GND.t234 76.3513
R48 GND.n790 GND.n221 427.132
R49 GND.t249 GND.t1566 72.0417
R50 GND.n137 GND.t1439 26.1545
R51 GND.n771 GND.n20 427.132
R52 GND.t578 GND.t789 109.986
R53 GND.t621 GND.n119 96.0227
R54 GND.n91 GND.t46 9.79521
R55 GND.t355 GND.n795 422.846
R56 GND.t361 GND.n85 4.08146
R57 GND.n187 GND.t670 422.846
R58 GND.n78 GND.t675 422.846
R59 GND.n57 GND.t179 422.846
R60 GND.t494 GND.n48 422.846
R61 GND.t637 GND.n269 418.56
R62 GND.t1466 GND.n122 418.841
R63 GND.n203 GND.t313 418.56
R64 GND.t1460 GND.n76 418.56
R65 GND.n18 GND.t540 418.56
R66 GND.t5 GND.t1153 237.142
R67 GND.t396 GND.t14 53.8079
R68 GND.t636 GND.n275 414.274
R69 GND.t265 GND.n132 414.555
R70 GND.n121 GND.t459 11.995
R71 GND.n75 GND.t1541 414.274
R72 GND.n58 GND.t1540 414.274
R73 GND.n455 GND.t581 67.2827
R74 GND.n875 GND.n383 427.132
R75 GND.n282 GND.t1231 242.846
R76 GND.n345 GND.t353 19.9891
R77 GND.t1259 GND.n235 242.846
R78 GND.t1261 GND.n346 242.846
R79 GND.n876 GND.n26 427.132
R80 GND.n791 GND.n340 411.43
R81 GND.t1117 GND.n341 242.846
R82 GND.t988 GND.n323 242.846
R83 GND.n80 GND.t1533 60.1439
R84 GND.t957 GND.n234 221.417
R85 GND.n416 GND.t175 28.5605
R86 GND.t922 GND.n414 242.846
R87 GND.n415 GND.t109 32.8462
R88 GND.n763 GND.t578 427.5
R89 GND.t834 GND.n86 243.171
R90 GND.t336 GND.n314 88.5605
R91 GND.t846 GND.n313 242.846
R92 GND.t801 GND.n312 242.846
R93 GND.t804 GND.n148 242.846
R94 GND.t807 GND.n311 242.846
R95 GND.t816 GND.n283 242.846
R96 GND.t494 GND.n315 19.9891
R97 GND.n770 GND.n50 427.132
R98 GND.n545 GND.n524 411.43
R99 GND.n282 GND.t353 422.846
R100 GND.t341 GND.n130 413.861
R101 GND.t669 GND.n493 407.144
R102 GND.n141 GND.t665 422.846
R103 GND.n549 GND.t1530 402.858
R104 GND.n826 GND.t1579 398.572
R105 GND.n98 GND.t1562 75.2357
R106 GND.n590 GND.t560 398.572
R107 GND.n597 GND.t281 398.572
R108 GND.t282 GND.n570 398.572
R109 GND.n661 GND.t1426 398.572
R110 GND.t1427 GND.n653 398.572
R111 GND.t1453 GND.n646 398.572
R112 GND.n690 GND.t88 398.572
R113 GND.t137 GND.n682 398.572
R114 GND.n137 GND.t294 75.2357
R115 GND.t252 GND.n471 398.572
R116 GND.n716 GND.t175 398.572
R117 GND.n728 GND.t538 398.572
R118 GND.n722 GND.t103 398.572
R119 GND.n736 GND.t603 398.572
R120 GND.t541 GND.n485 395.416
R121 GND.t329 GND.n629 395.159
R122 GND.t206 GND.n794 394.286
R123 GND.n819 GND.t1499 394.286
R124 GND.t203 GND.n582 394.286
R125 GND.n641 GND.t331 394.286
R126 GND.t201 GND.n657 394.286
R127 GND.n698 GND.t543 394.286
R128 GND.n491 GND.t110 394.286
R129 GND.t196 GND.n525 394.286
R130 GND.t178 GND.n531 394.286
R131 GND.n737 GND.t1525 394.286
R132 GND.t192 GND.n541 394.286
R133 GND.n834 GND.t87 391.668
R134 GND.t193 GND.n701 391.214
R135 GND.t416 GND.t339 390
R136 GND.n762 GND.t1582 390
R137 GND.t322 GND.n805 385.714
R138 GND.n843 GND.t74 385.714
R139 GND.n622 GND.t24 385.714
R140 GND.n745 GND.t304 385.714
R141 GND.n277 GND.t638 384.274
R142 GND.t429 GND.n5 384.274
R143 GND.n201 GND.t594 384.274
R144 GND.t440 GND.n723 384.274
R145 GND.t614 GND.n822 381.43
R146 GND.n811 GND.t1547 381.43
R147 GND.t611 GND.n604 381.43
R148 GND.n781 GND.t1544 381.43
R149 GND.t492 GND.n60 379.99
R150 GND.t141 GND.t507 379.447
R151 GND.n118 GND.t21 0.359562
R152 GND.t14 GND.n124 0.35956
R153 GND.t520 GND.n828 377.144
R154 GND.t659 GND.n613 377.144
R155 GND.n633 GND.t501 377.144
R156 GND.n692 GND.t575 377.144
R157 GND.n475 GND.t255 377.144
R158 GND.n550 GND.t1409 377.144
R159 GND.t53 GND.n97 43.6455
R160 GND.n68 GND.t581 376.724
R161 GND.n178 GND.t156 376.724
R162 GND.n589 GND.t558 372.858
R163 GND.t561 GND.n578 372.858
R164 GND.t280 GND.n572 372.858
R165 GND.n599 GND.t283 372.858
R166 GND.t1425 GND.n655 372.858
R167 GND.n663 GND.t1428 372.858
R168 GND.n669 GND.t1452 372.858
R169 GND.t1455 GND.n645 372.858
R170 GND.n733 GND.t617 372.858
R171 GND.t1524 GND.n735 372.858
R172 GND.t1380 GND.n532 372.858
R173 GND.t135 GND.n683 368.572
R174 GND.t1459 GND.n472 368.572
R175 GND.t318 GND.n734 368.572
R176 GND.t351 GND.n34 367.135
R177 GND.t250 GND.n73 367.135
R178 GND.n268 GND.t1398 367.132
R179 GND.n773 GND.t241 365.279
R180 GND.t111 GND.t586 364.286
R181 GND.t476 GND.t442 364.286
R182 GND.n474 GND.t484 364.286
R183 GND.n225 GND.t1456 362.846
R184 GND.n776 GND.t385 362.07
R185 GND.n856 GND.t350 361.033
R186 GND.t1503 GND.n84 376.781
R187 GND.t248 GND.n484 361.033
R188 GND.t293 GND.n782 361.033
R189 GND.n701 GND.t1431 361.033
R190 GND.n806 GND.t612 360
R191 GND.n844 GND.t75 360
R192 GND.n623 GND.t22 360
R193 GND.n758 GND.t220 360
R194 GND.n746 GND.t475 360
R195 GND.n810 GND.t1545 355.714
R196 GND.n818 GND.t1474 355.714
R197 GND.n813 GND.t432 355.714
R198 GND.t610 GND.n624 355.714
R199 GND.t263 GND.n615 355.714
R200 GND.n671 GND.t472 355.714
R201 GND.n687 GND.t650 355.714
R202 GND.n697 GND.t542 355.714
R203 GND.t6 GND.n800 351.43
R204 GND.t66 GND.n85 351.594
R205 GND.n827 GND.t1470 351.43
R206 GND.n820 GND.t1471 351.43
R207 GND.t1562 GND.n840 351.43
R208 GND.n620 GND.t18 351.43
R209 GND.t1504 GND.n630 351.43
R210 GND.n634 GND.t502 351.43
R211 GND.t434 GND.n681 351.43
R212 GND.t1583 GND.n492 351.43
R213 GND.t549 GND.n480 351.43
R214 GND.n483 GND.t130 351.43
R215 GND.t294 GND.n786 351.43
R216 GND.n80 GND.t1487 99.1558
R217 GND.t91 GND.n471 351.43
R218 GND.t1537 GND.n715 351.43
R219 GND.n729 GND.t306 351.43
R220 GND.t579 GND.n754 351.43
R221 GND.t246 GND.n102 60.3116
R222 GND.n864 GND.t506 350.976
R223 GND.n802 GND.t17 347.144
R224 GND.t488 GND.n824 347.144
R225 GND.n841 GND.t654 347.144
R226 GND.t556 GND.n580 347.144
R227 GND.n596 GND.t278 347.144
R228 GND.n635 GND.t1440 347.144
R229 GND.t1429 GND.n652 347.144
R230 GND.n490 GND.t112 347.144
R231 GND.n717 GND.t1507 347.144
R232 GND.n760 GND.t314 347.144
R233 GND.t335 GND.n732 347.144
R234 GND.t1265 GND.n89 156.288
R235 GND.t1285 GND.n89 156.482
R236 GND.n89 GND.t1295 156.482
R237 GND.t1310 GND.n89 156.482
R238 GND.t1346 GND.n89 156.482
R239 GND.t1356 GND.n89 156.482
R240 GND.t239 GND.n838 345.834
R241 GND.n642 GND.t338 343.841
R242 GND.n503 GND.n502 343.75
R243 GND.t453 GND.n508 341.668
R244 GND.t399 GND.n36 341.418
R245 GND.t619 GND.t115 338.572
R246 GND.t301 GND.n509 337.5
R247 GND.n848 GND.t406 336.502
R248 GND.t431 GND.n614 334.286
R249 GND.t317 GND.n757 334.286
R250 GND.n747 GND.t1505 334.286
R251 GND.n89 GND.t1324 157.976
R252 GND.n586 GND.t1549 330
R253 GND.n659 GND.t639 330
R254 GND.t504 GND.n685 330
R255 GND.t102 GND.n677 330
R256 GND.t1501 GND.n721 330
R257 GND.n526 GND.t600 330
R258 GND.n546 GND.t655 330
R259 GND.n266 GND.t1520 329.185
R260 GND.n873 GND.t118 329.168
R261 GND.t149 GND.n831 329.168
R262 GND.n90 GND.t1563 340.188
R263 GND.t360 GND.n92 17.0819
R264 GND.n83 GND.t320 340.188
R265 GND.n708 GND.t132 329.168
R266 GND.t308 GND.n93 167.082
R267 GND.n766 GND.t176 329.168
R268 GND.n564 GND.t509 329.168
R269 GND.n30 GND.t1555 328.56
R270 GND.n14 GND.t1411 328.56
R271 GND.t167 GND.n799 325.714
R272 GND.n821 GND.t1576 325.714
R273 GND.t1508 GND.t642 325.714
R274 GND.t1487 GND.n789 325.714
R275 GND.n414 GND.t1384 341.418
R276 GND.t563 GND.n577 321.43
R277 GND.n668 GND.t1450 321.43
R278 GND.t113 GND.n759 321.43
R279 GND.n871 GND.t646 320.834
R280 GND.t1382 GND.n706 320.834
R281 GND.t21 GND.n134 12.2559
R282 GND.n100 GND.t1403 64.595
R283 GND.n106 GND.t451 162.888
R284 GND.t1580 GND.n495 320.271
R285 GND.t629 GND.n94 162.888
R286 GND.n24 GND.t1422 319.99
R287 GND.n261 GND.t487 319.99
R288 GND.t153 GND.n71 319.99
R289 GND.t526 GND.n340 312.858
R290 GND.n619 GND.t658 312.858
R291 GND.t574 GND.n684 312.858
R292 GND.t254 GND.n473 312.858
R293 GND.n545 GND.t1394 312.858
R294 GND.t1408 GND.n539 312.858
R295 GND.t243 GND.t16 312.5
R296 GND.t21 GND.n8 0.359442
R297 GND.n124 GND.t477 100.585
R298 GND.n81 GND.t5 11.1066
R299 GND.t945 GND.n785 305.159
R300 GND.t209 GND.n768 305.159
R301 GND.n559 GND.t712 305.159
R302 GND.t593 GND.n829 304.286
R303 GND.t78 GND.n821 304.286
R304 GND.t291 GND.n807 304.286
R305 GND.t183 GND.n844 304.286
R306 GND.n672 GND.t41 304.286
R307 GND.n88 GND.t978 187.369
R308 GND.t1399 GND.n780 304.286
R309 GND.n292 GND.t1522 319.99
R310 GND.t1506 GND.n748 304.286
R311 GND.n566 GND.t496 304.286
R312 GND.n833 GND.t522 304.168
R313 GND.t120 GND.n557 304.168
R314 GND.n260 GND.t1462 303.471
R315 GND.t585 GND.t234 303.469
R316 GND.n89 GND.t1315 159.536
R317 GND.t1376 GND.n89 159.53
R318 GND.n636 GND.t648 300
R319 GND.n488 GND.t1512 300
R320 GND.n133 GND.t340 86.4901
R321 GND.t64 GND.n835 295.834
R322 GND.n592 GND.t564 295.714
R323 GND.n595 GND.t572 295.714
R324 GND.t1442 GND.n651 295.714
R325 GND.t1449 GND.n648 295.714
R326 GND.n520 GND.t1577 291.514
R327 GND.t497 GND.t1485 291.43
R328 GND.n73 GND.t1509 290.777
R329 GND.t1268 GND.n89 157.972
R330 GND.t1298 GND.n89 157.976
R331 GND.t1339 GND.n89 157.976
R332 GND.t1349 GND.n89 157.976
R333 GND.t1369 GND.n89 157.976
R334 GND.t14 GND.t93 3.95885
R335 GND.n814 GND.t332 287.144
R336 GND.n605 GND.t32 287.144
R337 GND.n618 GND.t461 287.144
R338 GND.n689 GND.t620 287.144
R339 GND.t410 GND.n468 287.144
R340 GND.t1500 GND.n116 293.533
R341 GND.t552 GND.t445 282.858
R342 GND.n872 GND.t664 279.168
R343 GND.t244 GND.n705 279.168
R344 GND.t1423 GND.n643 278.572
R345 GND.n775 GND.t1511 275.863
R346 GND.t1550 GND.n4 94.6591
R347 GND.n785 GND.t480 275.072
R348 GND.n714 GND.t1521 275.072
R349 GND.t481 GND.t46 291.149
R350 GND.t1476 GND.n559 275.072
R351 GND.t154 GND.t227 275
R352 GND.t1371 GND.n89 156.482
R353 GND.n89 GND.t1366 156.482
R354 GND.t1361 GND.n89 156.482
R355 GND.t1359 GND.n89 157.976
R356 GND.n89 GND.t1354 157.976
R357 GND.t1341 GND.n89 156.482
R358 GND.n89 GND.t1336 156.482
R359 GND.t1331 GND.n89 156.482
R360 GND.t1329 GND.n89 157.976
R361 GND.t1321 GND.n89 156.482
R362 GND.n89 GND.t1317 156.482
R363 GND.t1313 GND.n89 157.976
R364 GND.t1305 GND.n89 156.482
R365 GND.n89 GND.t1300 156.482
R366 GND.t1290 GND.n89 156.482
R367 GND.t1288 GND.n89 157.976
R368 GND.t1280 GND.n89 156.482
R369 GND.n89 GND.t1275 156.482
R370 GND.t1270 GND.n89 156.482
R371 GND.t208 GND.n793 274.286
R372 GND.n489 GND.t164 274.286
R373 GND.t1585 GND.n583 270
R374 GND.t571 GND.n574 270
R375 GND.t30 GND.n658 270
R376 GND.n665 GND.t1443 270
R377 GND.t1417 GND.n527 270
R378 GND.t1528 GND.n542 270
R379 GND.t235 GND.n798 267.409
R380 GND.n868 GND.n866 266.668
R381 GND.t398 GND.t300 265.714
R382 GND.t535 GND.t426 265.714
R383 GND.t296 GND.t168 265.714
R384 GND.t551 GND.t147 265.714
R385 GND.t1566 GND.t405 265.714
R386 GND.t1486 GND.t124 265.714
R387 GND.t390 GND.t1383 265.714
R388 GND.t1542 GND.n116 97.9413
R389 GND.t107 GND.n14 259.99
R390 GND.t299 GND.t45 259.053
R391 GND.n511 GND.t386 258.909
R392 GND.t423 GND.t38 258.334
R393 GND.t1548 GND.t427 258.334
R394 GND.t212 GND.t527 258.334
R395 GND.n851 GND.t1468 258.334
R396 GND.t383 GND.t1572 258.334
R397 GND.t52 GND.n467 258.334
R398 GND.n779 GND.t547 258.334
R399 GND.t163 GND.t392 258.334
R400 GND.t546 GND.t587 258.334
R401 GND.t632 GND.t311 258.334
R402 GND.n751 GND.t576 258.334
R403 GND.n507 GND.t211 258.334
R404 GND.n767 GND.t580 258.334
R405 GND.t554 GND.t129 258.334
R406 GND.t155 GND.n556 258.334
R407 GND.n858 GND.n856 257.88
R408 GND.n782 GND.t189 257.88
R409 GND.t985 GND.n220 108.639
R410 GND.n228 GND.t1023 252.065
R411 GND.t157 GND.t707 252.065
R412 GND.t234 GND.n130 9.63482
R413 GND.t1114 GND.n250 252.041
R414 GND.t1121 GND.n240 252.041
R415 GND.n245 GND.t1123 252.041
R416 GND.n238 GND.t1125 252.041
R417 GND.t1133 GND.n276 252.041
R418 GND.n266 GND.t1110 252.041
R419 GND.n108 GND.t898 99.5774
R420 GND.t900 GND.n114 99.5774
R421 GND.t878 GND.n101 99.5774
R422 GND.t679 GND.n176 252.041
R423 GND.t737 GND.n167 252.041
R424 GND.n159 GND.t739 252.041
R425 GND.t741 GND.n169 252.041
R426 GND.n157 GND.t743 252.041
R427 GND.t745 GND.n171 252.041
R428 GND.n155 GND.t747 252.041
R429 GND.n23 GND.t1258 251.417
R430 GND.n28 GND.t1260 251.417
R431 GND.t1262 GND.n29 251.417
R432 GND.t1118 GND.n243 251.417
R433 GND.n241 GND.t1085 251.417
R434 GND.n275 GND.t1131 251.417
R435 GND.t1139 GND.n261 251.417
R436 GND.n255 GND.t1105 251.417
R437 GND.t1143 GND.n263 251.417
R438 GND.t1107 GND.n264 251.417
R439 GND.t1145 GND.n253 251.417
R440 GND.t983 GND.n221 251.417
R441 GND.n203 GND.t994 251.417
R442 GND.t996 GND.n204 251.417
R443 GND.n198 GND.t1035 251.417
R444 GND.n197 GND.t998 251.417
R445 GND.t1037 GND.n206 251.417
R446 GND.t1001 GND.n207 251.417
R447 GND.n195 GND.t1039 251.417
R448 GND.n194 GND.t1003 251.417
R449 GND.t1041 GND.n209 251.417
R450 GND.t1005 GND.n210 251.417
R451 GND.n192 GND.t1043 251.417
R452 GND.n191 GND.t1008 251.417
R453 GND.t1045 GND.n212 251.417
R454 GND.t1011 GND.n213 251.417
R455 GND.n189 GND.t1047 251.417
R456 GND.n186 GND.t1051 251.417
R457 GND.n185 GND.t1014 251.417
R458 GND.t1053 GND.n217 251.417
R459 GND.t1016 GND.n218 251.417
R460 GND.n183 GND.t1055 251.417
R461 GND.n75 GND.t954 251.417
R462 GND.t895 GND.n18 251.417
R463 GND.n64 GND.t831 251.417
R464 GND.n61 GND.t833 251.417
R465 GND.n58 GND.t839 251.417
R466 GND.n54 GND.t799 251.417
R467 GND.n55 GND.t802 251.417
R468 GND.n45 GND.t805 251.417
R469 GND.n46 GND.t808 251.417
R470 GND.n42 GND.t811 251.417
R471 GND.n41 GND.t814 251.417
R472 GND.t683 GND.n163 251.417
R473 GND.n165 GND.t735 251.417
R474 GND.n166 GND.t685 251.417
R475 GND.t688 GND.n161 251.417
R476 GND.t468 GND.t2 251.351
R477 GND.t70 GND.n112 257.877
R478 GND.t127 GND.t449 251.351
R479 GND.t8 GND.t242 251.351
R480 GND.t134 GND.t365 251.351
R481 GND.t630 GND.t302 251.351
R482 GND.t95 GND.n123 257.877
R483 GND.t528 GND.n845 250.952
R484 GND.t403 GND.n477 250.952
R485 GND.n565 GND.t553 250.952
R486 GND.t298 GND.n864 250.696
R487 GND.t29 GND.t1416 250
R488 GND.t982 GND.t444 249.285
R489 GND.n134 GND.t467 253.246
R490 GND.n1 GND.t1195 244.835
R491 GND.n13 GND.t913 244.835
R492 GND.n593 GND.t566 244.286
R493 GND.t1447 GND.n649 244.286
R494 GND.n252 GND.t1111 109.987
R495 GND.n222 GND.t984 109.986
R496 GND.t1022 GND.n229 100.888
R497 GND.t706 GND.n236 100.888
R498 GND.t1101 GND.n276 243.47
R499 GND.t1097 GND.n238 243.47
R500 GND.n245 GND.t1095 243.47
R501 GND.t1092 GND.n240 243.47
R502 GND.n214 GND.t1048 243.47
R503 GND.n219 GND.t1056 243.47
R504 GND.n103 GND.t934 100.883
R505 GND.t932 GND.n113 100.883
R506 GND.t46 GND.n107 9.30721
R507 GND.t578 GND.n145 9.30764
R508 GND.n155 GND.t704 243.47
R509 GND.t700 GND.n171 243.47
R510 GND.n157 GND.t698 243.47
R511 GND.t695 GND.n169 243.47
R512 GND.n159 GND.t692 243.47
R513 GND.t690 GND.n167 243.47
R514 GND.n112 GND.t21 9.79175
R515 GND.n117 GND.t165 93.3945
R516 GND.n123 GND.t14 9.79175
R517 GND.n22 GND.t1223 242.846
R518 GND.n27 GND.t1226 242.846
R519 GND.t1115 GND.n248 242.846
R520 GND.t1084 GND.n242 242.846
R521 GND.t1120 GND.n241 242.846
R522 GND.n262 GND.t1142 242.846
R523 GND.n263 GND.t1106 242.846
R524 GND.t1144 GND.n254 242.846
R525 GND.t1109 GND.n253 242.846
R526 GND.t986 GND.n223 242.846
R527 GND.t1034 GND.n199 242.846
R528 GND.t997 GND.n198 242.846
R529 GND.n205 GND.t1036 242.846
R530 GND.n206 GND.t999 242.846
R531 GND.t1038 GND.n196 242.846
R532 GND.t1002 GND.n195 242.846
R533 GND.n208 GND.t1040 242.846
R534 GND.n209 GND.t1004 242.846
R535 GND.t1042 GND.n193 242.846
R536 GND.t1007 GND.n192 242.846
R537 GND.n211 GND.t1044 242.846
R538 GND.n212 GND.t1009 242.846
R539 GND.t1046 GND.n190 242.846
R540 GND.t1012 GND.n189 242.846
R541 GND.n216 GND.t1052 242.846
R542 GND.n217 GND.t1015 242.846
R543 GND.t1054 GND.n184 242.846
R544 GND.t1017 GND.n183 242.846
R545 GND.n63 GND.t793 242.846
R546 GND.n62 GND.t796 242.846
R547 GND.n60 GND.t840 242.846
R548 GND.n53 GND.t848 242.846
R549 GND.n56 GND.t850 242.846
R550 GND.n44 GND.t852 242.846
R551 GND.n47 GND.t854 242.846
R552 GND.n43 GND.t856 242.846
R553 GND.n40 GND.t858 242.846
R554 GND.n48 GND.t865 242.846
R555 GND.t680 GND.n174 242.846
R556 GND.t734 GND.n164 242.846
R557 GND.t684 GND.n165 242.846
R558 GND.n162 GND.t736 242.846
R559 GND.t1518 GND.n87 79.0593
R560 GND.n260 GND.t460 239.184
R561 GND.n237 GND.t34 238.56
R562 GND.t5 GND.n3 38.2412
R563 GND.n97 GND.t1154 238.357
R564 GND.t944 GND.n783 236.391
R565 GND.t916 GND.t46 252.71
R566 GND.t1229 GND.n383 251.417
R567 GND.t1234 GND.n803 235.714
R568 GND.t1244 GND.n139 101.781
R569 GND.t161 GND.n120 339.01
R570 GND.n347 GND.t1222 251.417
R571 GND.n235 GND.t1225 251.417
R572 GND.t1112 GND.n585 235.714
R573 GND.n587 GND.t1116 235.714
R574 GND.t1083 GND.n341 251.417
R575 GND.n594 GND.t1089 235.714
R576 GND.t1091 GND.n571 235.714
R577 GND.n600 GND.t1093 235.714
R578 GND.t1096 GND.n568 235.714
R579 GND.t1129 GND.n606 235.714
R580 GND.t1100 GND.n603 235.714
R581 GND.n609 GND.t1102 235.714
R582 GND.n620 GND.t1141 235.714
R583 GND.n132 GND.t21 0.369499
R584 GND.n122 GND.t21 0.369499
R585 GND.n660 GND.t987 235.714
R586 GND.t1021 GND.n323 251.417
R587 GND.n667 GND.t1029 235.714
R588 GND.t499 GND.t138 235.714
R589 GND.t1033 GND.n681 235.714
R590 GND.n675 GND.t1049 235.714
R591 GND.t971 GND.n481 235.714
R592 GND.t975 GND.t249 252.041
R593 GND.t978 GND.n316 251.417
R594 GND.t960 GND.n105 105.684
R595 GND.n95 GND.t962 244.398
R596 GND.n416 GND.t921 251.417
R597 GND.n126 GND.t924 101.781
R598 GND.n136 GND.t926 105.684
R599 GND.t891 GND.n720 235.714
R600 GND.t893 GND.n722 235.714
R601 GND.n725 GND.t929 235.714
R602 GND.t931 GND.n108 242.431
R603 GND.n114 GND.t933 242.431
R604 GND.n181 GND.t578 0.369515
R605 GND.n528 GND.t828 235.714
R606 GND.n309 GND.t791 251.417
R607 GND.n142 GND.t795 251.417
R608 GND.n761 GND.t841 235.714
R609 GND.n759 GND.t844 235.714
R610 GND.n757 GND.t847 235.714
R611 GND.n312 GND.t849 251.417
R612 GND.n148 GND.t851 251.417
R613 GND.n311 GND.t853 251.417
R614 GND.n294 GND.t855 251.417
R615 GND.n310 GND.t857 251.417
R616 GND.n283 GND.t859 251.417
R617 GND.n129 GND.t578 11.7003
R618 GND.n747 GND.t864 235.714
R619 GND.n315 GND.t866 251.417
R620 GND.t676 GND.n544 235.714
R621 GND.n547 GND.t681 235.714
R622 GND.t733 GND.n460 251.417
R623 GND.n551 GND.t691 235.714
R624 GND.t694 GND.n537 235.714
R625 GND.n553 GND.t696 235.714
R626 GND.t699 GND.n535 235.714
R627 GND.n555 GND.t702 235.714
R628 GND.t705 GND.n533 235.714
R629 GND.n852 GND.t1578 233.333
R630 GND.t215 GND.n778 233.333
R631 GND.n752 GND.t60 233.333
R632 GND.n558 GND.t382 233.333
R633 GND.t328 GND.t1554 232.093
R634 GND.t645 GND.t1575 231.429
R635 GND.n111 GND.t640 68.847
R636 GND.t238 GND.t1560 229.167
R637 GND.t1239 GND.n849 229.167
R638 GND.n478 GND.t964 229.167
R639 GND.n778 GND.t966 229.167
R640 GND.t869 GND.n749 229.167
R641 GND.n302 GND.t779 244.835
R642 GND.t710 GND.n558 229.167
R643 GND.t27 GND.n518 228.782
R644 GND.t711 GND.n561 227.794
R645 GND.n514 GND.n513 227.56
R646 GND.n715 GND.t919 227.488
R647 GND.n375 GND.t1250 242.846
R648 GND.n347 GND.t1257 242.846
R649 GND.t1113 GND.n584 227.143
R650 GND.t1088 GND.n576 227.143
R651 GND.t1122 GND.n569 227.143
R652 GND.n601 GND.t1124 227.143
R653 GND.n625 GND.t1126 227.143
R654 GND.n606 GND.t1099 227.143
R655 GND.n607 GND.t1132 227.143
R656 GND.n609 GND.t1136 227.143
R657 GND.n623 GND.t1138 227.143
R658 GND.t1146 GND.n611 227.143
R659 GND.n640 GND.t1066 227.143
R660 GND.n662 GND.t1024 227.143
R661 GND.t1028 GND.n650 227.143
R662 GND.n290 GND.t991 243.47
R663 GND.n688 GND.t995 227.143
R664 GND.n482 GND.t974 227.143
R665 GND.t977 GND.n141 242.846
R666 GND.n789 GND.t948 227.143
R667 GND.n470 GND.t955 227.143
R668 GND.n95 GND.t942 102.457
R669 GND.n292 GND.t963 242.846
R670 GND.n136 GND.t887 106.677
R671 GND.t889 GND.n115 106.159
R672 GND.n728 GND.t892 227.143
R673 GND.t896 GND.n107 234.188
R674 GND.n233 GND.t827 242.846
R675 GND.n309 GND.t830 242.846
R676 GND.n142 GND.t832 242.846
R677 GND.n294 GND.t810 242.846
R678 GND.n310 GND.t813 242.846
R679 GND.n128 GND.t863 102.457
R680 GND.n50 GND.t880 242.846
R681 GND.t677 GND.n543 227.143
R682 GND.n460 GND.t682 242.846
R683 GND.n549 GND.t686 227.143
R684 GND.t738 GND.n538 227.143
R685 GND.n552 GND.t740 227.143
R686 GND.t742 GND.n536 227.143
R687 GND.n554 GND.t744 227.143
R688 GND.t746 GND.n534 227.143
R689 GND.n566 GND.t709 227.143
R690 GND.n499 GND.t582 227.028
R691 GND.n500 GND.t616 227.028
R692 GND.n825 GND.t643 222.857
R693 GND.t1586 GND.n140 231.541
R694 GND.t412 GND.n469 222.857
R695 GND.t958 GND.t1458 222.857
R696 GND.n232 GND.t1081 102.707
R697 GND.t1220 GND.n131 102.703
R698 GND.n250 GND.t1082 222.042
R699 GND.t46 GND.n115 3.83506
R700 GND.n176 GND.t732 222.042
R701 GND.n214 GND.t1013 222.041
R702 GND.n104 GND.t903 102.703
R703 GND.t234 GND.t1237 110.709
R704 GND.n29 GND.t1228 221.417
R705 GND.n5 GND.t1067 221.417
R706 GND.t989 GND.n227 221.417
R707 GND.n182 GND.t1018 221.417
R708 GND.n76 GND.t938 221.417
R709 GND.t935 GND.n20 221.417
R710 GND.n39 GND.t817 221.417
R711 GND.n49 GND.t818 221.417
R712 GND.t820 GND.n51 221.417
R713 GND.n853 GND.t1241 220.833
R714 GND.n91 GND.t914 227.374
R715 GND.n753 GND.t872 220.833
R716 GND.t233 GND.t166 219.198
R717 GND.t31 GND.n583 218.571
R718 GND.t567 GND.n575 218.571
R719 GND.t568 GND.n575 218.571
R720 GND.t1412 GND.n658 218.571
R721 GND.n666 GND.t1445 218.571
R722 GND.n666 GND.t1446 218.571
R723 GND.t76 GND.t1050 218.571
R724 GND.n527 GND.t1532 218.571
R725 GND.t49 GND.n542 218.571
R726 GND.t559 GND.t1086 214.286
R727 GND.t1130 GND.t344 214.286
R728 GND.t952 GND.t409 214.286
R729 GND.t1418 GND.t837 214.286
R730 GND.t61 GND.t874 214.286
R731 GND.t1419 GND.n703 212.5
R732 GND.t330 GND.n637 210
R733 GND.t150 GND.t993 210
R734 GND.t109 GND.t894 210
R735 GND.n248 GND.t31 208.56
R736 GND.n223 GND.t1412 208.56
R737 GND.n174 GND.t49 208.56
R738 GND.t117 GND.t516 208.333
R739 GND.t428 GND.t84 208.095
R740 GND.t455 GND.n503 206.898
R741 GND.t1415 GND.n517 206.643
R742 GND.n768 GND.t765 206.304
R743 GND.n345 GND.t1232 221.417
R744 GND.t1232 GND.n794 205.714
R745 GND.t433 GND.t1254 205.714
R746 GND.t1255 GND.n131 235.006
R747 GND.n346 GND.t1228 221.417
R748 GND.t513 GND.n842 205.714
R749 GND.t1082 GND.n584 205.714
R750 GND.n617 GND.t1467 205.714
R751 GND.n232 GND.t1067 213.577
R752 GND.n670 GND.t1031 205.714
R753 GND.t1013 GND.n675 205.714
R754 GND.t1018 GND.n673 205.714
R755 GND.n780 GND.t957 205.714
R756 GND.n234 GND.t938 221.417
R757 GND.t928 GND.n115 107.194
R758 GND.n104 GND.t935 213.578
R759 GND.n86 GND.t798 110.639
R760 GND.t817 GND.n145 212.758
R761 GND.t818 GND.n744 205.714
R762 GND.n101 GND.t820 212.431
R763 GND.t732 GND.n543 205.714
R764 GND.t643 GND.n31 204.274
R765 GND.n809 GND.t1586 204.274
R766 GND.t460 GND.n258 204.274
R767 GND.n74 GND.t412 204.274
R768 GND.t347 GND.t1135 201.429
R769 GND.t249 GND.t952 200.613
R770 GND.t1246 GND.n140 102.457
R771 GND.t1253 GND.t234 200.613
R772 GND.n249 GND.t1113 200.613
R773 GND.n272 GND.t1128 200.613
R774 GND.t1099 GND.n273 200.613
R775 GND.n271 GND.t1130 200.613
R776 GND.t1104 GND.n279 200.613
R777 GND.t1138 GND.n267 200.613
R778 GND.t995 GND.n200 200.613
R779 GND.t1050 GND.n188 200.613
R780 GND.n99 GND.t249 86.7547
R781 GND.n105 GND.t940 106.677
R782 GND.n96 GND.t961 23.2336
R783 GND.n95 GND.t249 7.66905
R784 GND.n127 GND.t925 23.2336
R785 GND.n136 GND.t46 3.31705
R786 GND.n125 GND.t46 86.7547
R787 GND.t837 GND.t578 200.613
R788 GND.n128 GND.t578 7.66905
R789 GND.t877 GND.t578 200.613
R790 GND.n175 GND.t677 200.613
R791 GND.t1255 GND.n24 199.989
R792 GND.t1257 GND.n25 199.989
R793 GND.t1259 GND.n22 199.989
R794 GND.t1261 GND.n27 199.989
R795 GND.n242 GND.t1120 199.989
R796 GND.n239 GND.t1122 199.989
R797 GND.t1124 GND.n246 199.989
R798 GND.t1132 GND.n270 199.989
R799 GND.t1136 GND.n268 199.989
R800 GND.n257 GND.t1140 199.989
R801 GND.t1106 GND.n262 199.989
R802 GND.n254 GND.t1109 199.989
R803 GND.n199 GND.t997 199.989
R804 GND.t999 GND.n205 199.989
R805 GND.n196 GND.t1002 199.989
R806 GND.t1004 GND.n208 199.989
R807 GND.n193 GND.t1007 199.989
R808 GND.t1009 GND.n211 199.989
R809 GND.n190 GND.t1012 199.989
R810 GND.t1015 GND.n216 199.989
R811 GND.n184 GND.t1017 199.989
R812 GND.n79 GND.t977 199.989
R813 GND.t948 GND.n788 199.989
R814 GND.t892 GND.n15 199.989
R815 GND.n17 GND.t896 199.989
R816 GND.t899 GND.n19 199.989
R817 GND.n16 GND.t902 199.989
R818 GND.t832 GND.n63 199.989
R819 GND.t834 GND.n62 199.989
R820 GND.t843 GND.n57 199.989
R821 GND.t801 GND.n53 199.989
R822 GND.t804 GND.n56 199.989
R823 GND.t807 GND.n44 199.989
R824 GND.t810 GND.n47 199.989
R825 GND.t813 GND.n43 199.989
R826 GND.t816 GND.n40 199.989
R827 GND.t880 GND.n51 199.989
R828 GND.n164 GND.t684 199.989
R829 GND.t686 GND.n162 199.989
R830 GND.n168 GND.t738 199.989
R831 GND.t740 GND.n158 199.989
R832 GND.n170 GND.t742 199.989
R833 GND.t744 GND.n156 199.989
R834 GND.n172 GND.t746 199.989
R835 GND.t748 GND.n154 199.989
R836 GND.t709 GND.n153 199.989
R837 GND.n111 GND.t36 102.159
R838 GND.t1558 GND.n259 196.327
R839 GND.n857 GND.n854 193.411
R840 GND.n593 GND.t567 192.857
R841 GND.n594 GND.t568 192.857
R842 GND.t1445 GND.n650 192.857
R843 GND.t1446 GND.n649 192.857
R844 GND.t1031 GND.t1454 192.857
R845 GND.n233 GND.t1532 208.56
R846 GND.n120 GND.t1251 101.781
R847 GND.t234 GND.n139 7.34144
R848 GND.t1110 GND.n252 192.054
R849 GND.n265 GND.t1145 192.042
R850 GND.n267 GND.t1137 192.042
R851 GND.t1102 GND.n279 192.042
R852 GND.n271 GND.t1129 192.042
R853 GND.t1098 GND.n273 192.042
R854 GND.n272 GND.t1127 192.042
R855 GND.t1049 GND.n188 192.042
R856 GND.t994 GND.n200 192.042
R857 GND.n222 GND.t983 192.054
R858 GND.n96 GND.t249 86.7547
R859 GND.n99 GND.t939 22.2411
R860 GND.t249 GND.t958 192.042
R861 GND.n125 GND.t888 22.2411
R862 GND.n127 GND.t46 86.7547
R863 GND.t46 GND.n126 7.34144
R864 GND.t835 GND.t578 108.719
R865 GND.t578 GND.t786 108.722
R866 GND.t950 GND.t249 108.719
R867 GND.t1151 GND.t1463 191.667
R868 GND.n795 GND.t1229 191.417
R869 GND.n36 GND.t1234 191.417
R870 GND.n23 GND.t1222 191.417
R871 GND.n28 GND.t1225 191.417
R872 GND.n30 GND.t1262 191.417
R873 GND.n251 GND.t1114 191.417
R874 GND.n243 GND.t1083 191.417
R875 GND.t1093 GND.n239 191.417
R876 GND.n246 GND.t1096 191.417
R877 GND.t1125 GND.n237 191.417
R878 GND.n270 GND.t1100 191.417
R879 GND.n269 GND.t1133 191.417
R880 GND.t1141 GND.n255 191.417
R881 GND.n264 GND.t1143 191.417
R882 GND.n132 GND.t1060 108.635
R883 GND.n122 GND.t1063 108.635
R884 GND.n227 GND.t1021 191.417
R885 GND.t992 GND.n201 191.417
R886 GND.n204 GND.t1033 191.417
R887 GND.t1035 GND.n197 191.417
R888 GND.n207 GND.t1037 191.417
R889 GND.t1039 GND.n194 191.417
R890 GND.n210 GND.t1041 191.417
R891 GND.t1043 GND.n191 191.417
R892 GND.n213 GND.t1045 191.417
R893 GND.t1051 GND.n185 191.417
R894 GND.n218 GND.t1053 191.417
R895 GND.t1055 GND.n182 191.417
R896 GND.t962 GND.n78 191.417
R897 GND.n723 GND.t893 191.417
R898 GND.t929 GND.n17 191.417
R899 GND.n19 GND.t931 191.417
R900 GND.t933 GND.n16 191.417
R901 GND.n181 GND.t824 108.638
R902 GND.n64 GND.t791 191.417
R903 GND.n61 GND.t795 191.417
R904 GND.n54 GND.t847 191.417
R905 GND.n55 GND.t849 191.417
R906 GND.n45 GND.t851 191.417
R907 GND.n46 GND.t853 191.417
R908 GND.n42 GND.t855 191.417
R909 GND.n41 GND.t857 191.417
R910 GND.n39 GND.t859 191.417
R911 GND.t864 GND.n49 191.417
R912 GND.n177 GND.t679 191.417
R913 GND.n163 GND.t733 191.417
R914 GND.t735 GND.n166 191.417
R915 GND.t691 GND.n168 191.417
R916 GND.n158 GND.t694 191.417
R917 GND.t696 GND.n170 191.417
R918 GND.n156 GND.t699 191.417
R919 GND.t702 GND.n172 191.417
R920 GND.n154 GND.t705 191.417
R921 GND.t92 GND.t28 189.633
R922 GND.n143 GND.t334 204.274
R923 GND.t285 GND.t1264 188.571
R924 GND.t34 GND.n567 188.571
R925 GND.n704 GND.t1419 187.5
R926 GND.n178 GND.t710 186.526
R927 GND.n4 GND.t1201 195.315
R928 GND.t919 GND.n714 184.815
R929 GND.n562 GND.t711 184.815
R930 GND.t1231 GND.n796 184.286
R931 GND.n874 GND.t641 184.286
R932 GND.t1236 GND.n804 184.286
R933 GND.t1250 GND.n807 184.286
R934 GND.t1223 GND.n815 184.286
R935 GND.t1226 GND.n816 184.286
R936 GND.t1264 GND.n817 184.286
R937 GND.t1117 GND.n582 184.286
R938 GND.n588 GND.t1084 184.286
R939 GND.t1086 GND.n579 184.286
R940 GND.t1090 GND.n573 184.286
R941 GND.t1095 GND.n569 184.286
R942 GND.n601 GND.t1097 184.286
R943 GND.t1126 GND.n567 184.286
R944 GND.n607 GND.t1101 184.286
R945 GND.n608 GND.t1134 184.286
R946 GND.t1140 GND.t532 184.286
R947 GND.t1142 GND.n612 184.286
R948 GND.n621 GND.t1144 184.286
R949 GND.t503 GND.n636 184.286
R950 GND.t1062 GND.n638 184.286
R951 GND.t1066 GND.n639 184.286
R952 GND.t988 GND.n657 184.286
R953 GND.t989 GND.n229 212.758
R954 GND.t1024 GND.n654 184.286
R955 GND.t1030 GND.n647 184.286
R956 GND.t991 GND.n643 184.286
R957 GND.t993 GND.n686 184.286
R958 GND.n693 GND.t1034 184.286
R959 GND.t1036 GND.n680 184.286
R960 GND.n694 GND.t1038 184.286
R961 GND.t1040 GND.n679 184.286
R962 GND.n695 GND.t1042 184.286
R963 GND.t1044 GND.n678 184.286
R964 GND.n696 GND.t1046 184.286
R965 GND.t1048 GND.n676 184.286
R966 GND.t1052 GND.n674 184.286
R967 GND.n699 GND.t1054 184.286
R968 GND.t1056 GND.n673 184.286
R969 GND.t963 GND.n476 184.286
R970 GND.t922 GND.n711 184.286
R971 GND.t894 GND.n724 184.286
R972 GND.t930 GND.n107 100.883
R973 GND.t899 GND.n113 234.188
R974 GND.n103 GND.t902 234.188
R975 GND.t830 GND.n525 184.286
R976 GND.t793 GND.n529 184.286
R977 GND.t796 GND.n530 184.286
R978 GND.t846 GND.n731 184.286
R979 GND.t848 GND.n738 184.286
R980 GND.t850 GND.n739 184.286
R981 GND.t852 GND.n740 184.286
R982 GND.t854 GND.n741 184.286
R983 GND.t856 GND.n742 184.286
R984 GND.t858 GND.n743 184.286
R985 GND.t860 GND.n145 100.888
R986 GND.t865 GND.n744 184.286
R987 GND.n756 GND.t868 184.286
R988 GND.t874 GND.n755 184.286
R989 GND.t682 GND.n541 184.286
R990 GND.n548 GND.t734 184.286
R991 GND.t736 GND.n540 184.286
R992 GND.t692 GND.n538 184.286
R993 GND.n552 GND.t695 184.286
R994 GND.t698 GND.n536 184.286
R995 GND.n554 GND.t700 184.286
R996 GND.t704 GND.n534 184.286
R997 GND.t748 GND.n236 234.188
R998 GND.t782 GND.t396 183.333
R999 GND.t1241 GND.n852 179.167
R1000 GND.t872 GND.n752 179.167
R1001 GND.n865 GND.t298 178.379
R1002 GND.t1154 GND.n81 181.464
R1003 GND.n784 GND.t944 176.219
R1004 GND.t1248 GND.n808 175.714
R1005 GND.t1254 GND.n812 175.714
R1006 GND.t1256 GND.n130 99.5774
R1007 GND.t1258 GND.n815 175.714
R1008 GND.t1260 GND.n816 175.714
R1009 GND.n588 GND.t1118 175.714
R1010 GND.t1085 GND.n580 175.714
R1011 GND.n591 GND.t1087 175.714
R1012 GND.n598 GND.t1091 175.714
R1013 GND.n600 GND.t1121 175.714
R1014 GND.t1123 GND.n568 175.714
R1015 GND.t1131 GND.n603 175.714
R1016 GND.t1135 GND.n602 175.714
R1017 GND.t1105 GND.n612 175.714
R1018 GND.n621 GND.t1107 175.714
R1019 GND.n664 GND.t1026 175.714
R1020 GND.t990 GND.n644 175.714
R1021 GND.n693 GND.t996 175.714
R1022 GND.t998 GND.n680 175.714
R1023 GND.n694 GND.t1001 175.714
R1024 GND.t1003 GND.n679 175.714
R1025 GND.n695 GND.t1005 175.714
R1026 GND.t1008 GND.n678 175.714
R1027 GND.n696 GND.t1011 175.714
R1028 GND.t1047 GND.n677 175.714
R1029 GND.t1014 GND.n674 175.714
R1030 GND.n699 GND.t1016 175.714
R1031 GND.n787 GND.t946 175.714
R1032 GND.t954 GND.n469 175.714
R1033 GND.t921 GND.n712 175.714
R1034 GND.n725 GND.t895 175.714
R1035 GND.t831 GND.n529 175.714
R1036 GND.t833 GND.n530 175.714
R1037 GND.t840 GND.t490 175.714
R1038 GND.n730 GND.t841 175.714
R1039 GND.n732 GND.t844 175.714
R1040 GND.t799 GND.n738 175.714
R1041 GND.t802 GND.n739 175.714
R1042 GND.t805 GND.n740 175.714
R1043 GND.t808 GND.n741 175.714
R1044 GND.t811 GND.n742 175.714
R1045 GND.t814 GND.n743 175.714
R1046 GND.n748 GND.t866 175.714
R1047 GND.n548 GND.t683 175.714
R1048 GND.t685 GND.n540 175.714
R1049 GND.n551 GND.t737 175.714
R1050 GND.t739 GND.n537 175.714
R1051 GND.n553 GND.t741 175.714
R1052 GND.t743 GND.n535 175.714
R1053 GND.n555 GND.t745 175.714
R1054 GND.t747 GND.n533 175.714
R1055 GND.n501 GND.t454 174.325
R1056 GND.t1087 GND.t562 171.429
R1057 GND.t946 GND.t258 171.429
R1058 GND.n129 GND.t861 97.3
R1059 GND.n850 GND.t1239 170.833
R1060 GND.t1195 GND.n465 170.833
R1061 GND.n479 GND.t966 170.833
R1062 GND.t913 GND.n709 170.833
R1063 GND.n750 GND.t869 170.833
R1064 GND.t1510 GND.n774 168.103
R1065 GND.t471 GND.t1236 167.143
R1066 GND.t566 GND.n576 167.143
R1067 GND.t570 GND.n574 167.143
R1068 GND.t531 GND.t1139 167.143
R1069 GND.n665 GND.t1444 167.143
R1070 GND.n667 GND.t1447 167.143
R1071 GND.n689 GND.t499 167.143
R1072 GND.n720 GND.t107 167.143
R1073 GND.t140 GND.n797 166.667
R1074 GND.t651 GND.n837 166.667
R1075 GND.t1578 GND.n851 166.667
R1076 GND.t1196 GND.n119 227.374
R1077 GND.n467 GND.t537 166.667
R1078 GND.n779 GND.t215 166.667
R1079 GND.n91 GND.t174 96.0227
R1080 GND.n702 GND.t1565 166.667
R1081 GND.t60 GND.n751 166.667
R1082 GND.t1513 GND.n507 166.667
R1083 GND.n767 GND.t236 166.667
R1084 GND.t382 GND.n556 166.667
R1085 GND.t1432 GND.t86 162.857
R1086 GND.t1451 GND.t1030 162.857
R1087 GND.t216 GND.t971 162.857
R1088 GND.n867 GND.n865 162.162
R1089 GND.n112 GND.t128 93.3945
R1090 GND.n117 GND.t435 257.877
R1091 GND.t616 GND.n499 162.162
R1092 GND.n123 GND.t615 93.3945
R1093 GND.t80 GND.n2 157.335
R1094 GND.n0 GND.t52 157.335
R1095 GND.t1535 GND.n12 157.335
R1096 GND.t211 GND.n506 157.335
R1097 GND.t580 GND.n67 157.335
R1098 GND.n516 GND.t172 154.982
R1099 GND.n857 GND.t0 154.728
R1100 GND.n861 GND.t349 154.596
R1101 GND.t633 GND.t990 154.286
R1102 GND.t312 GND.t992 154.286
R1103 GND.t336 GND.t843 154.286
R1104 GND.t422 GND.n873 154.167
R1105 GND.t505 GND.t511 154.167
R1106 GND.n831 GND.t428 154.167
R1107 GND.n846 GND.t528 154.167
R1108 GND.n478 GND.t403 154.167
R1109 GND.n708 GND.t545 154.167
R1110 GND.n135 GND.t394 167.082
R1111 GND.n564 GND.t553 154.167
R1112 GND.n118 GND.t436 57.341
R1113 GND.t96 GND.n124 57.341
R1114 GND.n6 GND.t70 153.474
R1115 GND.t435 GND.n626 153.474
R1116 GND.n69 GND.t95 153.474
R1117 GND.t5 GND.n4 5.85107
R1118 GND.t1521 GND.n713 153.243
R1119 GND.n33 GND.t208 152.846
R1120 GND.t187 GND.n247 152.846
R1121 GND.t197 GND.n224 152.846
R1122 GND.t194 GND.n65 152.846
R1123 GND.t191 GND.n173 152.846
R1124 GND.n512 GND.t251 151.708
R1125 GND.t613 GND.n839 150
R1126 GND.t1243 GND.n853 150
R1127 GND.t1464 GND.t360 150
R1128 GND.t268 GND.t1558 150
R1129 GND.t1467 GND.t462 150
R1130 GND.t467 GND.n100 162.888
R1131 GND.t969 GND.n479 150
R1132 GND.t873 GND.n753 150
R1133 GND.t58 GND.n302 165.669
R1134 GND.t236 GND.t12 150
R1135 GND.t199 GND.n10 149.002
R1136 GND.n518 GND.t1415 147.601
R1137 GND.n502 GND.n500 145.946
R1138 GND.t640 GND.t513 145.714
R1139 GND.t518 GND.t1146 145.714
R1140 GND.t1026 GND.t1441 145.714
R1141 GND.t875 GND.t309 145.714
R1142 GND.t349 GND.n798 142.061
R1143 GND.n866 GND.t505 141.667
R1144 GND.t1560 GND.n836 141.667
R1145 GND.t1468 GND.n850 141.667
R1146 GND.t965 GND.t401 141.667
R1147 GND.n318 GND.t547 157.335
R1148 GND.n703 GND.t1430 141.667
R1149 GND.t576 GND.n750 141.667
R1150 GND.t237 GND.t184 141.667
R1151 GND.n557 GND.t155 141.667
R1152 GND.t86 GND.n793 141.429
R1153 GND.n587 GND.t1585 141.429
R1154 GND.n592 GND.t565 141.429
R1155 GND.n595 GND.t571 141.429
R1156 GND.t297 GND.t503 141.429
R1157 GND.t1379 GND.t330 141.429
R1158 GND.n660 GND.t30 141.429
R1159 GND.t1443 GND.n651 141.429
R1160 GND.t1448 GND.n648 141.429
R1161 GND.n528 GND.t1417 141.429
R1162 GND.t474 GND.t877 141.429
R1163 GND.n547 GND.t1528 141.429
R1164 GND.t1511 GND.n504 137.931
R1165 GND.n775 GND.t1510 137.931
R1166 GND.t454 GND.n497 137.839
R1167 GND.t384 GND.n498 137.839
R1168 GND.t230 GND.n81 89.8491
R1169 GND.t1554 GND.n628 137.536
R1170 GND.t480 GND.n784 137.536
R1171 GND.t599 GND.n455 153.243
R1172 GND.n561 GND.t1476 137.536
R1173 GND.t408 GND.n702 137.5
R1174 GND.t56 GND.t1112 137.143
R1175 GND.t573 GND.t1090 137.143
R1176 GND.t164 GND.n488 137.143
R1177 GND.t464 GND.t676 137.143
R1178 GND.n860 GND.t235 133.706
R1179 GND.n869 GND.n868 133.333
R1180 GND.t478 GND.t481 133.238
R1181 GND.n672 GND.t1423 132.857
R1182 GND.t839 GND.t1581 132.857
R1183 GND.t1529 GND.t688 132.857
R1184 GND.n515 GND.n514 132.841
R1185 GND.n861 GND.n859 130.435
R1186 GND.n513 GND.t92 128.952
R1187 GND.t1127 GND.t1514 128.571
R1188 GND.t1134 GND.t346 128.571
R1189 GND.n133 GND.t1379 64.9154
R1190 GND.t955 GND.t1543 128.571
R1191 GND.t648 GND.n7 127.132
R1192 GND.n519 GND.t27 125.462
R1193 GND.t1198 GND.n3 70.8418
R1194 GND.t1536 GND.t916 124.642
R1195 GND.n810 GND.t1587 124.287
R1196 GND.t332 GND.n813 124.287
R1197 GND.n586 GND.t1488 124.287
R1198 GND.n624 GND.t32 124.287
R1199 GND.t1462 GND.n616 124.287
R1200 GND.n659 GND.t99 124.287
R1201 GND.t620 GND.n685 124.287
R1202 GND.n470 GND.t410 124.287
R1203 GND.n718 GND.t1500 124.287
R1204 GND.n721 GND.t443 124.287
R1205 GND.t438 GND.n526 124.287
R1206 GND.n546 GND.t25 124.287
R1207 GND.t142 GND.t690 124.287
R1208 GND.n88 GND.t1461 84.0263
R1209 GND.n494 GND.t153 121.496
R1210 GND.t251 GND.n87 217.589
R1211 GND.t664 GND.n871 120.834
R1212 GND.n838 GND.t608 120.834
R1213 GND.n706 GND.t244 120.834
R1214 GND.t1430 GND.t408 120.834
R1215 GND.t1201 GND.t1203 120.344
R1216 GND.t284 GND.t1092 120.001
R1217 GND.t974 GND.t1381 120.001
R1218 GND.t473 GND.t875 120.001
R1219 GND.n2 GND.t383 119.835
R1220 GND.n0 GND.t457 119.835
R1221 GND.n12 GND.t163 119.835
R1222 GND.n506 GND.t288 119.835
R1223 GND.t2 GND.n6 116.987
R1224 GND.n626 GND.t127 116.987
R1225 GND.t302 GND.n69 116.987
R1226 GND.t1564 GND.t965 116.668
R1227 GND.t564 GND.n577 115.715
R1228 GND.t572 GND.n573 115.715
R1229 GND.n664 GND.t1442 115.715
R1230 GND.n668 GND.t1449 115.715
R1231 GND.t346 GND.n277 114.275
R1232 GND.t658 GND.n257 114.275
R1233 GND.n161 GND.t1408 114.275
R1234 GND.t608 GND.t651 112.501
R1235 GND.t1587 GND.t1248 111.43
R1236 GND.t1023 GND.t1424 111.43
R1237 GND.t1512 GND.n487 111.43
R1238 GND.n874 GND.t1432 107.144
R1239 GND.n830 GND.t593 107.144
R1240 GND.t1243 GND.n827 107.144
R1241 GND.n822 GND.t78 107.144
R1242 GND.n811 GND.t291 107.144
R1243 GND.t1422 GND.n812 107.144
R1244 GND.n840 GND.t613 107.144
R1245 GND.n845 GND.t183 107.144
R1246 GND.t1514 GND.n604 107.144
R1247 GND.t487 GND.n614 107.144
R1248 GND.t44 GND.n134 77.2375
R1249 GND.t41 GND.n644 107.144
R1250 GND.n480 GND.t969 107.144
R1251 GND.n786 GND.t945 107.144
R1252 GND.n781 GND.t1399 107.144
R1253 GND.n477 GND.t1522 107.144
R1254 GND.n756 GND.t1506 107.144
R1255 GND.n754 GND.t873 107.144
R1256 GND.t496 GND.n565 107.144
R1257 GND.t38 GND.n869 104.168
R1258 GND.t511 GND.n797 104.168
R1259 GND.n835 GND.t1548 104.168
R1260 GND.n836 GND.t64 104.168
R1261 GND.n849 GND.t212 104.168
R1262 GND.n318 GND.t1564 119.835
R1263 GND.t587 GND.n704 104.168
R1264 GND.n749 GND.t632 104.168
R1265 GND.t129 GND.n563 104.168
R1266 GND.t1407 GND.t1406 101.562
R1267 GND.n496 GND.t8 101.352
R1268 GND.n497 GND.t134 101.352
R1269 GND.t964 GND.t437 100.001
R1270 GND.t1565 GND.t199 100.001
R1271 GND.t1555 GND.n817 98.5719
R1272 GND.n585 GND.t526 98.5719
R1273 GND.t1520 GND.n611 98.5719
R1274 GND.n690 GND.t574 98.5719
R1275 GND.n474 GND.t254 98.5719
R1276 GND.t1411 GND.n719 98.5719
R1277 GND.t1394 GND.n544 98.5719
R1278 GND.t1386 GND.n532 98.5719
R1279 GND.t1549 GND.n251 97.1319
R1280 GND.t639 GND.n220 97.4123
R1281 GND.n15 GND.t1501 97.1319
R1282 GND.t600 GND.n181 97.4123
R1283 GND.t655 GND.n177 97.1319
R1284 GND.t45 GND.n862 96.1008
R1285 GND.t522 GND.n832 95.8338
R1286 GND.n563 GND.t120 95.8338
R1287 GND.t1509 GND.t105 94.5564
R1288 GND.t327 GND.n520 92.2514
R1289 GND.t172 GND.n515 92.2514
R1290 GND.n854 GND.t424 90.2584
R1291 GND.t300 GND.n802 90.0005
R1292 GND.n824 GND.t529 90.0005
R1293 GND.n591 GND.t563 90.0005
R1294 GND.n596 GND.t573 90.0005
R1295 GND.t168 GND.n635 90.0005
R1296 GND.t1441 GND.n652 90.0005
R1297 GND.t1450 GND.n647 90.0005
R1298 GND.t147 GND.n490 90.0005
R1299 GND.t405 GND.n482 90.0005
R1300 GND.t1567 GND.t975 90.0005
R1301 GND.t124 GND.n787 90.0005
R1302 GND.n717 GND.t390 90.0005
R1303 GND.n760 GND.t113 90.0005
R1304 GND.t309 GND.n110 103.269
R1305 GND.t437 GND.t249 87.1423
R1306 GND.t1495 GND.n92 66.1984
R1307 GND.t509 GND.n179 87.1413
R1308 GND.t1563 GND.n1 86.5025
R1309 GND.n13 GND.t320 86.5025
R1310 GND.n135 GND.t67 66.199
R1311 GND.t176 GND.n66 86.5025
R1312 GND.n804 GND.t399 85.7148
R1313 GND.t1576 GND.n820 85.7148
R1314 GND.n842 GND.t536 85.7148
R1315 GND.n637 GND.t297 85.7148
R1316 GND.n492 GND.t552 85.7148
R1317 GND.n483 GND.t1567 85.7148
R1318 GND.n729 GND.t1384 85.7148
R1319 GND.n102 GND.t474 99.148
R1320 GND.n100 GND.t21 3.42966
R1321 GND.n106 GND.t393 64.595
R1322 GND.t143 GND.n94 64.595
R1323 GND.n70 GND.t1580 84.5541
R1324 GND.t12 GND.n508 83.3338
R1325 GND.n818 GND.t161 81.4291
R1326 GND.t240 GND.n841 81.4291
R1327 GND.n617 GND.t268 81.4291
R1328 GND.n671 GND.t633 81.4291
R1329 GND.n687 GND.t312 81.4291
R1330 GND.n688 GND.t504 81.4291
R1331 GND.n697 GND.t102 81.4291
R1332 GND.n719 GND.t497 81.4291
R1333 GND.t54 GND.t364 81.0816
R1334 GND.t589 GND.n110 62.9212
R1335 GND.t1381 GND.t249 80.6121
R1336 GND.t17 GND.n35 79.9891
R1337 GND.t646 GND.n870 79.1672
R1338 GND.t406 GND.n847 79.1672
R1339 GND.n707 GND.t1382 79.1672
R1340 GND.t14 GND.n521 78.1255
R1341 GND.t642 GND.n806 77.1434
R1342 GND.n758 GND.t317 77.1434
R1343 GND.t1505 GND.n746 77.1434
R1344 GND.t707 GND.t1386 77.1434
R1345 GND.n501 GND.n498 77.0275
R1346 GND.t578 GND.n102 2.91846
R1347 GND.n35 GND.t6 75.7034
R1348 GND.t130 GND.n79 75.7034
R1349 GND.t241 GND.t591 75.4129
R1350 GND.t288 GND.t782 75.0005
R1351 GND.n68 GND.t453 74.0263
R1352 GND.t260 GND.n516 73.8012
R1353 GND.t325 GND.t167 72.8576
R1354 GND.t461 GND.t530 72.8576
R1355 GND.t234 GND.t535 72.0417
R1356 GND.t578 GND.t473 72.0417
R1357 GND.t605 GND.t234 72.0407
R1358 GND.t166 GND.n34 71.5798
R1359 GND.n31 GND.t604 71.4177
R1360 GND.t1545 GND.n809 71.4177
R1361 GND.n7 GND.t296 71.4177
R1362 GND.t472 GND.n225 71.4177
R1363 GND.n290 GND.t650 72.0417
R1364 GND.n788 GND.t1486 71.4177
R1365 GND.t1543 GND.n74 71.4177
R1366 GND.t118 GND.n872 70.8338
R1367 GND.n832 GND.t149 70.8338
R1368 GND.n847 GND.t154 70.8338
R1369 GND.t132 GND.n707 70.8338
R1370 GND.t269 GND.n93 66.1984
R1371 GND.n67 GND.t11 69.8359
R1372 GND.n495 GND.t54 68.9194
R1373 GND.t338 GND.n628 68.7684
R1374 GND.t765 GND.t599 68.7684
R1375 GND.t71 GND.n8 57.3414
R1376 GND.t81 GND.n3 18.8619
R1377 GND.n713 GND.t1536 67.2827
R1378 GND.t1431 GND.n11 67.2827
R1379 GND.t641 GND.t422 66.6672
R1380 GND.t1571 GND.n90 43.2152
R1381 GND.t83 GND.t1464 66.6672
R1382 GND.t457 GND.t1151 66.6672
R1383 GND.n83 GND.t389 43.2152
R1384 GND.t545 GND.t358 66.6672
R1385 GND.t868 GND.t308 66.6672
R1386 GND.t10 GND.t394 66.6672
R1387 GND.t184 GND.n765 66.6672
R1388 GND.t217 GND.t451 64.8654
R1389 GND.t364 GND.t243 64.8654
R1390 GND.t601 GND.t629 64.8654
R1391 GND.t0 GND.n855 64.4704
R1392 GND.n589 GND.t556 64.2862
R1393 GND.t562 GND.n578 64.2862
R1394 GND.t278 GND.n572 64.2862
R1395 GND.n599 GND.t284 64.2862
R1396 GND.t1440 GND.n634 64.2862
R1397 GND.t1424 GND.n655 64.2862
R1398 GND.n663 GND.t1429 64.2862
R1399 GND.n669 GND.t1451 64.2862
R1400 GND.t1456 GND.n645 64.2862
R1401 GND.t112 GND.n489 64.2862
R1402 GND.t258 GND.t249 80.6121
R1403 GND.t1507 GND.n712 64.2862
R1404 GND.n314 GND.t314 79.9891
R1405 GND.n733 GND.t335 64.2862
R1406 GND.t115 GND.n735 64.2862
R1407 GND.t1577 GND.n519 62.7311
R1408 GND.n799 GND.t351 60.0005
R1409 GND.n828 GND.t66 60.0005
R1410 GND.t1470 GND.n826 60.0005
R1411 GND.t1488 GND.t1115 60.0005
R1412 GND.t1398 GND.n602 60.0005
R1413 GND.t18 GND.n613 60.0005
R1414 GND.n631 GND.t1504 60.0005
R1415 GND.t502 GND.n633 60.0005
R1416 GND.t99 GND.t986 60.0005
R1417 GND.n692 GND.t434 60.0005
R1418 GND.n486 GND.t250 60.0005
R1419 GND.n493 GND.t1583 60.0005
R1420 GND.n481 GND.t549 60.0005
R1421 GND.n475 GND.t91 60.0005
R1422 GND.n716 GND.t1537 60.0005
R1423 GND.t306 GND.n126 69.0108
R1424 GND.t827 GND.t438 60.0005
R1425 GND.n755 GND.t579 60.0005
R1426 GND.t25 GND.t680 60.0005
R1427 GND.n550 GND.t142 60.0005
R1428 GND.n521 GND.t262 59.0411
R1429 GND.t638 GND.n278 58.5605
R1430 GND.t532 GND.n256 58.5605
R1431 GND.n160 GND.t1529 58.5605
R1432 GND.n803 GND.t398 55.7148
R1433 GND.t1575 GND.n823 55.7148
R1434 GND.n375 GND.t1474 71.4177
R1435 GND.n143 GND.t432 71.4177
R1436 GND.n625 GND.t610 55.7148
R1437 GND.t462 GND.n616 55.7148
R1438 GND.t542 GND.n676 55.7148
R1439 GND.t1383 GND.n711 55.7148
R1440 GND.n249 GND.t56 54.8988
R1441 GND.n175 GND.t464 54.8988
R1442 GND.n265 GND.t518 54.8979
R1443 GND.n153 GND.t1380 54.2748
R1444 GND.n839 GND.t239 54.1672
R1445 GND.t227 GND.n846 54.1672
R1446 GND.t1463 GND.t5 53.8089
R1447 GND.n179 GND.t554 53.8089
R1448 GND.t401 GND.t249 53.8079
R1449 GND.t527 GND.n848 53.1692
R1450 GND.t311 GND.t578 53.8089
R1451 GND.t21 GND.t468 52.777
R1452 GND.t449 GND.t21 52.777
R1453 GND.t14 GND.t630 52.777
R1454 GND.t242 GND.n70 52.1217
R1455 GND.n776 GND.t455 51.7246
R1456 GND.t385 GND.n504 51.7246
R1457 GND.t350 GND.n855 51.5764
R1458 GND.n642 GND.t1503 51.5764
R1459 GND.n777 GND.t248 51.5764
R1460 GND.n783 GND.t293 51.5764
R1461 GND.t156 GND.n562 51.5764
R1462 GND.t612 GND.n805 51.4291
R1463 GND.t75 GND.n843 51.4291
R1464 GND.t1128 GND.t1098 51.4291
R1465 GND.t1137 GND.t1104 51.4291
R1466 GND.t22 GND.n622 51.4291
R1467 GND.t530 GND.n615 51.4291
R1468 GND.n99 GND.t959 23.2336
R1469 GND.n96 GND.t941 22.2411
R1470 GND.n127 GND.t886 22.2411
R1471 GND.n125 GND.t927 23.2336
R1472 GND.t443 GND.t891 51.4291
R1473 GND.t220 GND.n734 51.4291
R1474 GND.n745 GND.t475 51.4291
R1475 GND.t506 GND.n863 50.1398
R1476 GND.t516 GND.t186 50.0005
R1477 GND.t11 GND.t117 50.0005
R1478 GND.n278 GND.t347 49.9891
R1479 GND.n256 GND.t659 49.9891
R1480 GND.t1409 GND.n160 49.9891
R1481 GND.t424 GND.t233 47.2784
R1482 GND.t267 GND.t431 47.1434
R1483 GND.t653 GND.t551 47.1434
R1484 GND.t484 GND.n472 47.1434
R1485 GND.n762 GND.t492 47.1434
R1486 GND.t28 GND.n512 45.5125
R1487 GND.n510 GND.n66 44.8359
R1488 GND.t262 GND.t327 44.2809
R1489 GND.n629 GND.t328 42.9804
R1490 GND.t105 GND.n485 42.9804
R1491 GND.t84 GND.n830 42.8576
R1492 GND.t1401 GND.n819 42.8576
R1493 GND.t565 GND.t1088 42.8576
R1494 GND.n641 GND.t429 42.8576
R1495 GND.t594 GND.n686 42.8576
R1496 GND.n691 GND.t135 42.8576
R1497 GND.n698 GND.t111 42.8576
R1498 GND.t445 GND.n491 42.8576
R1499 GND.n724 GND.t440 42.8576
R1500 GND.t1581 GND.n531 42.8576
R1501 GND.n259 GND.t24 42.0417
R1502 GND.n258 GND.t1457 41.4177
R1503 GND.t334 GND.t1253 38.5719
R1504 GND.n26 GND.t285 54.2748
R1505 GND.t536 GND.t585 38.5719
R1506 GND.t1116 GND.t187 38.5719
R1507 GND.t558 GND.n579 38.5719
R1508 GND.n590 GND.t561 38.5719
R1509 GND.n597 GND.t280 38.5719
R1510 GND.t283 GND.n570 38.5719
R1511 GND.t987 GND.t197 38.5719
R1512 GND.n661 GND.t1425 38.5719
R1513 GND.t1428 GND.n653 38.5719
R1514 GND.t1452 GND.n646 38.5719
R1515 GND.n670 GND.t1455 38.5719
R1516 GND.t1485 GND.n718 38.5719
R1517 GND.t828 GND.t194 38.5719
R1518 GND.t617 GND.n731 38.5719
R1519 GND.n736 GND.t1524 38.5719
R1520 GND.t681 GND.t191 38.5719
R1521 GND.n863 GND.t299 37.605
R1522 GND.n870 GND.t423 37.5005
R1523 GND.t427 GND.n834 37.5005
R1524 GND.t1572 GND.n465 37.5005
R1525 GND.t1196 GND.t80 37.5005
R1526 GND.t392 GND.n709 37.5005
R1527 GND.t914 GND.t1535 37.5005
R1528 GND.n705 GND.t546 37.5005
R1529 GND.t186 GND.n509 37.5005
R1530 GND.n77 GND.t98 37.1319
R1531 GND.t365 GND.n496 36.487
R1532 GND.n829 GND.t520 34.2862
R1533 GND.t529 GND.t645 34.2862
R1534 GND.t501 GND.n632 34.2862
R1535 GND.t1029 GND.t1448 34.2862
R1536 GND.t575 GND.n682 34.2862
R1537 GND.t442 GND.n486 34.2862
R1538 GND.n510 GND.t301 33.3338
R1539 GND.n517 GND.t260 33.2108
R1540 GND.n33 GND.t206 32.8462
R1541 GND.t1499 GND.n32 32.8462
R1542 GND.n247 GND.t203 32.8462
R1543 GND.n224 GND.t201 32.8462
R1544 GND.n202 GND.t150 32.8462
R1545 GND.t543 GND.n215 32.8462
R1546 GND.t110 GND.n72 32.8462
R1547 GND.n65 GND.t196 32.8462
R1548 GND.n59 GND.t178 32.8462
R1549 GND.t1525 GND.n52 32.8462
R1550 GND.n173 GND.t192 32.8462
R1551 GND.n10 GND.t193 32.3359
R1552 GND.n774 GND.n773 31.2505
R1553 GND.t591 GND.t583 30.6368
R1554 GND.n823 GND.t614 30.0005
R1555 GND.t1547 GND.n808 30.0005
R1556 GND.n814 GND.t433 30.0005
R1557 GND.n605 GND.t611 30.0005
R1558 GND.t1457 GND.t263 30.0005
R1559 GND.n618 GND.t267 30.0005
R1560 GND.t1544 GND.n468 30.0005
R1561 GND.t255 GND.t1484 30.0005
R1562 GND.n98 GND.t652 26.1545
R1563 GND.t249 GND.t216 29.1846
R1564 GND.t578 GND.t61 29.1836
R1565 GND.n837 GND.t238 29.1672
R1566 GND.n244 GND.t559 28.5605
R1567 GND.t560 GND.n244 28.5605
R1568 GND.t344 GND.n274 28.5605
R1569 GND.n274 GND.t636 28.5605
R1570 GND.n226 GND.t1453 28.5605
R1571 GND.t1454 GND.n226 28.5605
R1572 GND.t538 GND.n727 28.5605
R1573 GND.n727 GND.t103 28.5605
R1574 GND.t775 GND.t101 26.7266
R1575 GND.t386 GND.t775 26.7266
R1576 GND.n139 GND.t322 34.7251
R1577 GND.n737 GND.t257 25.7148
R1578 GND.t304 GND.n128 34.3974
R1579 GND.t582 GND.t384 24.3248
R1580 GND.n32 GND.t1508 24.2748
R1581 GND.t313 GND.n202 24.2748
R1582 GND.n215 GND.t76 24.2748
R1583 GND.n72 GND.t653 24.2748
R1584 GND.t490 GND.n59 24.2748
R1585 GND.n52 GND.t619 24.2748
R1586 GND.t74 GND.t343 21.4291
R1587 GND.t98 GND.t1459 21.4291
R1588 GND.t1582 GND.n761 21.4291
R1589 GND.t73 GND.t21 19.6558
R1590 GND.n129 GND.t667 7.95766
R1591 GND.t343 GND.t234 20.6121
R1592 GND.n11 GND.t478 20.0048
R1593 GND.n25 GND.t341 19.9891
R1594 GND.t586 GND.n187 19.9891
R1595 GND.t670 GND.n186 19.9891
R1596 GND.n71 GND.t669 19.9891
R1597 GND.t1484 GND.n77 19.9891
R1598 GND.n765 GND.t596 18.2932
R1599 GND.n777 GND.t541 17.1925
R1600 GND.t1471 GND.t1401 17.1434
R1601 GND.n630 GND.t329 17.1434
R1602 GND.t331 GND.n640 17.1434
R1603 GND.t1444 GND.t1028 17.1434
R1604 GND.t257 GND.t318 17.1434
R1605 GND.n383 GND.t234 0.649832
R1606 GND.t234 GND.n26 0.649832
R1607 GND.t578 GND.n50 0.649832
R1608 GND.t234 GND.n874 17.0005
R1609 GND.t234 GND.n793 17.0005
R1610 GND.t234 GND.n794 17.0005
R1611 GND.n345 GND.t234 0.649813
R1612 GND.n282 GND.t234 0.649813
R1613 GND.n796 GND.t234 17.0005
R1614 GND.t234 GND.n797 17.0005
R1615 GND.t234 GND.n866 17.0005
R1616 GND.t234 GND.n869 17.0005
R1617 GND.t234 GND.n870 17.0005
R1618 GND.t234 GND.n871 17.0005
R1619 GND.t234 GND.n872 17.0005
R1620 GND.t234 GND.n873 17.0005
R1621 GND.t234 GND.n798 17.0005
R1622 GND.t234 GND.n860 17.0005
R1623 GND.t234 GND.n863 17.0005
R1624 GND.t234 GND.n864 17.0005
R1625 GND.t234 GND.n854 17.0005
R1626 GND.t234 GND.n855 17.0005
R1627 GND.t234 GND.n856 17.0005
R1628 GND.n830 GND.t234 17.0005
R1629 GND.n829 GND.t234 17.0005
R1630 GND.n828 GND.t234 17.0005
R1631 GND.n85 GND.t234 16.1868
R1632 GND.t234 GND.n804 17.0005
R1633 GND.t234 GND.n803 17.0005
R1634 GND.t234 GND.n802 17.0005
R1635 GND.t234 GND.n800 17.0005
R1636 GND.t234 GND.n799 17.0005
R1637 GND.n839 GND.t234 17.0005
R1638 GND.n838 GND.t234 17.0005
R1639 GND.n837 GND.t234 17.0005
R1640 GND.n836 GND.t234 17.0005
R1641 GND.n835 GND.t234 17.0005
R1642 GND.n834 GND.t234 17.0005
R1643 GND.n833 GND.t234 17.0005
R1644 GND.n832 GND.t234 17.0005
R1645 GND.n831 GND.t234 17.0005
R1646 GND.n840 GND.t234 17.0005
R1647 GND.n853 GND.t234 17.0005
R1648 GND.n852 GND.t234 17.0005
R1649 GND.n851 GND.t234 17.0005
R1650 GND.n850 GND.t234 17.0005
R1651 GND.n849 GND.t234 17.0005
R1652 GND.n847 GND.t234 17.0005
R1653 GND.n846 GND.t234 17.0005
R1654 GND.n845 GND.t234 17.0005
R1655 GND.n844 GND.t234 17.0005
R1656 GND.n843 GND.t234 17.0005
R1657 GND.n111 GND.t234 7.50525
R1658 GND.n842 GND.t234 17.0005
R1659 GND.n841 GND.t234 17.0005
R1660 GND.n98 GND.t234 1.11651
R1661 GND.t234 GND.n817 17.0005
R1662 GND.t234 GND.n346 0.649813
R1663 GND.t234 GND.n816 17.0005
R1664 GND.t234 GND.n235 0.649813
R1665 GND.t234 GND.n815 17.0005
R1666 GND.n347 GND.t234 0.649813
R1667 GND.t234 GND.n131 8.48814
R1668 GND.t234 GND.n812 17.0005
R1669 GND.t234 GND.n814 17.0005
R1670 GND.t234 GND.n813 17.0005
R1671 GND.n143 GND.t234 0.649813
R1672 GND.n120 GND.t234 7.34144
R1673 GND.t234 GND.n818 17.0005
R1674 GND.n375 GND.t234 0.649813
R1675 GND.t234 GND.n807 17.0005
R1676 GND.t234 GND.n811 17.0005
R1677 GND.t234 GND.n808 17.0005
R1678 GND.t234 GND.n810 17.0005
R1679 GND.n140 GND.t234 7.66905
R1680 GND.t234 GND.n805 17.0005
R1681 GND.t234 GND.n806 17.0005
R1682 GND.t234 GND.n819 17.0005
R1683 GND.t234 GND.n820 17.0005
R1684 GND.t234 GND.n821 17.0005
R1685 GND.t234 GND.n822 17.0005
R1686 GND.t234 GND.n823 17.0005
R1687 GND.t234 GND.n824 17.0005
R1688 GND.t234 GND.n825 17.0005
R1689 GND.t234 GND.n826 17.0005
R1690 GND.t234 GND.n827 17.0005
R1691 GND.t5 GND.n92 3.4198
R1692 GND.t5 GND.n97 14.3867
R1693 GND.t5 GND.n467 17.0005
R1694 GND.t5 GND.n342 17.0005
R1695 GND.n387 GND.t5 5.6463
R1696 GND.t1165 GND.t1164 0.0657511
R1697 GND.n385 GND.t508 0.069885
R1698 GND.t5 GND.t1159 17.0005
R1699 GND.n386 GND.t5 5.6463
R1700 GND.t5 GND.n119 9.79521
R1701 GND.t5 GND.n465 17.0005
R1702 GND.t5 GND.n90 4.76624
R1703 GND.t5 GND.n390 5.64438
R1704 GND.t519 GND.n611 17.0005
R1705 GND.t519 GND.n621 17.0005
R1706 GND.t519 GND.n612 17.0005
R1707 GND.t519 GND.n620 17.0005
R1708 GND.t519 GND.n613 17.0005
R1709 GND.t519 GND.n619 17.0005
R1710 GND.t519 GND.n614 17.0005
R1711 GND.t519 GND.n618 17.0005
R1712 GND.t519 GND.n615 17.0005
R1713 GND.t519 GND.n616 17.0005
R1714 GND.t519 GND.n617 17.0005
R1715 GND.n622 GND.t519 17.0005
R1716 GND.t519 GND.n623 17.0005
R1717 GND.t519 GND.n609 17.0005
R1718 GND.t519 GND.n602 17.0005
R1719 GND.t519 GND.n608 17.0005
R1720 GND.t519 GND.n607 17.0005
R1721 GND.t519 GND.n603 17.0005
R1722 GND.t519 GND.n606 17.0005
R1723 GND.t519 GND.n604 17.0005
R1724 GND.t519 GND.n605 17.0005
R1725 GND.n624 GND.t519 17.0005
R1726 GND.t519 GND.n625 17.0005
R1727 GND.t519 GND.n567 17.0005
R1728 GND.t519 GND.n601 17.0005
R1729 GND.t519 GND.n568 17.0005
R1730 GND.t519 GND.n569 17.0005
R1731 GND.t519 GND.n600 17.0005
R1732 GND.t519 GND.n599 17.0005
R1733 GND.t519 GND.n570 17.0005
R1734 GND.t519 GND.n598 17.0005
R1735 GND.t519 GND.n571 17.0005
R1736 GND.t519 GND.n597 17.0005
R1737 GND.t519 GND.n572 17.0005
R1738 GND.t519 GND.n596 17.0005
R1739 GND.t519 GND.n573 17.0005
R1740 GND.t519 GND.n595 17.0005
R1741 GND.t519 GND.n574 17.0005
R1742 GND.t519 GND.n594 17.0005
R1743 GND.t519 GND.n575 17.0005
R1744 GND.t519 GND.n593 17.0005
R1745 GND.t519 GND.n576 17.0005
R1746 GND.t519 GND.n592 17.0005
R1747 GND.t519 GND.n577 17.0005
R1748 GND.t519 GND.n591 17.0005
R1749 GND.t519 GND.n578 17.0005
R1750 GND.t519 GND.n590 17.0005
R1751 GND.t519 GND.n579 17.0005
R1752 GND.t519 GND.n589 17.0005
R1753 GND.t519 GND.n580 17.0005
R1754 GND.t519 GND.n588 17.0005
R1755 GND.t519 GND.n341 0.649813
R1756 GND.t519 GND.n582 17.0005
R1757 GND.t519 GND.n587 17.0005
R1758 GND.t519 GND.n583 17.0005
R1759 GND.t519 GND.n586 17.0005
R1760 GND.t519 GND.n584 17.0005
R1761 GND.t519 GND.n585 17.0005
R1762 GND.t519 GND.n340 17.0005
R1763 GND.n117 GND.t21 9.79175
R1764 GND.n106 GND.t21 3.42966
R1765 GND.n394 GND.t21 5.6463
R1766 GND.t21 GND.n642 17.0005
R1767 GND.t21 GND.n628 17.0005
R1768 GND.t21 GND.n133 11.4368
R1769 GND.t21 GND.n637 17.0005
R1770 GND.t21 GND.n636 17.0005
R1771 GND.t21 GND.n635 17.0005
R1772 GND.t21 GND.n634 17.0005
R1773 GND.t21 GND.n633 17.0005
R1774 GND.t21 GND.n632 17.0005
R1775 GND.t21 GND.n631 17.0005
R1776 GND.t21 GND.n630 17.0005
R1777 GND.t21 GND.n629 17.0005
R1778 GND.n121 GND.t21 15.8598
R1779 GND.n638 GND.t21 17.0005
R1780 GND.t21 GND.n232 8.48857
R1781 GND.n9 GND.t21 0.975673
R1782 GND.t21 GND.n641 17.0005
R1783 GND.n640 GND.t21 17.0005
R1784 GND.n639 GND.t21 17.0005
R1785 GND.n228 GND.n673 17.0005
R1786 GND.n228 GND.n699 17.0005
R1787 GND.n228 GND.n674 17.0005
R1788 GND.n228 GND.n698 17.0005
R1789 GND.n228 GND.n675 17.0005
R1790 GND.n228 GND.n676 17.0005
R1791 GND.n228 GND.n697 17.0005
R1792 GND.n228 GND.n677 17.0005
R1793 GND.n228 GND.n696 17.0005
R1794 GND.n228 GND.n678 17.0005
R1795 GND.n228 GND.n695 17.0005
R1796 GND.n228 GND.n679 17.0005
R1797 GND.n228 GND.n694 17.0005
R1798 GND.n228 GND.n680 17.0005
R1799 GND.n228 GND.n693 17.0005
R1800 GND.n228 GND.n681 17.0005
R1801 GND.n228 GND.n692 17.0005
R1802 GND.n228 GND.n682 17.0005
R1803 GND.n228 GND.n691 17.0005
R1804 GND.n228 GND.n683 17.0005
R1805 GND.n228 GND.n690 17.0005
R1806 GND.n228 GND.n684 17.0005
R1807 GND.n228 GND.n689 17.0005
R1808 GND.n228 GND.n685 17.0005
R1809 GND.n228 GND.n688 17.0005
R1810 GND.n228 GND.n686 17.0005
R1811 GND.n228 GND.n687 17.0005
R1812 GND.n228 GND.n643 17.0005
R1813 GND.n228 GND.n672 17.0005
R1814 GND.n228 GND.n644 17.0005
R1815 GND.n228 GND.n671 17.0005
R1816 GND.n228 GND.n645 17.0005
R1817 GND.n228 GND.n670 17.0005
R1818 GND.n228 GND.n646 17.0005
R1819 GND.n228 GND.n669 17.0005
R1820 GND.n228 GND.n647 17.0005
R1821 GND.n228 GND.n668 17.0005
R1822 GND.n228 GND.n648 17.0005
R1823 GND.n228 GND.n667 17.0005
R1824 GND.n228 GND.n649 17.0005
R1825 GND.n228 GND.n666 17.0005
R1826 GND.n228 GND.n650 17.0005
R1827 GND.n228 GND.n665 17.0005
R1828 GND.n228 GND.n651 17.0005
R1829 GND.n228 GND.n664 17.0005
R1830 GND.n228 GND.n652 17.0005
R1831 GND.n228 GND.n663 17.0005
R1832 GND.n228 GND.n653 17.0005
R1833 GND.n228 GND.n662 17.0005
R1834 GND.n228 GND.n654 17.0005
R1835 GND.n228 GND.n661 17.0005
R1836 GND.n228 GND.n655 17.0005
R1837 GND.n228 GND.n229 9.30762
R1838 GND.n228 GND.n323 0.649813
R1839 GND.n228 GND.n657 17.0005
R1840 GND.n228 GND.n660 17.0005
R1841 GND.n228 GND.n658 17.0005
R1842 GND.n228 GND.n659 17.0005
R1843 GND.n783 GND.t249 17.0005
R1844 GND.n782 GND.t249 17.0005
R1845 GND.n784 GND.t249 17.0005
R1846 GND.n80 GND.t249 2.91035
R1847 GND.n789 GND.t249 17.0005
R1848 GND.n787 GND.t249 17.0005
R1849 GND.n137 GND.t249 1.11651
R1850 GND.n786 GND.t249 17.0005
R1851 GND.n785 GND.t249 17.0005
R1852 GND.t249 GND.n479 17.0005
R1853 GND.n778 GND.t249 17.0005
R1854 GND.t249 GND.n779 17.0005
R1855 GND.n318 GND.t249 0.666899
R1856 GND.t249 GND.n478 17.0005
R1857 GND.t249 GND.n477 17.0005
R1858 GND.n292 GND.t249 0.649813
R1859 GND.t249 GND.n476 17.0005
R1860 GND.t249 GND.n105 3.31705
R1861 GND.n319 GND.t249 0.649813
R1862 GND.t249 GND.n471 17.0005
R1863 GND.t249 GND.n475 17.0005
R1864 GND.t249 GND.n472 17.0005
R1865 GND.t249 GND.n474 17.0005
R1866 GND.t249 GND.n473 17.0005
R1867 GND.t249 GND.n234 0.649813
R1868 GND.n780 GND.t249 17.0005
R1869 GND.t249 GND.n781 17.0005
R1870 GND.t249 GND.n468 17.0005
R1871 GND.t249 GND.n470 17.0005
R1872 GND.t249 GND.n469 17.0005
R1873 GND.t249 GND.n404 5.64548
R1874 GND.n291 GND.t249 0.649813
R1875 GND.t249 GND.n777 17.0005
R1876 GND.t249 GND.n484 17.0005
R1877 GND.n88 GND.t249 4.69537
R1878 GND.n316 GND.t249 0.649813
R1879 GND.t249 GND.n141 0.649813
R1880 GND.t249 GND.n483 17.0005
R1881 GND.n482 GND.t249 17.0005
R1882 GND.n481 GND.t249 17.0005
R1883 GND.n480 GND.t249 17.0005
R1884 GND.t249 GND.t548 4.25103
R1885 GND.t249 GND.n485 17.0005
R1886 GND.t249 GND.n776 17.0005
R1887 GND.t249 GND.n503 17.0005
R1888 GND.t249 GND.n500 17.0005
R1889 GND.t249 GND.n499 17.0005
R1890 GND.t249 GND.n498 17.0005
R1891 GND.t249 GND.n497 17.0005
R1892 GND.t249 GND.n496 17.0005
R1893 GND.t249 GND.n495 17.0005
R1894 GND.t249 GND.n493 17.0005
R1895 GND.t249 GND.n492 17.0005
R1896 GND.t249 GND.n491 17.0005
R1897 GND.t249 GND.n490 17.0005
R1898 GND.t249 GND.n489 17.0005
R1899 GND.t249 GND.n488 17.0005
R1900 GND.t249 GND.n487 17.0005
R1901 GND.t249 GND.n486 17.0005
R1902 GND.t249 GND.n504 17.0005
R1903 GND.t249 GND.n775 17.0005
R1904 GND.t592 GND.n328 0.0298249
R1905 GND.t249 GND.n774 17.0005
R1906 GND.t46 GND.n701 17.0005
R1907 GND.t46 GND.n702 17.0005
R1908 GND.t46 GND.n703 17.0005
R1909 GND.t46 GND.n704 17.0005
R1910 GND.t46 GND.n705 17.0005
R1911 GND.t46 GND.n706 17.0005
R1912 GND.t46 GND.n707 17.0005
R1913 GND.t46 GND.n708 17.0005
R1914 GND.n419 GND.t273 0.120486
R1915 GND.t46 GND.n709 17.0005
R1916 GND.n83 GND.t46 4.76624
R1917 GND.t46 GND.n729 17.0005
R1918 GND.t46 GND.n414 0.649813
R1919 GND.t46 GND.n711 17.0005
R1920 GND.t46 GND.n717 17.0005
R1921 GND.t46 GND.n712 17.0005
R1922 GND.n416 GND.t46 0.649813
R1923 GND.t46 GND.n716 17.0005
R1924 GND.n715 GND.t46 17.0005
R1925 GND.n714 GND.t46 17.0005
R1926 GND.t46 GND.n104 8.48812
R1927 GND.t46 GND.n103 9.30721
R1928 GND.t46 GND.n114 9.63482
R1929 GND.t46 GND.n113 9.30721
R1930 GND.t46 GND.n108 9.63482
R1931 GND.t46 GND.n725 17.0005
R1932 GND.n415 GND.t46 0.649813
R1933 GND.n724 GND.t46 17.0005
R1934 GND.n722 GND.t46 17.0005
R1935 GND.t46 GND.n728 17.0005
R1936 GND.t46 GND.n721 17.0005
R1937 GND.t46 GND.n720 17.0005
R1938 GND.t46 GND.n719 17.0005
R1939 GND.t46 GND.n718 17.0005
R1940 GND.t46 GND.n116 9.96245
R1941 GND.t578 GND.n756 17.0005
R1942 GND.t578 GND.n748 17.0005
R1943 GND.t578 GND.n315 0.649813
R1944 GND.t578 GND.n744 17.0005
R1945 GND.t578 GND.n747 17.0005
R1946 GND.n746 GND.t578 17.0005
R1947 GND.t578 GND.n745 17.0005
R1948 GND.t578 GND.n283 0.649813
R1949 GND.t578 GND.n743 17.0005
R1950 GND.n310 GND.t578 0.649813
R1951 GND.t578 GND.n742 17.0005
R1952 GND.n294 GND.t578 0.649813
R1953 GND.t578 GND.n741 17.0005
R1954 GND.t578 GND.n311 0.649813
R1955 GND.t578 GND.n740 17.0005
R1956 GND.t578 GND.n148 0.649813
R1957 GND.t578 GND.n739 17.0005
R1958 GND.t578 GND.n312 0.649813
R1959 GND.t578 GND.n738 17.0005
R1960 GND.n757 GND.t578 17.0005
R1961 GND.t578 GND.n758 17.0005
R1962 GND.t578 GND.n734 17.0005
R1963 GND.t578 GND.n737 17.0005
R1964 GND.t578 GND.n735 17.0005
R1965 GND.t578 GND.n736 17.0005
R1966 GND.t578 GND.n313 0.649813
R1967 GND.t578 GND.n731 17.0005
R1968 GND.t578 GND.n733 17.0005
R1969 GND.t578 GND.n732 17.0005
R1970 GND.n759 GND.t578 17.0005
R1971 GND.t578 GND.n760 17.0005
R1972 GND.t578 GND.n314 0.649813
R1973 GND.t578 GND.n730 17.0005
R1974 GND.n761 GND.t578 17.0005
R1975 GND.t578 GND.n762 17.0005
R1976 GND.t578 GND.n531 17.0005
R1977 GND.n293 GND.t578 0.649813
R1978 GND.t578 GND.n530 17.0005
R1979 GND.n142 GND.t578 0.649813
R1980 GND.t578 GND.n529 17.0005
R1981 GND.n309 GND.t578 0.649813
R1982 GND.t578 GND.n525 17.0005
R1983 GND.t578 GND.n528 17.0005
R1984 GND.n527 GND.t578 17.0005
R1985 GND.t578 GND.n233 0.649813
R1986 GND.n526 GND.t578 17.0005
R1987 GND.n753 GND.t578 17.0005
R1988 GND.n752 GND.t578 17.0005
R1989 GND.n751 GND.t578 17.0005
R1990 GND.n750 GND.t578 17.0005
R1991 GND.n749 GND.t578 17.0005
R1992 GND.t578 GND.n93 3.4198
R1993 GND.n755 GND.t578 17.0005
R1994 GND.n754 GND.t578 17.0005
R1995 GND.t578 GND.n101 9.63482
R1996 GND.n110 GND.t578 3.08228
R1997 GND.t14 GND.n94 3.42966
R1998 GND.t763 GND.t764 0.0583051
R1999 GND.n450 GND.t1494 0.069885
R2000 GND.t14 GND.n522 17.0005
R2001 GND.n512 GND.t14 17.0005
R2002 GND.n513 GND.t14 17.0005
R2003 GND.n515 GND.t14 17.0005
R2004 GND.n517 GND.t14 17.0005
R2005 GND.n518 GND.t14 17.0005
R2006 GND.n519 GND.t14 17.0005
R2007 GND.n520 GND.t14 17.0005
R2008 GND.n87 GND.t14 11.0749
R2009 GND.n454 GND.t778 0.0583051
R2010 GND.n455 GND.t14 0.648101
R2011 GND.t14 GND.n508 17.0005
R2012 GND.t14 GND.n767 17.0005
R2013 GND.t14 GND.n509 17.0005
R2014 GND.t14 GND.n766 17.0005
R2015 GND.n768 GND.t14 17.0005
R2016 GND.n459 GND.t14 5.6463
R2017 GND.t14 GND.n135 3.41984
R2018 GND.n507 GND.t14 17.0005
R2019 GND.n302 GND.t14 0.666899
R2020 GND.n565 GND.t157 17.0005
R2021 GND.t157 GND.n566 17.0005
R2022 GND.t157 GND.n532 17.0005
R2023 GND.t157 GND.n236 9.30762
R2024 GND.t157 GND.n533 17.0005
R2025 GND.t157 GND.n534 17.0005
R2026 GND.t157 GND.n555 17.0005
R2027 GND.t157 GND.n554 17.0005
R2028 GND.t157 GND.n535 17.0005
R2029 GND.t157 GND.n536 17.0005
R2030 GND.t157 GND.n553 17.0005
R2031 GND.t157 GND.n552 17.0005
R2032 GND.t157 GND.n537 17.0005
R2033 GND.t157 GND.n538 17.0005
R2034 GND.t157 GND.n551 17.0005
R2035 GND.t157 GND.n550 17.0005
R2036 GND.t157 GND.n539 17.0005
R2037 GND.t157 GND.n549 17.0005
R2038 GND.t157 GND.n540 17.0005
R2039 GND.t157 GND.n548 17.0005
R2040 GND.t157 GND.n460 0.649813
R2041 GND.t157 GND.n541 17.0005
R2042 GND.t157 GND.n547 17.0005
R2043 GND.t157 GND.n542 17.0005
R2044 GND.t157 GND.n546 17.0005
R2045 GND.t157 GND.n543 17.0005
R2046 GND.t157 GND.n544 17.0005
R2047 GND.t157 GND.n545 17.0005
R2048 GND.t157 GND.n558 17.0005
R2049 GND.t157 GND.n556 17.0005
R2050 GND.t157 GND.n557 17.0005
R2051 GND.t157 GND.n563 17.0005
R2052 GND.t157 GND.n564 17.0005
R2053 GND.t157 GND.n559 17.0005
R2054 GND.t157 GND.n561 17.0005
R2055 GND.t157 GND.n562 17.0005
R2056 GND.t16 GND.n494 14.3531
R2057 GND.n800 GND.t325 12.8576
R2058 GND.t1579 GND.n825 12.8576
R2059 GND.t281 GND.n571 12.8576
R2060 GND.n598 GND.t282 12.8576
R2061 GND.n632 GND.t416 12.8576
R2062 GND.n638 GND.t265 12.8576
R2063 GND.n121 GND.t1062 227.636
R2064 GND.t1426 GND.n654 12.8576
R2065 GND.n662 GND.t1427 12.8576
R2066 GND.t88 GND.n683 12.8576
R2067 GND.n691 GND.t137 12.8576
R2068 GND.n487 GND.t476 12.8576
R2069 GND.t409 GND.n291 28.5605
R2070 GND.n291 GND.t1541 28.5605
R2071 GND.n319 GND.t252 28.5605
R2072 GND.n319 GND.t1458 28.5605
R2073 GND.n293 GND.t1418 28.5605
R2074 GND.n293 GND.t1540 28.5605
R2075 GND.n313 GND.t603 28.5605
R2076 GND.n867 GND.t140 12.5005
R2077 GND.t537 GND.t1153 12.5005
R2078 GND.n766 GND.t237 12.5005
R2079 GND.n859 GND.n858 11.8582
R2080 GND.t444 GND.n484 8.59649
R2081 GND.t604 GND.t488 8.57193
R2082 GND.t654 GND.t605 8.57193
R2083 GND.t426 GND.t240 8.57193
R2084 GND.t1089 GND.t570 8.57193
R2085 GND.n608 GND.t637 8.57193
R2086 GND.n619 GND.t531 8.57193
R2087 GND.t339 GND.n631 8.57193
R2088 GND.n639 GND.t1466 8.57193
R2089 GND.t138 GND.n684 8.57193
R2090 GND.n473 GND.t1460 8.57193
R2091 GND.t540 GND.n415 24.2748
R2092 GND.t1530 GND.n539 8.57193
R2093 GND.t5 GND.n298 3.36018
R2094 GND.t14 GND.t766 8.53839
R2095 GND.n149 GND.t249 3.32451
R2096 GND.n372 GND.t1377 0.096752
R2097 GND.t1375 GND.n89 8.501
R2098 GND.n371 GND.t1372 0.130189
R2099 GND.t1370 GND.n89 8.501
R2100 GND.n370 GND.t1367 0.130189
R2101 GND.t1365 GND.n89 8.501
R2102 GND.n369 GND.t1362 0.130189
R2103 GND.t1360 GND.n89 8.501
R2104 GND.n368 GND.t1357 0.130189
R2105 GND.t1355 GND.n89 8.501
R2106 GND.n367 GND.t1352 0.130189
R2107 GND.t1350 GND.n89 8.501
R2108 GND.n366 GND.t1347 0.130189
R2109 GND.t1345 GND.n89 8.501
R2110 GND.n365 GND.t1342 0.130189
R2111 GND.t1340 GND.n89 8.501
R2112 GND.n364 GND.t1337 0.130189
R2113 GND.t1335 GND.n89 8.501
R2114 GND.n363 GND.t1332 0.130189
R2115 GND.t1330 GND.n89 8.501
R2116 GND.n362 GND.t1327 0.130189
R2117 GND.t1325 GND.n89 8.501
R2118 GND.n361 GND.t1322 0.130189
R2119 GND.t1320 GND.n89 8.501
R2120 GND.n360 GND.t225 0.130189
R2121 GND.n359 GND.t1316 0.280539
R2122 GND.t1314 GND.n89 8.501
R2123 GND.n358 GND.t1311 0.130189
R2124 GND.t1309 GND.n89 8.501
R2125 GND.n357 GND.t1306 0.130189
R2126 GND.t1304 GND.n89 8.501
R2127 GND.n356 GND.t1301 0.130189
R2128 GND.t1299 GND.n89 8.501
R2129 GND.n355 GND.t1296 0.130189
R2130 GND.t1291 GND.n354 0.215686
R2131 GND.t1289 GND.n89 8.501
R2132 GND.n353 GND.t1286 0.130189
R2133 GND.t1284 GND.n89 8.501
R2134 GND.n352 GND.t1281 0.130189
R2135 GND.t1279 GND.n89 8.501
R2136 GND.n351 GND.t1276 0.130189
R2137 GND.t1274 GND.n89 8.501
R2138 GND.n350 GND.t1271 0.130189
R2139 GND.t1269 GND.n89 8.501
R2140 GND.n89 GND.n349 3.33079
R2141 GND.t1233 GND.n344 0.0377157
R2142 GND.n344 GND.t234 4.23289
R2143 GND.t234 GND.n384 3.33079
R2144 GND.t234 GND.t362 0.952411
R2145 GND.t400 GND.n343 0.135296
R2146 GND.t644 GND.n374 0.624318
R2147 GND.t1242 GND.t234 8.501
R2148 GND.n373 GND.t234 3.33079
R2149 GND.t234 GND.t286 8.501
R2150 GND.n382 GND.t234 2.318
R2151 GND.n381 GND.t234 2.31585
R2152 GND.n380 GND.t234 2.31585
R2153 GND.n379 GND.t234 0.983506
R2154 GND.n378 GND.t234 3.33079
R2155 GND.t292 GND.t234 8.501
R2156 GND.t1247 GND.n377 0.130189
R2157 GND.t79 GND.n376 0.236161
R2158 GND.n82 GND.t5 0.885608
R2159 GND.t1189 GND.n146 0.146844
R2160 GND.t1188 GND.n333 0.0793054
R2161 GND.t1187 GND.n297 0.135098
R2162 GND.t1185 GND.t5 8.501
R2163 GND.t1184 GND.n339 0.0836055
R2164 GND.t5 GND.n388 5.6463
R2165 GND.t1181 GND.n299 0.135098
R2166 GND.n334 GND.t5 4.20468
R2167 GND.n387 GND.t229 0.0333775
R2168 GND.n138 GND.t5 3.33079
R2169 GND.t470 GND.n337 0.0836055
R2170 GND.t5 GND.t223 5.6463
R2171 GND.t1170 GND.n336 0.0836055
R2172 GND.n231 GND.t5 2.7427
R2173 GND.t5 GND.t1164 5.6463
R2174 GND.n385 GND.t5 5.64493
R2175 GND.n386 GND.t1158 0.0333775
R2176 GND.n280 GND.t5 3.32884
R2177 GND.t1199 GND.t5 8.501
R2178 GND.n389 GND.t1197 0.397766
R2179 GND.t1193 GND.n332 0.0793054
R2180 GND.t5 GND.n296 3.32884
R2181 GND.n300 GND.t5 4.20315
R2182 GND.t469 GND.n298 0.0971543
R2183 GND.t82 GND.t5 1.21353
R2184 GND.t1206 GND.n390 0.0362711
R2185 GND.t1204 GND.n331 0.0793054
R2186 GND.n391 GND.t5 3.32876
R2187 GND.t23 GND.n329 0.759456
R2188 GND.n393 GND.t519 0.416151
R2189 GND.t188 GND.n392 0.751124
R2190 GND.n394 GND.t1072 0.0333775
R2191 GND.n326 GND.t21 4.20253
R2192 GND.t1079 GND.n325 0.0737702
R2193 GND.t90 GND.t21 8.501
R2194 GND.t337 GND.t21 8.501
R2195 GND.n397 GND.t21 2.3169
R2196 GND.n398 GND.t21 0.556945
R2197 GND.n399 GND.t21 3.32884
R2198 GND.t1064 GND.n289 0.215964
R2199 GND.n289 GND.t21 2.33234
R2200 GND.n401 GND.n228 0.41286
R2201 GND.t198 GND.n400 0.809428
R2202 GND.t62 GND.t249 0.89507
R2203 GND.t949 GND.n403 0.129991
R2204 GND.n402 GND.t249 2.31576
R2205 GND.n321 GND.t249 0.757701
R2206 GND.t967 GND.n407 0.130189
R2207 GND.n317 GND.t249 1.74964
R2208 GND.t404 GND.n317 0.328435
R2209 GND.n406 GND.t249 0.610124
R2210 GND.t256 GND.n405 0.431232
R2211 GND.t956 GND.n320 0.28496
R2212 GND.t953 GND.n404 0.0346178
R2213 GND.t970 GND.t249 8.501
R2214 GND.t106 GND.n411 0.795086
R2215 GND.t146 GND.t249 8.501
R2216 GND.t979 GND.n410 0.130189
R2217 GND.t666 GND.t249 8.501
R2218 GND.t131 GND.n409 0.129991
R2219 GND.t972 GND.n408 0.236161
R2220 GND.t3 GND.t249 1.30802
R2221 GND.t448 GND.n301 0.0737702
R2222 GND.n422 GND.t917 0.129991
R2223 GND.t915 GND.n417 0.397766
R2224 GND.n284 GND.t46 4.20253
R2225 GND.t307 GND.t46 1.00612
R2226 GND.t923 GND.n413 0.219597
R2227 GND.t920 GND.t46 8.501
R2228 GND.n424 GND.t46 0.557273
R2229 GND.n423 GND.t104 0.130189
R2230 GND.n431 GND.t578 3.33087
R2231 GND.n430 GND.t578 2.31585
R2232 GND.t305 GND.t578 8.501
R2233 GND.t578 GND.n429 3.33079
R2234 GND.n443 GND.t578 2.31581
R2235 GND.n442 GND.t578 2.31585
R2236 GND.n441 GND.t578 2.31585
R2237 GND.n440 GND.t578 2.31585
R2238 GND.n439 GND.t578 2.31585
R2239 GND.n438 GND.t578 2.31585
R2240 GND.n437 GND.t578 2.31585
R2241 GND.t116 GND.n436 0.290827
R2242 GND.n435 GND.t578 3.33087
R2243 GND.t315 GND.t578 8.501
R2244 GND.n434 GND.t578 3.33079
R2245 GND.n433 GND.t578 1.73694
R2246 GND.n447 GND.t578 2.318
R2247 GND.n446 GND.t578 2.31585
R2248 GND.n445 GND.t578 2.31585
R2249 GND.n444 GND.t578 3.33087
R2250 GND.t439 GND.t578 8.501
R2251 GND.n448 GND.t578 3.33079
R2252 GND.t790 GND.t578 8.501
R2253 GND.t578 GND.n449 3.33079
R2254 GND.n432 GND.t578 1.05028
R2255 GND.t270 GND.t578 8.501
R2256 GND.t247 GND.t578 8.501
R2257 GND.n427 GND.t578 3.33079
R2258 GND.n428 GND.t578 2.31412
R2259 GND.t14 GND.n286 2.75749
R2260 GND.n450 GND.t14 5.64493
R2261 GND.n305 GND.t656 0.0811489
R2262 GND.n452 GND.t14 5.64438
R2263 GND.n454 GND.t14 5.64879
R2264 GND.n456 GND.t13 0.530424
R2265 GND.n765 GND.t14 8.501
R2266 GND.t10 GND.t14 2.42941
R2267 GND.n459 GND.t68 0.0333775
R2268 GND.t14 GND.t397 8.501
R2269 GND.t780 GND.n458 0.130189
R2270 GND.n463 GND.t157 1.99155
R2271 GND.n464 GND.t157 0.518239
R2272 GND.n462 GND.t157 0.671652
R2273 GND.n461 GND.t716 0.918791
R2274 GND.t234 GND.n865 8.5005
R2275 GND.t234 GND.t1469 4.25087
R2276 GND.n146 GND.t5 2.76736
R2277 GND.n333 GND.t5 4.20468
R2278 GND.n339 GND.t5 4.20253
R2279 GND.t1179 GND.n334 0.07903
R2280 GND.t1177 GND.n338 0.119605
R2281 GND.n338 GND.t5 4.177
R2282 GND.n337 GND.t5 4.20253
R2283 GND.n336 GND.t5 4.20253
R2284 GND.n152 GND.t5 3.30696
R2285 GND.t1163 GND.n335 0.17801
R2286 GND.n466 GND.t5 8.47111
R2287 GND.t5 GND.n332 4.20468
R2288 GND.t160 GND.n300 0.0820912
R2289 GND.n331 GND.t5 4.20468
R2290 GND.t519 GND.t35 8.47111
R2291 GND.t48 GND.n144 0.346537
R2292 GND.n151 GND.t21 0.279461
R2293 GND.t607 GND.n330 0.119605
R2294 GND.t21 GND.n330 4.177
R2295 GND.n144 GND.t21 1.75821
R2296 GND.t1073 GND.n326 0.083315
R2297 GND.n327 GND.t21 2.29755
R2298 GND.n288 GND.t21 4.177
R2299 GND.n325 GND.t21 4.20744
R2300 GND.t1076 GND.n324 0.177814
R2301 GND.n627 GND.t21 8.47111
R2302 GND.n395 GND.t21 4.177
R2303 GND.t151 GND.n395 0.119605
R2304 GND.t483 GND.n396 0.119605
R2305 GND.n396 GND.t21 4.177
R2306 GND.t622 GND.n288 0.119605
R2307 GND.n322 GND.t943 0.119605
R2308 GND.n322 GND.t249 4.177
R2309 GND.n281 GND.t379 0.119605
R2310 GND.t46 GND.n281 4.177
R2311 GND.n412 GND.t46 3.30688
R2312 GND.n425 GND.t371 0.177814
R2313 GND.t367 GND.n426 0.119605
R2314 GND.n426 GND.t46 4.177
R2315 GND.n419 GND.t46 5.61485
R2316 GND.t272 GND.t46 8.47111
R2317 GND.n301 GND.t46 4.20744
R2318 GND.n420 GND.t46 4.177
R2319 GND.t625 GND.n420 0.119605
R2320 GND.t319 GND.n284 0.083315
R2321 GND.n421 GND.t46 4.177
R2322 GND.t885 GND.n421 0.119605
R2323 GND.n418 GND.t46 4.177
R2324 GND.n523 GND.t14 8.47111
R2325 GND.n306 GND.t14 2.29755
R2326 GND.n307 GND.t14 5.61485
R2327 GND.n285 GND.t14 2.29748
R2328 GND.t14 GND.n305 4.20376
R2329 GND.t14 GND.n453 4.177
R2330 GND.t20 GND.n453 0.119605
R2331 GND.n150 GND.t14 4.177
R2332 GND.n150 GND.t94 0.119605
R2333 GND.t14 GND.n304 4.177
R2334 GND.t59 GND.n303 0.723143
R2335 GND.t767 GND.n457 0.119605
R2336 GND.n457 GND.t14 4.177
R2337 GND GND.t689 8.36235
R2338 GND.n862 GND.n860 8.35705
R2339 GND.t87 GND.n833 8.33383
R2340 GND GND.t295 8.3005
R2341 GND.t838 GND 8.3005
R2342 GND GND.t1421 8.3005
R2343 GND GND.t413 8.3005
R2344 GND GND.t1027 8.3005
R2345 GND GND.t1413 8.3005
R2346 GND GND.t557 8.3005
R2347 GND GND.n109 8.3005
R2348 GND.t7 GND 8.3005
R2349 GND GND.t1294 8.3005
R2350 GND.t93 GND.n511 7.813
R2351 GND.t145 GND.t249 1.71436
R2352 GND.t613 GND.t1557 7.1604
R2353 GND.t1469 GND.t1243 7.1604
R2354 GND.t548 GND.t969 7.1604
R2355 GND.t873 GND.t577 7.1604
R2356 GND.t58 GND.t210 7.1604
R2357 GND.t596 GND.t1393 7.1604
R2358 GND.t101 GND.t1391 6.68201
R2359 GND.n328 GND.t249 4.32641
R2360 GND.t72 GND.t21 1.23508
R2361 GND.t14 GND.t19 0.60247
R2362 GND.t234 GND.n859 5.66717
R2363 GND.n372 GND.n89 3.35999
R2364 GND.n451 GND.t14 2.74064
R2365 GND.n89 GND.n371 3.33079
R2366 GND.n370 GND.n89 3.33079
R2367 GND.n89 GND.n369 3.33079
R2368 GND.n368 GND.n89 3.33079
R2369 GND.n89 GND.n367 3.33079
R2370 GND.n366 GND.n89 3.33079
R2371 GND.n89 GND.n365 3.33079
R2372 GND.n364 GND.n89 3.33079
R2373 GND.n89 GND.n363 3.33079
R2374 GND.n362 GND.n89 3.33079
R2375 GND.n89 GND.n361 3.33079
R2376 GND.n360 GND.n89 3.33079
R2377 GND.n358 GND.n89 3.33079
R2378 GND.n89 GND.n357 3.33079
R2379 GND.n356 GND.n89 3.33079
R2380 GND.n89 GND.n355 3.33079
R2381 GND.n353 GND.n89 3.33079
R2382 GND.n89 GND.n352 3.33079
R2383 GND.n351 GND.n89 3.33079
R2384 GND.n89 GND.n350 3.33079
R2385 GND.t1267 GND.n349 0.0863258
R2386 GND.t234 GND.n343 3.32876
R2387 GND.t1240 GND.n373 0.0863258
R2388 GND.n378 GND.t1252 0.0863258
R2389 GND.t234 GND.n377 3.33079
R2390 GND.n297 GND.t5 3.32884
R2391 GND.n299 GND.t5 3.32884
R2392 GND.t1169 GND.t5 5.61485
R2393 GND.t85 GND.n231 0.147758
R2394 GND.t1166 GND.n152 0.118193
R2395 GND.t5 GND.n335 3.30688
R2396 GND.t1156 GND.n280 0.0895683
R2397 GND.t1200 GND.n391 0.0896992
R2398 GND.t1191 GND.n296 0.0895683
R2399 GND.t40 GND.n327 0.231606
R2400 GND.n230 GND.t21 3.30696
R2401 GND.n324 GND.t21 3.30696
R2402 GND.n38 GND.t21 0.724122
R2403 GND.t937 GND.n149 0.106033
R2404 GND.n403 GND.t249 3.33087
R2405 GND.t249 GND.n407 3.33079
R2406 GND.n410 GND.t249 3.33079
R2407 GND.t249 GND.n409 3.33087
R2408 GND.t249 GND.n772 5.61485
R2409 GND.n412 GND.t180 0.118323
R2410 GND.t46 GND.n425 3.30696
R2411 GND.n710 GND.t46 5.61485
R2412 GND.t447 GND.n295 0.182687
R2413 GND.n422 GND.t46 3.33087
R2414 GND.t908 GND.t46 5.61485
R2415 GND.t618 GND.t46 5.61485
R2416 GND.t46 GND.n413 2.33234
R2417 GND.n423 GND.t46 3.33079
R2418 GND.n431 GND.t867 0.0861948
R2419 GND.t862 GND.n429 0.0863258
R2420 GND.n435 GND.t845 0.0861948
R2421 GND.n434 GND.t842 0.0863258
R2422 GND.n444 GND.t829 0.0861948
R2423 GND.t826 GND.n448 0.0863258
R2424 GND.t788 GND.n449 0.0863258
R2425 GND.t876 GND.n427 0.0863258
R2426 GND.t446 GND.n306 0.231606
R2427 GND.t770 GND.n286 0.118926
R2428 GND.t51 GND.n451 0.150338
R2429 GND.t261 GND.n285 0.231785
R2430 GND.n764 GND.t14 5.61485
R2431 GND.t387 GND.n147 0.774337
R2432 GND.t1392 GND.t14 5.61485
R2433 GND.n180 GND.t14 1.97612
R2434 GND.n458 GND.t14 3.33079
R2435 GND.t14 GND.t1438 5.61485
R2436 GND.n796 GND.t355 4.28621
R2437 GND.n316 GND.t665 19.9891
R2438 GND.t675 GND.n476 4.28621
R2439 GND.t179 GND.n730 4.28621
R2440 GND.t210 GND.t14 4.25119
R2441 GND.t1393 GND.t14 4.25113
R2442 GND.t1557 GND.t234 4.2505
R2443 GND.t577 GND.t578 4.2505
R2444 GND.n295 GND.t46 2.33137
R2445 GND.t1057 GND.t21 4.20468
R2446 GND.t773 GND.t14 4.177
R2447 GND.t779 GND.t1513 4.16717
R2448 GND.n84 GND.t1080 3.24379
R2449 GND.t145 GND.t982 3.50108
R2450 GND.t62 GND.t189 3.50108
R2451 GND.t596 GND.t19 3.50108
R2452 GND.n354 GND.n89 2.33238
R2453 GND.n376 GND.t234 2.31579
R2454 GND.n408 GND.t249 2.31579
R2455 GND.t879 GND.n428 0.0947366
R2456 GND.n382 GND.t1263 0.0893255
R2457 GND.n430 GND.t495 0.433869
R2458 GND.n447 GND.t836 0.0893255
R2459 GND.t947 GND.n402 0.0923917
R2460 GND.t157 GND.t708 2.75379
R2461 GND.t578 GND.n436 1.9918
R2462 GND.t249 GND.n320 1.99317
R2463 GND.n463 GND.t121 0.492596
R2464 GND.n773 GND.t3 2.35714
R2465 GND.n769 GND.t58 2.31175
R2466 GND.n769 GND.t209 2.31175
R2467 GND.n433 GND.t491 0.0933495
R2468 GND.t82 GND.t1203 2.19188
R2469 GND.t46 GND.n726 1.97708
R2470 GND.t5 GND.n389 1.52935
R2471 GND.t46 GND.n417 1.52935
R2472 GND.t46 GND.t358 1.88939
R2473 GND.t14 GND.t601 1.88939
R2474 GND.t249 GND.n405 1.36107
R2475 GND.t234 GND.n801 1.72307
R2476 GND.n511 GND.t19 1.67088
R2477 GND.t217 GND.t21 1.41717
R2478 GND.t14 GND.n456 1.09158
R2479 GND.t249 GND.n494 1.32495
R2480 GND.t157 GND.t158 0.270596
R2481 GND.t871 GND.n432 0.0682891
R2482 GND.t14 GND.n769 1.21529
R2483 GND.n147 GND.t14 0.604781
R2484 GND.n379 GND.t1221 0.0831959
R2485 GND.t446 GND.n308 1.30358
R2486 GND.t890 GND.n21 0.0250765
R2487 GND.t264 GND.t23 1.18416
R2488 GND.t345 GND.t348 1.17726
R2489 GND.t1000 GND.t1006 1.16755
R2490 GND.n82 GND.t1152 0.00994909
R2491 GND.n792 GND.t1 1.09946
R2492 GND.t693 GND.t697 1.07852
R2493 GND.n461 GND.t718 1.11315
R2494 GND.t279 GND.t1094 1.06642
R2495 GND.t136 GND.t139 1.04538
R2496 GND.n9 GND.t1068 0.00788005
R2497 GND.t897 GND.t901 1.0402
R2498 GND.t234 GND.n37 0.375568
R2499 GND.t703 GND.t701 1.02135
R2500 GND.n700 GND.t133 1.01899
R2501 GND.t77 GND.t671 1.01844
R2502 GND.t1010 GND.t77 1.01786
R2503 GND.t119 GND.n792 1.01423
R2504 GND.t569 GND.t279 1.01126
R2505 GND.n287 GND.t55 1.12157
R2506 GND.n21 GND.t108 0.874945
R2507 GND.t689 GND.t693 0.988665
R2508 GND.t37 GND.n37 1.06204
R2509 GND.n303 GND.t14 0.800902
R2510 GND.t1061 GND.n398 0.809808
R2511 GND.t441 GND.n424 0.807673
R2512 GND.t701 GND.t697 0.95865
R2513 GND.n400 GND.t1025 0.0575035
R2514 GND.n401 GND.t42 0.813051
R2515 GND.t169 GND.t171 0.946063
R2516 GND.n411 GND.t55 0.963078
R2517 GND.n406 GND.t253 0.772267
R2518 GND.n393 GND.t33 0.791157
R2519 GND.t122 GND.n321 0.0682542
R2520 GND.t1027 GND.t1025 0.903816
R2521 GND.n329 GND.t1103 0.0639814
R2522 GND.n464 GND.t26 0.765643
R2523 GND.n374 GND.t234 0.754145
R2524 GND.t943 GND.t122 0.895641
R2525 GND.n392 GND.t1119 0.0552535
R2526 GND.n228 GND.t1032 0.877142
R2527 GND.t1000 GND.t136 0.874909
R2528 GND.t557 GND.t1119 0.873601
R2529 GND.t1006 GND.t1010 0.859403
R2530 GND.t1149 GND.t5 0.855188
R2531 GND.t231 GND.n118 100.585
R2532 GND.n147 GND.t261 1.13479
R2533 GND.t689 GND.t687 0.843814
R2534 GND.t359 GND.n700 0.836494
R2535 GND.t188 GND.n581 0.829771
R2536 GND.t26 GND.t678 0.82925
R2537 GND.n560 GND.t718 0.811737
R2538 GND.t5 GND.t83 0.810024
R2539 GND.t177 GND.n456 0.886786
R2540 GND.n462 GND.t715 0.0585935
R2541 GND.t13 GND.n303 0.87229
R2542 GND.t726 GND.n560 0.776686
R2543 GND.t716 GND.t715 0.773104
R2544 GND.t465 GND.t678 0.76562
R2545 GND.t57 GND.n581 0.764008
R2546 GND.n321 GND.t190 0.633077
R2547 GND.n656 GND.t198 0.752358
R2548 GND.t79 GND.n374 0.893494
R2549 GND.n37 GND.t65 0.283473
R2550 GND.t121 GND.n462 0.620226
R2551 GND.n406 GND.t404 0.995656
R2552 GND.t1221 GND.t342 0.714073
R2553 GND.t333 GND.n379 0.581396
R2554 GND.t1032 GND.t42 0.706871
R2555 GND.t519 GND.n329 0.594599
R2556 GND.n656 GND.n228 0.693307
R2557 GND.n626 GND.t21 0.68391
R2558 GND.t21 GND.n6 0.68391
R2559 GND.t249 GND.n70 0.68391
R2560 GND.t14 GND.n69 0.68391
R2561 GND.n848 GND.t234 0.666899
R2562 GND.t5 GND.n2 0.666899
R2563 GND.t5 GND.n1 0.666899
R2564 GND.t46 GND.n10 0.666899
R2565 GND.t46 GND.n12 0.666899
R2566 GND.t46 GND.n13 0.666899
R2567 GND.t14 GND.n67 0.666899
R2568 GND.t14 GND.n66 0.666899
R2569 GND.n506 GND.t14 0.666899
R2570 GND.t249 GND.n411 0.558578
R2571 GND.n424 GND.t897 0.0638689
R2572 GND.n398 GND.t169 0.0640142
R2573 GND.t14 GND.n68 0.655024
R2574 GND.t157 GND.n178 0.655024
R2575 GND.t234 GND.n33 0.649813
R2576 GND.n795 GND.t234 0.649813
R2577 GND.t234 GND.n36 0.649813
R2578 GND.t234 GND.n35 0.649813
R2579 GND.t234 GND.n30 0.649813
R2580 GND.t234 GND.n29 0.649813
R2581 GND.t234 GND.n27 0.649813
R2582 GND.t234 GND.n28 0.649813
R2583 GND.t234 GND.n22 0.649813
R2584 GND.t234 GND.n23 0.649813
R2585 GND.t234 GND.n25 0.649813
R2586 GND.t234 GND.n24 0.649813
R2587 GND.n809 GND.t234 0.649813
R2588 GND.t234 GND.n32 0.649813
R2589 GND.t234 GND.n31 0.649813
R2590 GND.t519 GND.n253 0.649813
R2591 GND.t519 GND.n254 0.649813
R2592 GND.t519 GND.n264 0.649813
R2593 GND.t519 GND.n263 0.649813
R2594 GND.t519 GND.n262 0.649813
R2595 GND.t519 GND.n255 0.649813
R2596 GND.t519 GND.n256 0.649813
R2597 GND.t519 GND.n257 0.649813
R2598 GND.t519 GND.n261 0.649813
R2599 GND.t519 GND.n258 0.649813
R2600 GND.t519 GND.n268 0.649813
R2601 GND.t519 GND.n278 0.649813
R2602 GND.t519 GND.n277 0.649813
R2603 GND.t519 GND.n269 0.649813
R2604 GND.t519 GND.n270 0.649813
R2605 GND.t519 GND.n275 0.649813
R2606 GND.t519 GND.n274 0.649813
R2607 GND.t519 GND.n237 0.649813
R2608 GND.t519 GND.n246 0.649813
R2609 GND.t519 GND.n239 0.649813
R2610 GND.t519 GND.n244 0.649813
R2611 GND.t519 GND.n241 0.649813
R2612 GND.t519 GND.n242 0.649813
R2613 GND.t519 GND.n243 0.649813
R2614 GND.t519 GND.n247 0.649813
R2615 GND.t519 GND.n248 0.649813
R2616 GND.t519 GND.n251 0.649813
R2617 GND.t21 GND.n7 0.649813
R2618 GND.t21 GND.n5 0.649813
R2619 GND.n228 GND.n182 0.649813
R2620 GND.n228 GND.n183 0.649813
R2621 GND.n228 GND.n184 0.649813
R2622 GND.n228 GND.n218 0.649813
R2623 GND.n228 GND.n217 0.649813
R2624 GND.n228 GND.n216 0.649813
R2625 GND.n228 GND.n185 0.649813
R2626 GND.n228 GND.n186 0.649813
R2627 GND.n228 GND.n187 0.649813
R2628 GND.n228 GND.n215 0.649813
R2629 GND.n228 GND.n189 0.649813
R2630 GND.n228 GND.n190 0.649813
R2631 GND.n228 GND.n213 0.649813
R2632 GND.n228 GND.n212 0.649813
R2633 GND.n228 GND.n211 0.649813
R2634 GND.n228 GND.n191 0.649813
R2635 GND.n228 GND.n192 0.649813
R2636 GND.n228 GND.n193 0.649813
R2637 GND.n228 GND.n210 0.649813
R2638 GND.n228 GND.n209 0.649813
R2639 GND.n228 GND.n208 0.649813
R2640 GND.n228 GND.n194 0.649813
R2641 GND.n228 GND.n195 0.649813
R2642 GND.n228 GND.n196 0.649813
R2643 GND.n228 GND.n207 0.649813
R2644 GND.n228 GND.n206 0.649813
R2645 GND.n228 GND.n205 0.649813
R2646 GND.n228 GND.n197 0.649813
R2647 GND.n228 GND.n198 0.649813
R2648 GND.n228 GND.n199 0.649813
R2649 GND.n228 GND.n204 0.649813
R2650 GND.n228 GND.n203 0.649813
R2651 GND.n228 GND.n202 0.649813
R2652 GND.n228 GND.n201 0.649813
R2653 GND.n290 GND.n228 0.0258175
R2654 GND.n228 GND.n225 0.649813
R2655 GND.n228 GND.n226 0.649813
R2656 GND.n228 GND.n227 0.649813
R2657 GND.n228 GND.n224 0.649813
R2658 GND.n228 GND.n223 0.649813
R2659 GND.n228 GND.n220 0.369515
R2660 GND.n228 GND.n221 0.649813
R2661 GND.n788 GND.t249 0.649813
R2662 GND.t249 GND.n78 0.649813
R2663 GND.t249 GND.n77 0.649813
R2664 GND.t249 GND.n76 0.649813
R2665 GND.t249 GND.n74 0.649813
R2666 GND.t249 GND.n75 0.649813
R2667 GND.t249 GND.n79 0.649813
R2668 GND.t249 GND.n71 0.649813
R2669 GND.t249 GND.n72 0.649813
R2670 GND.t46 GND.n20 0.649813
R2671 GND.t46 GND.n16 0.649813
R2672 GND.t46 GND.n19 0.649813
R2673 GND.t46 GND.n17 0.649813
R2674 GND.t46 GND.n18 0.649813
R2675 GND.n723 GND.t46 0.649813
R2676 GND.n727 GND.t46 0.649813
R2677 GND.t46 GND.n15 0.649813
R2678 GND.t46 GND.n14 0.649813
R2679 GND.t578 GND.n48 0.649813
R2680 GND.t578 GND.n49 0.649813
R2681 GND.t578 GND.n39 0.649813
R2682 GND.t578 GND.n40 0.649813
R2683 GND.t578 GND.n41 0.649813
R2684 GND.t578 GND.n43 0.649813
R2685 GND.t578 GND.n42 0.649813
R2686 GND.t578 GND.n47 0.649813
R2687 GND.t578 GND.n46 0.649813
R2688 GND.t578 GND.n44 0.649813
R2689 GND.t578 GND.n45 0.649813
R2690 GND.t578 GND.n56 0.649813
R2691 GND.t578 GND.n55 0.649813
R2692 GND.t578 GND.n53 0.649813
R2693 GND.t578 GND.n54 0.649813
R2694 GND.t578 GND.n52 0.649813
R2695 GND.t578 GND.n57 0.649813
R2696 GND.t578 GND.n60 0.649813
R2697 GND.t578 GND.n59 0.649813
R2698 GND.t578 GND.n58 0.649813
R2699 GND.t578 GND.n62 0.649813
R2700 GND.t578 GND.n61 0.649813
R2701 GND.t578 GND.n63 0.649813
R2702 GND.t578 GND.n64 0.649813
R2703 GND.t578 GND.n65 0.649813
R2704 GND.t578 GND.n51 0.649813
R2705 GND.t157 GND.n153 0.649813
R2706 GND.t157 GND.n154 0.649813
R2707 GND.t157 GND.n172 0.649813
R2708 GND.t157 GND.n156 0.649813
R2709 GND.t157 GND.n170 0.649813
R2710 GND.t157 GND.n158 0.649813
R2711 GND.t157 GND.n168 0.649813
R2712 GND.t157 GND.n160 0.649813
R2713 GND.t157 GND.n161 0.649813
R2714 GND.t157 GND.n162 0.649813
R2715 GND.t157 GND.n166 0.649813
R2716 GND.t157 GND.n165 0.649813
R2717 GND.t157 GND.n164 0.649813
R2718 GND.t157 GND.n163 0.649813
R2719 GND.t157 GND.n173 0.649813
R2720 GND.t157 GND.n174 0.649813
R2721 GND.t157 GND.n177 0.649813
R2722 GND.t234 GND.n34 0.648546
R2723 GND.t249 GND.n73 0.648546
R2724 GND.t46 GND.n11 0.648101
R2725 GND.n713 GND.t46 0.648101
R2726 GND.n8 GND.t539 100.579
R2727 GND.t157 GND.t678 0.643752
R2728 GND.t519 GND.n581 0.643206
R2729 GND.t1032 GND.t1027 0.632767
R2730 GND.t519 GND.n392 0.523746
R2731 GND.t687 GND.n464 0.0557893
R2732 GND.t1103 GND.t348 0.594968
R2733 GND.n228 GND.n400 0.503501
R2734 GND.t911 GND.t321 0.586786
R2735 GND.t182 GND.t1194 0.586786
R2736 GND.n405 GND.t253 0.652632
R2737 GND.n610 GND.t1108 0.553319
R2738 GND.t7 GND.n801 0.549816
R2739 GND.t870 GND.n432 0.450039
R2740 GND.t321 GND.n417 0.0932221
R2741 GND.t1194 GND.n389 0.0932221
R2742 GND.n656 GND.t100 0.511584
R2743 GND.t46 GND.n700 0.509246
R2744 GND.t157 GND.t701 0.504936
R2745 GND.t157 GND.t693 0.504897
R2746 GND.t1 GND.n801 0.498088
R2747 GND.t712 GND.t158 0.49449
R2748 GND.n393 GND.t345 0.0459658
R2749 GND.n401 GND.t139 0.0469627
R2750 GND.n180 GND.t177 0.286417
R2751 GND.t871 GND.t310 0.47154
R2752 GND.n560 GND.t157 0.466058
R2753 GND.t493 GND.t491 0.456136
R2754 GND.t1374 GND.n89 157.976
R2755 GND.n433 GND.t838 0.342687
R2756 GND.t356 GND.n151 1.13511
R2757 GND.t144 GND.n308 0.0511627
R2758 GND.n397 GND.t170 0.509388
R2759 GND.t144 GND.t768 0.406098
R2760 GND.t221 GND.n436 0.493079
R2761 GND.n463 GND.t510 0.291279
R2762 GND.n320 GND.t411 0.0918841
R2763 GND.t225 GND.n359 0.489322
R2764 GND.n228 GND.t671 0.37098
R2765 GND.n461 GND.t157 0.314668
R2766 GND.t40 GND.t634 0.36115
R2767 GND.n710 GND.t447 0.360811
R2768 GND.t85 GND.t1166 0.360811
R2769 GND.t778 GND.n180 0.526885
R2770 GND.t708 GND.t510 0.350665
R2771 GND.n726 GND.t901 0.345252
R2772 GND.n428 GND.t821 0.241971
R2773 GND.t402 GND.n317 0.331253
R2774 GND.t286 GND.t1263 0.344562
R2775 GND.t838 GND.t836 0.344562
R2776 GND.n726 GND.t904 0.344367
R2777 GND.t1224 GND.n380 0.433869
R2778 GND.t815 GND.n442 0.433869
R2779 GND.t812 GND.n441 0.433869
R2780 GND.t809 GND.n440 0.433869
R2781 GND.t806 GND.n439 0.433869
R2782 GND.t803 GND.n438 0.433869
R2783 GND.t800 GND.n437 0.433869
R2784 GND.t794 GND.n445 0.433869
R2785 GND.t668 GND.n443 0.433709
R2786 GND.t947 GND.t949 0.341746
R2787 GND.t1245 GND.t1247 0.341445
R2788 GND.t973 GND.t131 0.341445
R2789 GND.t247 GND.t879 0.339141
R2790 GND.n228 GND.t1010 0.336772
R2791 GND.n376 GND.t1245 0.0924786
R2792 GND.n408 GND.t973 0.0924786
R2793 GND.t125 GND.n402 0.23595
R2794 GND.n443 GND.t815 0.235876
R2795 GND.n381 GND.t1224 0.235729
R2796 GND.n380 GND.t342 0.235729
R2797 GND.t819 GND.n430 0.235729
R2798 GND.n442 GND.t812 0.235729
R2799 GND.n441 GND.t809 0.235729
R2800 GND.n440 GND.t806 0.235729
R2801 GND.n439 GND.t803 0.235729
R2802 GND.n438 GND.t800 0.235729
R2803 GND.n437 GND.t221 0.235729
R2804 GND.n446 GND.t794 0.235729
R2805 GND.n445 GND.t792 0.235729
R2806 GND.t1227 GND.n381 0.422619
R2807 GND.t797 GND.n446 0.422619
R2808 GND.t171 GND.n397 0.232048
R2809 GND.n295 GND.t277 0.13748
R2810 GND.t413 GND.t411 0.325609
R2811 GND.n382 GND.t1227 0.228063
R2812 GND.n447 GND.t797 0.228063
R2813 GND.n228 GND.t1000 0.314875
R2814 GND.n451 GND.t50 0.15112
R2815 GND.n354 GND.t1292 0.0850573
R2816 GND.t15 GND.n764 0.301114
R2817 GND.t369 GND.t367 0.301114
R2818 GND.n38 GND.t222 0.328961
R2819 GND.n772 GND.t9 0.301114
R2820 GND.t618 GND.t97 0.301114
R2821 GND.t319 GND.t908 0.301114
R2822 GND.t375 GND.n412 0.17801
R2823 GND.t89 GND.n627 0.301114
R2824 GND.t352 GND.t937 0.301114
R2825 GND.n335 GND.t1162 0.118323
R2826 GND.t226 GND.t1169 0.301114
R2827 GND.t1180 GND.t1179 0.301114
R2828 GND.t94 GND.t387 0.300775
R2829 GND.n764 GND.t219 0.300775
R2830 GND.t885 GND.t618 0.300775
R2831 GND.t908 GND.t884 0.300775
R2832 GND.t369 GND.n425 0.118193
R2833 GND.t371 GND.t180 0.300775
R2834 GND.t634 GND.n230 0.118193
R2835 GND.n324 GND.t89 0.118193
R2836 GND.t450 GND.n151 1.06414
R2837 GND.t515 GND.t1392 0.300775
R2838 GND.t1438 GND.t59 0.300775
R2839 GND.t773 GND.t763 0.299894
R2840 GND.t656 GND.t773 0.286144
R2841 GND.t1071 GND.n144 0.28899
R2842 GND.t277 GND.t47 0.272116
R2843 GND.t519 GND.t279 0.270519
R2844 GND.n149 GND.t63 0.160066
R2845 GND.t708 GND.t703 0.252657
R2846 GND.n457 GND.t784 0.119605
R2847 GND.t219 GND.n285 0.291785
R2848 GND.n304 GND.t515 0.119605
R2849 GND.t48 GND.t450 0.241078
R2850 GND.n288 GND.t606 0.360183
R2851 GND.t97 GND.n418 0.119605
R2852 GND.t173 GND.n306 0.291652
R2853 GND.t9 GND.n287 0.981668
R2854 GND.n523 GND.t173 0.241078
R2855 GND.n418 GND.t485 0.360183
R2856 GND.t884 GND.n421 0.119605
R2857 GND.t911 GND.n420 0.119605
R2858 GND.n426 GND.t366 0.119605
R2859 GND.t377 GND.n281 0.119605
R2860 GND.t375 GND.t377 0.241078
R2861 GND.t379 GND.t272 0.241078
R2862 GND.n38 GND.t303 0.0979828
R2863 GND.t606 GND.n327 0.291652
R2864 GND.n396 GND.t622 0.360183
R2865 GND.t152 GND.n395 0.119605
R2866 GND.n627 GND.t152 0.241078
R2867 GND.t1094 GND.t35 0.241078
R2868 GND.t20 GND.n150 0.360183
R2869 GND.t776 GND.n453 0.119605
R2870 GND.n322 GND.t352 0.119605
R2871 GND.n522 GND.t51 0.240825
R2872 GND.n772 GND.t592 0.240486
R2873 GND.t160 GND.t602 0.228657
R2874 GND.t867 GND.t270 0.227075
R2875 GND.t1202 GND.n391 0.135296
R2876 GND.n343 GND.t1235 0.0896992
R2877 GND.t845 GND.t116 0.227075
R2878 GND.t918 GND.t920 0.227075
R2879 GND.t666 GND.t976 0.227075
R2880 GND.t953 GND.t951 0.227075
R2881 GND.t1267 GND.t1269 0.226736
R2882 GND.t1274 GND.t1272 0.226736
R2883 GND.t1277 GND.t1279 0.226736
R2884 GND.t1284 GND.t1282 0.226736
R2885 GND.t1287 GND.t1289 0.226736
R2886 GND.t1240 GND.t1242 0.226736
R2887 GND.t181 GND.n296 0.135098
R2888 GND.n297 GND.t1186 0.0895683
R2889 GND.t1157 GND.n280 0.135098
R2890 GND.t968 GND.t970 0.226736
R2891 GND.t876 GND.t247 0.226736
R2892 GND.t862 GND.t305 0.226736
R2893 GND.t315 GND.t842 0.226736
R2894 GND.t788 GND.t790 0.226736
R2895 GND.t397 GND.t781 0.226736
R2896 GND.t1299 GND.t1297 0.226736
R2897 GND.t1302 GND.t1304 0.226736
R2898 GND.t1309 GND.t1307 0.226736
R2899 GND.t1312 GND.t1314 0.226736
R2900 GND.t1318 GND.t1320 0.226736
R2901 GND.t1325 GND.t1323 0.226736
R2902 GND.t1328 GND.t1330 0.226736
R2903 GND.t1335 GND.t1333 0.226736
R2904 GND.t1338 GND.t1340 0.226736
R2905 GND.t1345 GND.t1343 0.226736
R2906 GND.t1348 GND.t1350 0.226736
R2907 GND.t1355 GND.t1353 0.226736
R2908 GND.t1358 GND.t1360 0.226736
R2909 GND.t1365 GND.t1363 0.226736
R2910 GND.t1368 GND.t1370 0.226736
R2911 GND.n384 GND.t354 0.312561
R2912 GND.t333 GND.t1252 0.226736
R2913 GND.t292 GND.t1249 0.226736
R2914 GND.t980 GND.t146 0.226736
R2915 GND.t826 GND.t439 0.226736
R2916 GND.n423 GND.t441 0.312561
R2917 GND.n399 GND.t266 0.135098
R2918 GND.n289 GND.t1065 0.219767
R2919 GND.t1375 GND.t1373 0.226736
R2920 GND.n299 GND.t1180 0.0895683
R2921 GND.t780 GND.t1438 0.224575
R2922 GND.t792 GND.t829 0.224575
R2923 GND.t229 GND.n138 0.310061
R2924 GND.t1392 GND.t674 0.222075
R2925 GND.t50 GND.n523 0.220981
R2926 GND.t1230 GND.n384 0.130189
R2927 GND.n138 GND.t228 0.130189
R2928 GND.t1061 GND.n399 0.307393
R2929 GND.n356 GND.t1302 0.0863258
R2930 GND.n358 GND.t1312 0.0863258
R2931 GND.n360 GND.t1318 0.0863258
R2932 GND.n362 GND.t1328 0.0863258
R2933 GND.n364 GND.t1338 0.0863258
R2934 GND.n366 GND.t1348 0.0863258
R2935 GND.n368 GND.t1358 0.0863258
R2936 GND.n370 GND.t1368 0.0863258
R2937 GND.t1266 GND.n349 0.130189
R2938 GND.n351 GND.t1277 0.0863258
R2939 GND.n353 GND.t1287 0.0863258
R2940 GND.t1282 GND.n352 0.0863258
R2941 GND.t1272 GND.n350 0.0863258
R2942 GND.t37 GND.n373 0.130189
R2943 GND.n378 GND.t162 0.130189
R2944 GND.n377 GND.t1249 0.0863258
R2945 GND.n410 GND.t980 0.0863258
R2946 GND.t781 GND.n458 0.0863258
R2947 GND.t787 GND.n449 0.130189
R2948 GND.t825 GND.n448 0.130189
R2949 GND.t668 GND.n429 0.130189
R2950 GND.t310 GND.n427 0.130189
R2951 GND.n434 GND.t493 0.130189
R2952 GND.t770 GND.t214 0.218325
R2953 GND.t968 GND.n407 0.0863258
R2954 GND.t1156 GND.t1155 0.218325
R2955 GND.t1186 GND.t1185 0.218325
R2956 GND.t1191 GND.t39 0.218325
R2957 GND.t1373 GND.n371 0.0863258
R2958 GND.t1363 GND.n369 0.0863258
R2959 GND.t1353 GND.n367 0.0863258
R2960 GND.t1343 GND.n365 0.0863258
R2961 GND.t1333 GND.n363 0.0863258
R2962 GND.t1323 GND.n361 0.0863258
R2963 GND.t1307 GND.n357 0.0863258
R2964 GND.t1297 GND.n355 0.0863258
R2965 GND.t1200 GND.t1199 0.217986
R2966 GND.n431 GND.t495 0.129991
R2967 GND.t114 GND.n435 0.129991
R2968 GND.n422 GND.t918 0.0861948
R2969 GND.t391 GND.n413 0.216133
R2970 GND.t195 GND.n444 0.129991
R2971 GND.n409 GND.t976 0.0861948
R2972 GND.t951 GND.n403 0.0861948
R2973 GND.t1161 GND.t1162 0.217986
R2974 GND.t448 GND.n710 0.212986
R2975 GND.t1169 GND.t1168 0.206736
R2976 GND.n342 GND.t419 0.180789
R2977 GND.t1183 GND.n388 0.24604
R2978 GND.n338 GND.t1176 0.299894
R2979 GND.t1172 GND.t223 0.24604
R2980 GND.n152 GND.t1165 0.358103
R2981 GND.t508 GND.n466 0.180789
R2982 GND.t784 GND.n459 0.24604
R2983 GND.t776 GND.n452 0.251827
R2984 GND.t764 GND.n286 0.119639
R2985 GND.t47 GND.n419 0.0605362
R2986 GND.t1073 GND.t418 0.180789
R2987 GND.t1494 GND.t213 0.180789
R2988 GND.t213 GND.n307 0.0605362
R2989 GND.t766 GND.t767 0.173289
R2990 GND.n339 GND.t1183 0.083315
R2991 GND.n336 GND.t226 0.083315
R2992 GND.t33 GND.t35 0.167039
R2993 GND.t90 GND.t1076 0.167039
R2994 GND.t1074 GND.n326 0.0836055
R2995 GND.n337 GND.t1172 0.083315
R2996 GND.t909 GND.n284 0.0836055
R2997 GND.t1072 GND.t607 0.164539
R2998 GND.t1178 GND.t1177 0.164539
R2999 GND.t39 GND.n300 0.0823774
R3000 GND.n230 GND.t1074 0.339353
R3001 GND.n305 GND.t15 0.080867
R3002 GND.t625 GND.t909 0.162039
R3003 GND.n372 GND.t1378 0.0647427
R3004 GND.t1205 GND.n331 0.07903
R3005 GND.n332 GND.t182 0.07903
R3006 GND.t419 GND.n333 0.07903
R3007 GND.n334 GND.t1178 0.0793054
R3008 GND.t514 GND.n304 0.272394
R3009 GND.t337 GND.t483 0.153289
R3010 GND.t1421 GND.t272 0.150789
R3011 GND.t1413 GND.t1071 0.150789
R3012 GND.t1235 GND.t7 0.150486
R3013 GND.t170 GND.n325 0.0735143
R3014 GND.t151 GND.t337 0.147039
R3015 GND.t485 GND.n301 0.0735143
R3016 GND.t356 GND.t1057 0.139432
R3017 GND.t1294 GND.t1292 0.135506
R3018 GND.t519 GND.n610 0.124021
R3019 GND.t1159 GND.t517 0.1205
R3020 GND.n9 GND.t430 0.113327
R3021 GND.t602 GND.n146 0.13248
R3022 GND.n610 GND.t264 0.117284
R3023 GND.t366 GND.t133 0.115789
R3024 GND.n298 GND.t1207 0.102285
R3025 GND.n390 GND.t1205 0.251827
R3026 GND.t1164 GND.t1163 0.197416
R3027 GND.t1189 GND.n342 0.10675
R3028 GND.t674 GND.n452 0.0362711
R3029 GND.t214 GND.n450 0.0354445
R3030 GND.t1161 GND.n385 0.0354445
R3031 GND.t1065 GND.t430 0.10175
R3032 GND.t1176 GND.n387 0.0657511
R3033 GND.t418 GND.n394 0.0657511
R3034 GND.t517 GND.n386 0.0657511
R3035 GND.n388 GND.t1182 0.0333775
R3036 GND.t1168 GND.n231 0.179832
R3037 GND.n466 GND.n109 0.090789
R3038 GND.t1413 GND.n330 0.209894
R3039 GND.t1159 GND.n109 0.0905
R3040 GND.t413 GND.n404 0.158232
R3041 GND.t223 GND.t1170 0.118377
R3042 GND.t295 GND.n522 0.0905
R3043 GND.t1233 GND.t119 0.08675
R3044 GND.n454 GND.t514 0.0296542
R3045 GND.t1269 GND.t1271 0.0855
R3046 GND.t1276 GND.t1274 0.0855
R3047 GND.t1279 GND.t1281 0.0855
R3048 GND.t1286 GND.t1284 0.0855
R3049 GND.t1289 GND.t1291 0.0855
R3050 GND.t162 GND.t292 0.0855
R3051 GND.t1204 GND.t1202 0.0855
R3052 GND.t1199 GND.t1197 0.0855
R3053 GND.t181 GND.t1193 0.0855
R3054 GND.t1188 GND.t1187 0.0855
R3055 GND.t1185 GND.t1184 0.0855
R3056 GND.t1182 GND.t1181 0.0855
R3057 GND.t228 GND.t470 0.0855
R3058 GND.t1158 GND.t1157 0.0855
R3059 GND.n82 GND.t1155 0.0772892
R3060 GND.t266 GND.t1064 0.0855
R3061 GND.t970 GND.t972 0.0855
R3062 GND.t967 GND.t402 0.0855
R3063 GND.t190 GND.t125 0.0855
R3064 GND.t104 GND.t108 0.0855
R3065 GND.t307 GND.t923 0.0855
R3066 GND.t920 GND.t391 0.0855
R3067 GND.t917 GND.t915 0.0855
R3068 GND.t305 GND.t819 0.0855
R3069 GND.t114 GND.t315 0.0855
R3070 GND.t439 GND.t195 0.0855
R3071 GND.t790 GND.t825 0.0855
R3072 GND.t397 GND.t68 0.0855
R3073 GND.t1294 GND.t1296 0.0855
R3074 GND.t1301 GND.t1299 0.0855
R3075 GND.t1304 GND.t1306 0.0855
R3076 GND.t1311 GND.t1309 0.0855
R3077 GND.t1320 GND.t1322 0.0855
R3078 GND.t1327 GND.t1325 0.0855
R3079 GND.t1330 GND.t1332 0.0855
R3080 GND.t1337 GND.t1335 0.0855
R3081 GND.t1340 GND.t1342 0.0855
R3082 GND.t1347 GND.t1345 0.0855
R3083 GND.t1350 GND.t1352 0.0855
R3084 GND.t1357 GND.t1355 0.0855
R3085 GND.t1360 GND.t1362 0.0855
R3086 GND.t1367 GND.t1365 0.0855
R3087 GND.t1370 GND.t1372 0.0855
R3088 GND.t666 GND.t979 0.0855
R3089 GND.t270 GND.t870 0.0855
R3090 GND.t1242 GND.t644 0.07425
R3091 GND.t362 GND.t400 0.07425
R3092 GND.t469 GND.t1206 0.07425
R3093 GND.t1079 GND.t90 0.07425
R3094 GND.t1314 GND.t1316 0.07425
R3095 GND.t1377 GND.t1375 0.07425
R3096 GND.t354 GND.n344 0.0377157
R3097 GND.t146 GND.t106 0.07425
R3098 GND.t256 GND.t956 0.05925
R3099 GND.n328 GND.t4 0.0108594
R3100 GND.t557 GND.t569 0.0305
R3101 GND.t1421 GND.t273 0.0305
R3102 GND.n307 GND.t295 0.150486
R3103 GND.t157 GND.n179 0.0271432
R3104 GND.t519 GND.n266 0.0258175
R3105 GND.t519 GND.n265 0.0258175
R3106 GND.t519 GND.n260 0.0258175
R3107 GND.t519 GND.n259 0.0258175
R3108 GND.t519 GND.n267 0.0258175
R3109 GND.t519 GND.n279 0.0258175
R3110 GND.t519 GND.n276 0.0258175
R3111 GND.t519 GND.n271 0.0258175
R3112 GND.t519 GND.n273 0.0258175
R3113 GND.t519 GND.n272 0.0258175
R3114 GND.t519 GND.n238 0.0258175
R3115 GND.t519 GND.n245 0.0258175
R3116 GND.t519 GND.n240 0.0258175
R3117 GND.t519 GND.n250 0.0258175
R3118 GND.t519 GND.n249 0.0258175
R3119 GND.n228 GND.n219 0.0258175
R3120 GND.n228 GND.n188 0.0258175
R3121 GND.n228 GND.n214 0.0258175
R3122 GND.n228 GND.n200 0.0258175
R3123 GND.t157 GND.n171 0.0258175
R3124 GND.t157 GND.n157 0.0258175
R3125 GND.t157 GND.n169 0.0258175
R3126 GND.t157 GND.n159 0.0258175
R3127 GND.t157 GND.n167 0.0258175
R3128 GND.t157 GND.n176 0.0258175
R3129 GND.t157 GND.n175 0.0258175
R3130 GND.n89 GND.t1344 157.976
R3131 GND.t1319 GND.n89 157.976
R3132 GND.t519 GND.n252 0.0184357
R3133 GND.t1303 GND.n89 157.976
R3134 GND.n89 GND.t1293 157.976
R3135 GND.t157 GND.n155 0.0322654
R3136 GND.n228 GND.n222 0.0197788
R3137 GND.n89 GND.t1273 157.976
R3138 GND.n89 GND.n359 2.36742
R3139 GND.t5 GND.n0 1.3145
R3140 GND.n792 GND.t234 1.24726
R3141 GND.t21 GND.n84 1.13293
R3142 GND.n308 GND.t14 1.09698
R3143 GND.t249 GND.n287 1.09235
R3144 GND.n86 GND.t578 1.08657
R3145 GND.n21 GND.t46 1.0852
R3146 _225_.A.n0 _225_.A 38.4217
R3147 _225_.A.n2 _225_.A 26.4999
R3148 _225_.A.n5 _225_.A.n4 21.1685
R3149 _225_.A.n6 _225_.A.n5 20.2672
R3150 _225_.A.n6 _225_.A 20.2267
R3151 _225_.A _225_.A.n6 19.6901
R3152 _225_.A.n1 _225_.A.n0 18.1221
R3153 _225_.A.n1 _225_.A 18.0022
R3154 _225_.A _225_.A.t0 17.0317
R3155 _225_.A _225_.A.t4 15.0215
R3156 _225_.A _225_.A.t2 15.0022
R3157 _225_.A _225_.A.t3 15.0005
R3158 _225_.A _225_.A.t1 15.0005
R3159 _225_.A.n3 _225_.A.n2 12.9135
R3160 _225_.A.n4 _225_.A.n3 12.6959
R3161 _225_.A.n4 _225_.A 10.1079
R3162 _225_.A.n5 _225_.A 9.90553
R3163 _225_.A.n3 _225_.A 9.42457
R3164 _225_.A.n0 _225_.A 9.0005
R3165 _225_.A.t0 _225_.A 8.62605
R3166 _225_.A.n2 _225_.A.n1 1.0565
C3495 freq_out GND 0.66055f
C3496 sdata GND 0.69311f
C3497 sclk GND 1.14379f
C3498 en GND 0.40001f
C3499 freq_in GND 2.02382f
C3500 rst GND 0.56777f
C3501 VDD GND 0.33673p
C3502 a_17120_3270# GND 0.08286f
C3503 a_8288_3270# GND 0.04396f
C3504 a_11475_4248# GND 0.01118f ; **FLOATING
C3505 a_10769_4258# GND 0.14626f ; **FLOATING
C3506 a_8288_3986# GND 0.04109f
C3507 a_8557_4248# GND 0.28261f ; **FLOATING
C3508 _145_.B1 GND 0.32633f ; **FLOATING
C3509 _143_.Y GND 0.19137f ; **FLOATING
C3510 a_6810_3863# GND 0.14843f ; **FLOATING
C3511 a_6095_4270# GND 0.082f ; **FLOATING
C3512 a_6060_4166# GND 0.19091f ; **FLOATING
C3513 a_3793_4261# GND 0.05838f ; **FLOATING
C3514 a_4554_3900# GND 0.18939f ; **FLOATING
C3515 a_3887_4261# GND 0.27244f ; **FLOATING
C3516 a_4144_4142# GND 0.14731f ; **FLOATING
C3517 a_3147_3911# GND 0.19443f ; **FLOATING
C3518 a_2916_4325# GND 0.03671f ; **FLOATING
C3519 a_2240_3986# GND 0.04201f
C3520 a_3045_3911# GND 0.42574f ; **FLOATING
C3521 a_2628_3904# GND 0.89884f ; **FLOATING
C3522 a_2602_3868# GND 0.08449f ; **FLOATING
C3523 a_2342_4338# GND 0.12154f ; **FLOATING
C3524 a_16736_4782# GND 0.04382f
C3525 a_16840_4688# GND 0.17342f ; **FLOATING
C3526 a_14624_4782# GND 0.04283f
C3527 a_13376_4782# GND 0.04229f
C3528 a_12128_4782# GND 0.04481f
C3529 _147_.B1 GND 0.36722f ; **FLOATING
C3530 a_10513_4727# GND 0.05791f ; **FLOATING
C3531 a_9636_4663# GND 0.03671f ; **FLOATING
C3532 a_13649_4704# GND 0.146f ; **FLOATING
C3533 a_12401_4704# GND 0.14152f ; **FLOATING
C3534 a_11661_4696# GND 0.09299f ; **FLOATING
C3535 a_11274_4948# GND 0.17713f ; **FLOATING
C3536 a_10864_4870# GND 0.14361f ; **FLOATING
C3537 a_10607_4727# GND 0.26511f ; **FLOATING
C3538 a_9867_4772# GND 0.1962f ; **FLOATING
C3539 a_9765_4629# GND 0.44009f ; **FLOATING
C3540 a_9348_4968# GND 0.89626f ; **FLOATING
C3541 a_9062_4650# GND 0.12351f ; **FLOATING
C3542 a_9322_4873# GND 0.0841f ; **FLOATING
C3543 _252_.RESET_B GND 0.52725f ; **FLOATING
C3544 _136_.B GND 0.64808f ; **FLOATING
C3545 a_7633_4727# GND 0.05788f ; **FLOATING
C3546 a_6756_4663# GND 0.03681f ; **FLOATING
C3547 a_8394_4948# GND 0.17808f ; **FLOATING
C3548 a_7984_4870# GND 0.14473f ; **FLOATING
C3549 a_7727_4727# GND 0.26676f ; **FLOATING
C3550 a_6987_4772# GND 0.19595f ; **FLOATING
C3551 a_6885_4629# GND 0.42619f ; **FLOATING
C3552 a_6468_4968# GND 0.90184f ; **FLOATING
C3553 a_6182_4650# GND 0.11459f ; **FLOATING
C3554 _210_.Y GND 0.29645f ; **FLOATING
C3555 a_6442_4873# GND 0.08505f ; **FLOATING
C3556 _224_.Y GND 0.57717f ; **FLOATING
C3557 a_5792_4782# GND 0.03677f
C3558 a_5608_4782# GND 0.08107f
C3559 a_4465_4727# GND 0.05864f ; **FLOATING
C3560 a_3588_4663# GND 0.03673f ; **FLOATING
C3561 a_5226_4948# GND 0.20404f ; **FLOATING
C3562 a_4816_4870# GND 0.1724f ; **FLOATING
C3563 a_4559_4727# GND 0.28054f ; **FLOATING
C3564 a_3819_4772# GND 0.19687f ; **FLOATING
C3565 a_3717_4629# GND 0.44224f ; **FLOATING
C3566 a_3300_4968# GND 0.90099f ; **FLOATING
C3567 a_3014_4650# GND 0.10989f ; **FLOATING
C3568 a_3274_4873# GND 0.08182f ; **FLOATING
C3569 _243_.D GND 0.28376f ; **FLOATING
C3570 a_2398_4654# GND 0.31983f ; **FLOATING
C3571 a_2075_4692# GND 0.12367f ; **FLOATING
C3572 _242_.RESET_B GND 0.53698f ; **FLOATING
C3573 _243_.RESET_B GND 1.00982f ; **FLOATING
C3574 a_1376_4782# GND 0.03616f
C3575 a_1192_4782# GND 0.11475f
C3576 a_17032_5498# GND 0.12093f
C3577 a_15889_5773# GND 0.05799f ; **FLOATING
C3578 a_16650_5412# GND 0.17848f ; **FLOATING
C3579 a_15983_5773# GND 0.26399f ; **FLOATING
C3580 a_16240_5654# GND 0.14326f ; **FLOATING
C3581 a_15243_5423# GND 0.19769f ; **FLOATING
C3582 a_15012_5837# GND 0.03671f ; **FLOATING
C3583 a_15141_5423# GND 0.43986f ; **FLOATING
C3584 a_14724_5416# GND 0.89766f ; **FLOATING
C3585 a_14698_5380# GND 0.08245f ; **FLOATING
C3586 a_14438_5850# GND 0.12265f ; **FLOATING
C3587 _226_.Y GND 0.56434f ; **FLOATING
C3588 _151_.X GND 0.39296f ; **FLOATING
C3589 a_13775_5782# GND 0.08113f ; **FLOATING
C3590 a_12712_5498# GND 0.08463f
C3591 a_13740_5678# GND 0.18225f ; **FLOATING
C3592 a_13073_5770# GND 0.1397f ; **FLOATING
C3593 _157_.B GND 0.35014f ; **FLOATING
C3594 _147_.Y GND 0.73185f ; **FLOATING
C3595 a_12128_5498# GND 0.05291f
C3596 a_12237_5760# GND 0.10541f ; **FLOATING
C3597 _147_.A1 GND 0.53563f ; **FLOATING
C3598 a_10799_5782# GND 0.08109f ; **FLOATING
C3599 a_10592_5498# GND 0.05195f
C3600 _139_.X GND 0.60219f ; **FLOATING
C3601 a_10764_5678# GND 0.19172f ; **FLOATING
C3602 _144_.B GND 0.68439f ; **FLOATING
C3603 a_8538_5375# GND 0.14391f ; **FLOATING
C3604 _252_.D GND 0.17364f ; **FLOATING
C3605 _138_.Y GND 0.78604f ; **FLOATING
C3606 a_8021_5782# GND 0.08113f ; **FLOATING
C3607 a_7872_5451# GND 0.18424f ; **FLOATING
C3608 a_7616_5498# GND 0.04565f
C3609 _145_.A2 GND 0.5133f ; **FLOATING
C3610 _143_.A GND 0.93614f ; **FLOATING
C3611 a_6656_5498# GND 0.04295f
C3612 _210_.B GND 0.5939f ; **FLOATING
C3613 a_6747_5468# GND 0.17052f ; **FLOATING
C3614 a_4465_5773# GND 0.05986f ; **FLOATING
C3615 a_5226_5412# GND 0.22027f ; **FLOATING
C3616 a_4559_5773# GND 0.28983f ; **FLOATING
C3617 a_4816_5654# GND 0.17371f ; **FLOATING
C3618 a_3819_5423# GND 0.19812f ; **FLOATING
C3619 a_3588_5837# GND 0.03671f ; **FLOATING
C3620 a_3717_5423# GND 0.43784f ; **FLOATING
C3621 a_3300_5416# GND 0.89931f ; **FLOATING
C3622 a_3274_5380# GND 0.08181f ; **FLOATING
C3623 a_3014_5850# GND 0.10996f ; **FLOATING
C3624 _242_.D GND 0.16194f ; **FLOATING
C3625 a_1864_5498# GND 0.09583f
C3626 a_2398_5782# GND 0.32133f ; **FLOATING
C3627 a_2075_5468# GND 0.14359f ; **FLOATING
C3628 _210_.A GND 1.016f ; **FLOATING
C3629 a_17120_6294# GND 0.08143f
C3630 a_13121_6188# GND 0.01151f ; **FLOATING
C3631 a_12800_6294# GND 0.05309f
C3632 _148_.X GND 0.65117f ; **FLOATING
C3633 _149_.A GND 1.13949f ; **FLOATING
C3634 _152_.X GND 0.41218f ; **FLOATING
C3635 _244_.RESET_B GND 0.7171f ; **FLOATING
C3636 _244_.D GND 0.26785f ; **FLOATING
C3637 a_2048_6294# GND 0.03963f
C3638 a_1864_6294# GND 0.09207f
C3639 a_2494_6166# GND 0.32819f ; **FLOATING
C3640 a_2171_6204# GND 0.14735f ; **FLOATING
C3641 _243_.Q GND 2.0735f ; **FLOATING
C3642 a_17120_7010# GND 0.07523f
C3643 a_16936_7010# GND 0.09304f
C3644 a_12904_7010# GND 0.08623f
C3645 a_13184_7183# GND 0.11594f ; **FLOATING
C3646 a_12328_7010# GND 0.09658f
C3647 a_3956_6888# GND 1.57549f ; **FLOATING
C3648 a_17120_7806# GND 0.07483f
C3649 a_16936_7806# GND 0.09151f
C3650 a_15776_7806# GND 0.05413f
C3651 a_13973_7678# GND 0.0817f ; **FLOATING
C3652 a_15980_7638# GND 0.16755f ; **FLOATING
C3653 a_13824_7989# GND 0.19466f ; **FLOATING
C3654 _160_.B GND 0.66367f ; **FLOATING
C3655 a_13073_7728# GND 0.14459f ; **FLOATING
C3656 _162_.Y GND 0.31913f ; **FLOATING
C3657 a_12032_7806# GND 0.05373f
C3658 a_10901_7678# GND 0.08189f ; **FLOATING
C3659 a_10408_7806# GND 0.09874f
C3660 a_9466_7678# GND 0.01001f ; **FLOATING
C3661 a_12215_7664# GND 0.28554f ; **FLOATING
C3662 a_10752_7989# GND 0.1949f ; **FLOATING
C3663 a_9248_7806# GND 0.05262f
C3664 _154_.X GND 0.85102f ; **FLOATING
C3665 a_7712_7806# GND 0.05396f
C3666 a_7985_7728# GND 0.15259f ; **FLOATING
C3667 _148_.A GND 2.45358f ; **FLOATING
C3668 a_2232_7868# GND 0.15529f ; **FLOATING
C3669 a_1952_7806# GND 0.0448f
C3670 _125_.A1 GND 0.89545f ; **FLOATING
C3671 a_2126_7864# GND 0.32738f ; **FLOATING
C3672 a_1192_7712# GND 0.20838f ; **FLOATING
C3673 a_17120_8522# GND 0.08024f
C3674 _166_.A GND 1.12823f ; **FLOATING
C3675 a_15985_8797# GND 0.05794f ; **FLOATING
C3676 a_16746_8436# GND 0.18066f ; **FLOATING
C3677 a_16079_8797# GND 0.26372f ; **FLOATING
C3678 a_16336_8678# GND 0.1443f ; **FLOATING
C3679 a_15339_8447# GND 0.19772f ; **FLOATING
C3680 a_15108_8861# GND 0.03692f ; **FLOATING
C3681 a_15237_8447# GND 0.42511f ; **FLOATING
C3682 a_14820_8440# GND 0.89779f ; **FLOATING
C3683 a_14794_8404# GND 0.08539f ; **FLOATING
C3684 a_14534_8874# GND 0.11492f ; **FLOATING
C3685 a_14144_8522# GND 0.0433f
C3686 _227_.Y GND 0.62425f ; **FLOATING
C3687 _159_.Y GND 0.21763f ; **FLOATING
C3688 a_13505_8784# GND 0.01136f ; **FLOATING
C3689 _158_.Y GND 0.42568f ; **FLOATING
C3690 a_13184_8522# GND 0.03626f
C3691 a_13000_8522# GND 0.07587f
C3692 _151_.B GND 1.07448f ; **FLOATING
C3693 _157_.Y GND 0.52876f ; **FLOATING
C3694 _161_.Y GND 0.17319f ; **FLOATING
C3695 a_12512_8522# GND 0.0362f
C3696 a_12328_8522# GND 0.08f
C3697 a_11974_8436# GND 0.01577f ; **FLOATING
C3698 _153_.Y GND 0.77113f ; **FLOATING
C3699 _162_.B GND 1.0548f ; **FLOATING
C3700 a_12110_8784# GND 0.01081f ; **FLOATING
C3701 a_10989_8784# GND 0.22997f ; **FLOATING
C3702 a_10784_8522# GND 0.04429f
C3703 a_11731_8698# GND 0.23985f ; **FLOATING
C3704 _164_.B1 GND 0.47231f ; **FLOATING
C3705 _145_.X GND 2.43201f ; **FLOATING
C3706 _160_.X GND 0.75284f ; **FLOATING
C3707 a_9928_8522# GND 0.08454f
C3708 _170_.Y GND 0.14547f ; **FLOATING
C3709 a_7634_8802# GND 0.01188f ; **FLOATING
C3710 a_8488_8436# GND 0.16963f ; **FLOATING
C3711 a_8014_8492# GND 0.14352f ; **FLOATING
C3712 a_6677_8806# GND 0.08169f ; **FLOATING
C3713 a_6528_8475# GND 0.19256f ; **FLOATING
C3714 a_6184_8522# GND 0.10159f
C3715 a_5242_8806# GND 0.01276f ; **FLOATING
C3716 a_3601_8797# GND 0.058f ; **FLOATING
C3717 a_4362_8436# GND 0.18815f ; **FLOATING
C3718 a_3695_8797# GND 0.26603f ; **FLOATING
C3719 a_3952_8678# GND 0.14495f ; **FLOATING
C3720 a_2955_8447# GND 0.19706f ; **FLOATING
C3721 a_2724_8861# GND 0.03692f ; **FLOATING
C3722 a_2853_8447# GND 0.42614f ; **FLOATING
C3723 a_2436_8440# GND 0.89703f ; **FLOATING
C3724 a_2410_8404# GND 0.08392f ; **FLOATING
C3725 a_2150_8874# GND 0.11278f ; **FLOATING
C3726 _218_.Y GND 0.59972f ; **FLOATING
C3727 _122_.X GND 0.17905f ; **FLOATING
C3728 a_17120_9318# GND 0.08f
C3729 a_15985_9263# GND 0.05795f ; **FLOATING
C3730 a_15108_9199# GND 0.03671f ; **FLOATING
C3731 a_16746_9484# GND 0.17927f ; **FLOATING
C3732 a_16336_9406# GND 0.14519f ; **FLOATING
C3733 a_16079_9263# GND 0.26263f ; **FLOATING
C3734 a_15339_9308# GND 0.19553f ; **FLOATING
C3735 a_15237_9165# GND 0.42374f ; **FLOATING
C3736 a_14820_9504# GND 0.8961f ; **FLOATING
C3737 a_14534_9186# GND 0.11222f ; **FLOATING
C3738 a_14794_9409# GND 0.08292f ; **FLOATING
C3739 _213_.Y GND 0.20725f ; **FLOATING
C3740 a_14056_9318# GND 0.08592f
C3741 a_11185_9263# GND 0.0579f ; **FLOATING
C3742 a_10308_9199# GND 0.03671f ; **FLOATING
C3743 a_11946_9484# GND 0.18618f ; **FLOATING
C3744 a_11536_9406# GND 0.1472f ; **FLOATING
C3745 a_11279_9263# GND 0.26533f ; **FLOATING
C3746 a_9269_9190# GND 0.08105f ; **FLOATING
C3747 a_8705_9212# GND 0.01137f ; **FLOATING
C3748 a_10539_9308# GND 0.19456f ; **FLOATING
C3749 a_10437_9165# GND 0.43989f ; **FLOATING
C3750 a_10020_9504# GND 0.89935f ; **FLOATING
C3751 a_9734_9186# GND 0.11222f ; **FLOATING
C3752 _228_.Y GND 0.64377f ; **FLOATING
C3753 a_9994_9409# GND 0.0828f ; **FLOATING
C3754 _172_.Y GND 0.19302f ; **FLOATING
C3755 a_7841_9212# GND 0.01135f ; **FLOATING
C3756 a_7520_9318# GND 0.03769f
C3757 a_7336_9318# GND 0.07691f
C3758 a_6962_9194# GND 0.01187f ; **FLOATING
C3759 a_6483_9212# GND 0.01139f ; **FLOATING
C3760 a_6106_9190# GND 0.01019f ; **FLOATING
C3761 a_9120_9501# GND 0.18587f ; **FLOATING
C3762 _180_.X GND 0.4571f ; **FLOATING
C3763 _170_.B GND 0.53357f ; **FLOATING
C3764 _165_.Y GND 0.37996f ; **FLOATING
C3765 _168_.Y GND 0.47964f ; **FLOATING
C3766 a_5800_9318# GND 0.08394f
C3767 a_4928_9318# GND 0.04594f
C3768 a_4744_9318# GND 0.08188f
C3769 a_3601_9263# GND 0.05799f ; **FLOATING
C3770 a_2724_9199# GND 0.03671f ; **FLOATING
C3771 _168_.A GND 0.9331f ; **FLOATING
C3772 _168_.B GND 0.61457f ; **FLOATING
C3773 a_5201_9240# GND 0.16955f ; **FLOATING
C3774 _136_.A GND 3.22587f ; **FLOATING
C3775 a_4362_9484# GND 0.18077f ; **FLOATING
C3776 a_3952_9406# GND 0.14639f ; **FLOATING
C3777 a_3695_9263# GND 0.26569f ; **FLOATING
C3778 _243_.CLK GND 2.47717f ; **FLOATING
C3779 a_2955_9308# GND 0.19555f ; **FLOATING
C3780 a_2853_9165# GND 0.42491f ; **FLOATING
C3781 a_2436_9504# GND 0.89616f ; **FLOATING
C3782 a_2150_9186# GND 0.11099f ; **FLOATING
C3783 a_2410_9409# GND 0.0826f ; **FLOATING
C3784 _219_.Y GND 0.59588f ; **FLOATING
C3785 a_17120_10034# GND 0.0894f
C3786 _260_.RESET_B GND 0.55604f ; **FLOATING
C3787 _171_.Y GND 0.5638f ; **FLOATING
C3788 a_8050_10326# GND 0.12569f ; **FLOATING
C3789 a_7808_10034# GND 0.03893f
C3790 a_7624_10034# GND 0.07413f
C3791 _164_.Y GND 1.07939f ; **FLOATING
C3792 _183_.Y GND 0.15053f ; **FLOATING
C3793 _185_.Y GND 0.19973f ; **FLOATING
C3794 a_7251_10296# GND 0.01118f ; **FLOATING
C3795 _171_.A GND 0.51513f ; **FLOATING
C3796 _184_.Y GND 0.18245f ; **FLOATING
C3797 _178_.Y GND 0.32942f ; **FLOATING
C3798 _177_.X GND 0.24697f ; **FLOATING
C3799 a_6124_9945# GND 0.10962f ; **FLOATING
C3800 _174_.Y GND 0.39269f ; **FLOATING
C3801 _173_.Y GND 0.86662f ; **FLOATING
C3802 a_1864_10034# GND 0.09605f
C3803 _246_.D GND 0.1797f ; **FLOATING
C3804 _122_.A0 GND 1.51173f ; **FLOATING
C3805 a_2232_10210# GND 0.15293f ; **FLOATING
C3806 a_2126_10214# GND 0.32468f ; **FLOATING
C3807 a_17032_10830# GND 0.1218f
C3808 a_14753_10724# GND 0.01118f ; **FLOATING
C3809 a_14432_10830# GND 0.04449f
C3810 a_8501_10702# GND 0.08117f ; **FLOATING
C3811 a_8352_11013# GND 0.20032f ; **FLOATING
C3812 _181_.Y GND 0.32091f ; **FLOATING
C3813 _179_.Y GND 0.82101f ; **FLOATING
C3814 a_3592_10830# GND 0.08614f
C3815 a_3886_10702# GND 1.55432f ; **FLOATING
C3816 a_17120_11546# GND 0.08024f
C3817 a_15985_11821# GND 0.05798f ; **FLOATING
C3818 a_16746_11460# GND 0.18141f ; **FLOATING
C3819 a_16079_11821# GND 0.2652f ; **FLOATING
C3820 a_16336_11702# GND 0.14407f ; **FLOATING
C3821 a_15339_11471# GND 0.19599f ; **FLOATING
C3822 a_15108_11885# GND 0.03671f ; **FLOATING
C3823 a_15237_11471# GND 0.43065f ; **FLOATING
C3824 a_14820_11464# GND 0.89727f ; **FLOATING
C3825 a_14794_11428# GND 0.08278f ; **FLOATING
C3826 a_14534_11898# GND 0.11099f ; **FLOATING
C3827 a_13985_11808# GND 0.01118f ; **FLOATING
C3828 _236_.Y GND 0.58045f ; **FLOATING
C3829 _131_.Y GND 0.16462f ; **FLOATING
C3830 a_13025_11808# GND 0.01118f ; **FLOATING
C3831 a_12704_11546# GND 0.04369f
C3832 _132_.Y GND 0.24818f ; **FLOATING
C3833 _178_.B1 GND 0.64283f ; **FLOATING
C3834 a_6485_11830# GND 0.08213f ; **FLOATING
C3835 a_6336_11499# GND 0.19725f ; **FLOATING
C3836 a_6080_11546# GND 0.04708f
C3837 a_1952_11546# GND 0.04561f
C3838 _173_.A GND 1.54302f ; **FLOATING
C3839 a_2232_11722# GND 0.15554f ; **FLOATING
C3840 a_2126_11726# GND 0.32104f ; **FLOATING
C3841 a_1192_11460# GND 0.20706f ; **FLOATING
C3842 a_17032_12342# GND 0.1201f
C3843 a_15889_12287# GND 0.05791f ; **FLOATING
C3844 a_15012_12223# GND 0.03671f ; **FLOATING
C3845 a_16650_12508# GND 0.17979f ; **FLOATING
C3846 a_16240_12430# GND 0.1468f ; **FLOATING
C3847 a_15983_12287# GND 0.26505f ; **FLOATING
C3848 a_15243_12332# GND 0.19571f ; **FLOATING
C3849 a_15141_12189# GND 0.43179f ; **FLOATING
C3850 a_14724_12528# GND 0.89558f ; **FLOATING
C3851 a_14438_12210# GND 0.11033f ; **FLOATING
C3852 _129_.Y GND 0.23263f ; **FLOATING
C3853 _235_.Y GND 0.61384f ; **FLOATING
C3854 a_14698_12433# GND 0.08295f ; **FLOATING
C3855 a_13297_12287# GND 0.0579f ; **FLOATING
C3856 a_12420_12223# GND 0.03671f ; **FLOATING
C3857 a_14058_12508# GND 0.17665f ; **FLOATING
C3858 a_13648_12430# GND 0.14656f ; **FLOATING
C3859 a_13391_12287# GND 0.26421f ; **FLOATING
C3860 a_12651_12332# GND 0.19406f ; **FLOATING
C3861 a_12549_12189# GND 0.44607f ; **FLOATING
C3862 a_12132_12528# GND 0.89645f ; **FLOATING
C3863 a_11846_12210# GND 0.1133f ; **FLOATING
C3864 _126_.Y GND 0.48554f ; **FLOATING
C3865 a_12106_12433# GND 0.0825f ; **FLOATING
C3866 _261_.RESET_B GND 0.61924f ; **FLOATING
C3867 a_11456_12342# GND 0.04163f
C3868 a_10321_12287# GND 0.05794f ; **FLOATING
C3869 a_9444_12223# GND 0.03672f ; **FLOATING
C3870 a_11082_12508# GND 0.17784f ; **FLOATING
C3871 a_10672_12430# GND 0.14529f ; **FLOATING
C3872 a_10415_12287# GND 0.26677f ; **FLOATING
C3873 _251_.CLK GND 3.9495f ; **FLOATING
C3874 a_9675_12332# GND 0.19482f ; **FLOATING
C3875 a_9573_12189# GND 0.43964f ; **FLOATING
C3876 a_9156_12528# GND 0.89584f ; **FLOATING
C3877 a_8870_12210# GND 0.1127f ; **FLOATING
C3878 _182_.Y GND 0.41277f ; **FLOATING
C3879 a_9130_12433# GND 0.08324f ; **FLOATING
C3880 _256_.RESET_B GND 0.59483f ; **FLOATING
C3881 a_6482_12218# GND 0.01261f ; **FLOATING
C3882 _176_.A GND 1.26155f ; **FLOATING
C3883 a_6272_12342# GND 0.04352f
C3884 a_4858_12214# GND 0.01132f ; **FLOATING
C3885 _176_.B GND 0.91189f ; **FLOATING
C3886 a_4552_12342# GND 0.0836f
C3887 a_3409_12287# GND 0.05788f ; **FLOATING
C3888 a_2532_12223# GND 0.03672f ; **FLOATING
C3889 a_5297_12264# GND 0.15578f ; **FLOATING
C3890 a_4170_12508# GND 0.18135f ; **FLOATING
C3891 a_3760_12430# GND 0.14465f ; **FLOATING
C3892 a_3503_12287# GND 0.26253f ; **FLOATING
C3893 a_2763_12332# GND 0.1947f ; **FLOATING
C3894 a_2661_12189# GND 0.44024f ; **FLOATING
C3895 a_2244_12528# GND 0.89728f ; **FLOATING
C3896 a_1958_12210# GND 0.11114f ; **FLOATING
C3897 _120_.X GND 0.28429f ; **FLOATING
C3898 a_2218_12433# GND 0.08248f ; **FLOATING
C3899 _220_.Y GND 0.56898f ; **FLOATING
C3900 a_1568_12342# GND 0.04371f
C3901 _131_.B1 GND 0.26483f ; **FLOATING
C3902 a_14451_13320# GND 0.01118f ; **FLOATING
C3903 a_14240_13058# GND 0.04039f
C3904 _260_.CLK GND 1.55399f ; **FLOATING
C3905 _129_.B1 GND 0.24628f ; **FLOATING
C3906 a_13366_13350# GND 0.12498f ; **FLOATING
C3907 a_5084_12972# GND 0.01679f ; **FLOATING
C3908 a_6881_13320# GND 0.01161f ; **FLOATING
C3909 a_12886_13350# GND 0.15463f ; **FLOATING
C3910 _126_.B1 GND 0.81352f ; **FLOATING
C3911 _131_.A2 GND 1.13416f ; **FLOATING
C3912 _133_.Y GND 0.40451f ; **FLOATING
C3913 _128_.B1 GND 0.28831f ; **FLOATING
C3914 _192_.B GND 0.31233f ; **FLOATING
C3915 _187_.Y GND 0.50915f ; **FLOATING
C3916 _192_.C GND 0.2911f ; **FLOATING
C3917 a_6197_13342# GND 0.08209f ; **FLOATING
C3918 a_6048_13011# GND 0.18955f ; **FLOATING
C3919 a_5178_13330# GND 0.013f ; **FLOATING
C3920 a_4640_13058# GND 0.03938f
C3921 a_4456_13058# GND 0.08019f
C3922 a_4913_13330# GND 0.17827f ; **FLOATING
C3923 a_3313_13333# GND 0.05792f ; **FLOATING
C3924 a_4074_12972# GND 0.18f ; **FLOATING
C3925 a_3407_13333# GND 0.26293f ; **FLOATING
C3926 a_3664_13214# GND 0.14343f ; **FLOATING
C3927 a_2667_12983# GND 0.19274f ; **FLOATING
C3928 a_2436_13397# GND 0.03671f ; **FLOATING
C3929 a_2565_12983# GND 0.44144f ; **FLOATING
C3930 a_2148_12976# GND 0.89724f ; **FLOATING
C3931 a_2122_12940# GND 0.0821f ; **FLOATING
C3932 a_1862_13410# GND 0.11748f ; **FLOATING
C3933 _221_.Y GND 0.77615f ; **FLOATING
C3934 a_1580_12936# GND 0.14635f ; **FLOATING
C3935 _215_.A GND 3.17571f ; **FLOATING
C3936 a_17120_13854# GND 0.08212f
C3937 a_12808_13854# GND 0.09782f
C3938 a_13100_13686# GND 0.16931f ; **FLOATING
C3939 a_10321_13799# GND 0.05795f ; **FLOATING
C3940 a_9444_13735# GND 0.03671f ; **FLOATING
C3941 a_11082_14020# GND 0.18342f ; **FLOATING
C3942 a_10672_13942# GND 0.14529f ; **FLOATING
C3943 a_10415_13799# GND 0.2633f ; **FLOATING
C3944 a_9675_13844# GND 0.1968f ; **FLOATING
C3945 a_9573_13701# GND 0.43856f ; **FLOATING
C3946 a_9156_14040# GND 0.89768f ; **FLOATING
C3947 a_8870_13722# GND 0.1127f ; **FLOATING
C3948 a_9130_13945# GND 0.08329f ; **FLOATING
C3949 _230_.Y GND 0.60006f ; **FLOATING
C3950 _194_.X GND 0.35685f ; **FLOATING
C3951 a_6760_13854# GND 0.08506f
C3952 a_6106_13726# GND 0.01021f ; **FLOATING
C3953 _192_.Y GND 0.31424f ; **FLOATING
C3954 a_5888_13854# GND 0.03774f
C3955 a_5704_13854# GND 0.08126f
C3956 a_7985_13776# GND 0.14526f ; **FLOATING
C3957 a_6958_13764# GND 0.15509f ; **FLOATING
C3958 _190_.A GND 1.31173f ; **FLOATING
C3959 _189_.X GND 0.69132f ; **FLOATING
C3960 clkbuf_1_0__f_sclk.A GND 3.36885f ; **FLOATING
C3961 a_3380_13690# GND 1.5746f ; **FLOATING
C3962 clkload0.Y GND 0.08172f ; **FLOATING
C3963 _120_.A0 GND 1.08271f ; **FLOATING
C3964 a_2232_13916# GND 0.1282f ; **FLOATING
C3965 a_1864_13854# GND 0.0965f
C3966 _119_.X GND 0.3166f ; **FLOATING
C3967 a_2126_13912# GND 0.32225f ; **FLOATING
C3968 a_7553_14832# GND 0.01135f ; **FLOATING
C3969 a_7232_14570# GND 0.05167f
C3970 a_17032_15366# GND 0.1196f
C3971 _263_.CLK GND 1.39256f ; **FLOATING
C3972 a_15505_15311# GND 0.058f ; **FLOATING
C3973 a_14628_15247# GND 0.03671f ; **FLOATING
C3974 a_16266_15532# GND 0.18592f ; **FLOATING
C3975 a_15856_15454# GND 0.14811f ; **FLOATING
C3976 a_15599_15311# GND 0.26097f ; **FLOATING
C3977 a_14859_15356# GND 0.19401f ; **FLOATING
C3978 a_14757_15213# GND 0.4355f ; **FLOATING
C3979 a_14340_15552# GND 0.89564f ; **FLOATING
C3980 a_14054_15234# GND 0.11099f ; **FLOATING
C3981 a_14314_15457# GND 0.0821f ; **FLOATING
C3982 _239_.Y GND 0.57082f ; **FLOATING
C3983 _134_.Y GND 0.41838f ; **FLOATING
C3984 a_12992_15437# GND 0.11296f ; **FLOATING
C3985 a_12424_15366# GND 0.08554f
C3986 a_5906_15242# GND 0.01205f ; **FLOATING
C3987 a_5427_15260# GND 0.01169f ; **FLOATING
C3988 a_5050_15238# GND 0.0165f ; **FLOATING
C3989 _193_.Y GND 0.99926f ; **FLOATING
C3990 a_7616_15437# GND 0.11276f ; **FLOATING
C3991 _186_.Y GND 1.46063f ; **FLOATING
C3992 _205_.B1 GND 0.1827f ; **FLOATING
C3993 _191_.Y GND 0.83514f ; **FLOATING
C3994 a_6286_15276# GND 0.14875f ; **FLOATING
C3995 _200_.Y GND 0.27042f ; **FLOATING
C3996 _199_.Y GND 0.58503f ; **FLOATING
C3997 a_4744_15366# GND 0.08443f
C3998 _195_.Y GND 0.36651f ; **FLOATING
C3999 _196_.Y GND 0.60944f ; **FLOATING
C4000 _148_.B GND 4.00355f ; **FLOATING
C4001 _119_.A0 GND 1.60104f ; **FLOATING
C4002 a_2232_15428# GND 0.15229f ; **FLOATING
C4003 a_1864_15366# GND 0.09549f
C4004 a_2126_15424# GND 0.325f ; **FLOATING
C4005 a_17032_16082# GND 0.12983f
C4006 _264_.Q GND 0.29241f ; **FLOATING
C4007 a_13969_16357# GND 0.05793f ; **FLOATING
C4008 a_14730_15996# GND 0.17805f ; **FLOATING
C4009 a_14063_16357# GND 0.26059f ; **FLOATING
C4010 a_14320_16238# GND 0.14344f ; **FLOATING
C4011 a_13323_16007# GND 0.19563f ; **FLOATING
C4012 a_13092_16421# GND 0.03671f ; **FLOATING
C4013 a_12416_16082# GND 0.03887f
C4014 a_13221_16007# GND 0.44559f ; **FLOATING
C4015 a_12804_16000# GND 0.89627f ; **FLOATING
C4016 a_12778_15964# GND 0.08287f ; **FLOATING
C4017 a_12518_16434# GND 0.12044f ; **FLOATING
C4018 _237_.Y GND 0.52569f ; **FLOATING
C4019 _135_.X GND 0.2521f ; **FLOATING
C4020 a_11944_16082# GND 0.08417f
C4021 a_11168_16082# GND 0.04075f
C4022 a_9073_16357# GND 0.0579f ; **FLOATING
C4023 a_9834_15996# GND 0.18364f ; **FLOATING
C4024 a_9167_16357# GND 0.26492f ; **FLOATING
C4025 a_9424_16238# GND 0.14492f ; **FLOATING
C4026 a_8427_16007# GND 0.19521f ; **FLOATING
C4027 a_8196_16421# GND 0.03671f ; **FLOATING
C4028 a_8325_16007# GND 0.42996f ; **FLOATING
C4029 a_7908_16000# GND 0.89496f ; **FLOATING
C4030 a_7882_15964# GND 0.08235f ; **FLOATING
C4031 a_7622_16434# GND 0.11051f ; **FLOATING
C4032 _258_.D GND 0.15506f ; **FLOATING
C4033 a_7157_16366# GND 0.08106f ; **FLOATING
C4034 a_7008_16035# GND 0.1899f ; **FLOATING
C4035 a_5147_15996# GND 0.0171f ; **FLOATING
C4036 _202_.Y GND 0.31592f ; **FLOATING
C4037 a_5249_16344# GND 0.01579f ; **FLOATING
C4038 a_4928_16082# GND 0.04539f
C4039 _201_.Y GND 0.50283f ; **FLOATING
C4040 _207_.B1 GND 0.27146f ; **FLOATING
C4041 a_4462_16052# GND 0.14633f ; **FLOATING
C4042 a_3313_16357# GND 0.05791f ; **FLOATING
C4043 a_4074_15996# GND 0.18119f ; **FLOATING
C4044 a_3407_16357# GND 0.26339f ; **FLOATING
C4045 a_3664_16238# GND 0.14351f ; **FLOATING
C4046 a_2667_16007# GND 0.1944f ; **FLOATING
C4047 a_2436_16421# GND 0.03671f ; **FLOATING
C4048 a_2565_16007# GND 0.42526f ; **FLOATING
C4049 a_2148_16000# GND 0.89638f ; **FLOATING
C4050 a_2122_15964# GND 0.08194f ; **FLOATING
C4051 a_1862_16434# GND 0.11099f ; **FLOATING
C4052 a_17120_16878# GND 0.08131f
C4053 a_14830_16746# GND 0.05791f ; **FLOATING
C4054 a_15722_16904# GND 0.03671f ; **FLOATING
C4055 _211_.Y GND 0.61975f ; **FLOATING
C4056 a_15861_16904# GND 0.08337f ; **FLOATING
C4057 a_15767_17137# GND 0.13028f ; **FLOATING
C4058 a_14940_16710# GND 0.89605f ; **FLOATING
C4059 a_14919_16964# GND 0.19514f ; **FLOATING
C4060 a_14572_16746# GND 0.14398f ; **FLOATING
C4061 a_15071_17016# GND 0.44096f ; **FLOATING
C4062 _238_.Y GND 0.85067f ; **FLOATING
C4063 a_14048_16878# GND 0.04553f
C4064 _135_.A GND 0.74592f ; **FLOATING
C4065 _266_.CLK GND 1.0064f ; **FLOATING
C4066 a_12529_16823# GND 0.05794f ; **FLOATING
C4067 a_11652_16759# GND 0.03671f ; **FLOATING
C4068 a_14359_16710# GND 0.26402f ; **FLOATING
C4069 a_14240_16921# GND 0.17955f ; **FLOATING
C4070 a_13290_17044# GND 0.18284f ; **FLOATING
C4071 a_12880_16966# GND 0.14446f ; **FLOATING
C4072 a_12623_16823# GND 0.26211f ; **FLOATING
C4073 a_11883_16868# GND 0.19254f ; **FLOATING
C4074 a_11781_16725# GND 0.44349f ; **FLOATING
C4075 a_11364_17064# GND 0.89574f ; **FLOATING
C4076 a_11078_16746# GND 0.12096f ; **FLOATING
C4077 _212_.Y GND 0.47468f ; **FLOATING
C4078 a_10888_16878# GND 0.07936f
C4079 _241_.Y GND 0.71446f ; **FLOATING
C4080 a_11338_16969# GND 0.08221f ; **FLOATING
C4081 a_9457_16823# GND 0.05791f ; **FLOATING
C4082 a_8580_16759# GND 0.03671f ; **FLOATING
C4083 a_10218_17044# GND 0.17622f ; **FLOATING
C4084 a_9808_16966# GND 0.14633f ; **FLOATING
C4085 a_9551_16823# GND 0.26242f ; **FLOATING
C4086 fanout7.A GND 3.83068f ; **FLOATING
C4087 a_8811_16868# GND 0.19333f ; **FLOATING
C4088 a_8709_16725# GND 0.43943f ; **FLOATING
C4089 a_8292_17064# GND 0.89614f ; **FLOATING
C4090 a_8006_16746# GND 0.11203f ; **FLOATING
C4091 a_8266_16969# GND 0.08356f ; **FLOATING
C4092 _259_.RESET_B GND 0.59932f ; **FLOATING
C4093 _258_.RESET_B GND 0.75473f ; **FLOATING
C4094 a_7328_16878# GND 0.04134f
C4095 a_6869_16750# GND 0.0813f ; **FLOATING
C4096 _209_.Y GND 0.2287f ; **FLOATING
C4097 a_6376_16878# GND 0.08995f
C4098 a_5525_16750# GND 0.0819f ; **FLOATING
C4099 _199_.B1 GND 0.52448f ; **FLOATING
C4100 a_4796_17044# GND 0.0108f ; **FLOATING
C4101 a_3313_16823# GND 0.05791f ; **FLOATING
C4102 a_2436_16759# GND 0.03671f ; **FLOATING
C4103 a_6720_17061# GND 0.18438f ; **FLOATING
C4104 _208_.X GND 0.38197f ; **FLOATING
C4105 _205_.Y GND 0.88577f ; **FLOATING
C4106 a_5376_17061# GND 0.19643f ; **FLOATING
C4107 _207_.A1 GND 0.93038f ; **FLOATING
C4108 a_4625_16800# GND 0.15813f ; **FLOATING
C4109 _207_.Y GND 0.62389f ; **FLOATING
C4110 a_4074_17044# GND 0.182f ; **FLOATING
C4111 a_3664_16966# GND 0.14516f ; **FLOATING
C4112 a_3407_16823# GND 0.26327f ; **FLOATING
C4113 _247_.CLK GND 1.96312f ; **FLOATING
C4114 a_2667_16868# GND 0.19452f ; **FLOATING
C4115 a_2565_16725# GND 0.42405f ; **FLOATING
C4116 a_2148_17064# GND 0.89637f ; **FLOATING
C4117 a_1862_16746# GND 0.11736f ; **FLOATING
C4118 _118_.X GND 0.29157f ; **FLOATING
C4119 _222_.Y GND 0.58822f ; **FLOATING
C4120 a_2122_16969# GND 0.08194f ; **FLOATING
C4121 a_1580_16710# GND 0.14988f ; **FLOATING
C4122 _250_.RESET_B GND 0.87079f ; **FLOATING
C4123 _222_.A GND 1.43068f ; **FLOATING
C4124 a_17032_17594# GND 0.13152f
C4125 _214_.A GND 0.44758f ; **FLOATING
C4126 a_11185_17869# GND 0.05788f ; **FLOATING
C4127 a_11946_17508# GND 0.18436f ; **FLOATING
C4128 a_11279_17869# GND 0.26342f ; **FLOATING
C4129 a_11536_17750# GND 0.14226f ; **FLOATING
C4130 a_10539_17519# GND 0.19183f ; **FLOATING
C4131 a_10308_17933# GND 0.03671f ; **FLOATING
C4132 a_10437_17519# GND 0.43952f ; **FLOATING
C4133 a_10020_17512# GND 0.89842f ; **FLOATING
C4134 a_9994_17476# GND 0.08191f ; **FLOATING
C4135 a_9734_17946# GND 0.11054f ; **FLOATING
C4136 a_9160_17594# GND 0.09791f
C4137 _240_.Y GND 0.55369f ; **FLOATING
C4138 _214_.Y GND 0.46042f ; **FLOATING
C4139 a_9352_17508# GND 0.1598f ; **FLOATING
C4140 _207_.A2 GND 0.61991f ; **FLOATING
C4141 a_4661_17878# GND 0.0854f ; **FLOATING
C4142 a_4512_17547# GND 0.21245f ; **FLOATING
C4143 fanout6.A GND 1.81751f ; **FLOATING
C4144 a_1952_17594# GND 0.04509f
C4145 _250_.D GND 0.27776f ; **FLOATING
C4146 _124_.S GND 3.01979f ; **FLOATING
C4147 _118_.A0 GND 0.92513f ; **FLOATING
C4148 _250_.Q GND 0.67823f ; **FLOATING
C4149 a_2232_17770# GND 0.15229f ; **FLOATING
C4150 a_2126_17774# GND 0.3235f ; **FLOATING
C4151 fanout8.A GND 2.47276f ; **FLOATING
C4152 a_1192_17508# GND 0.20549f ; **FLOATING
C4153 a_9928_18390# GND 0.09885f
C4154 _236_.A GND 3.25084f ; **FLOATING
C4155 _225_.A GND 8.05701f ; **FLOATING
C4156 a_10220_18222# GND 0.16933f ; **FLOATING
C4157 _225_.A.t2 GND 0.20907f ; **FLOATING
C4158 _225_.A.t4 GND 0.2091f ; **FLOATING
C4159 _225_.A.n0 GND 2.05982f ; **FLOATING
C4160 _225_.A.t3 GND 0.20906f ; **FLOATING
C4161 _225_.A.n1 GND 1.4664f ; **FLOATING
C4162 _225_.A.t1 GND 0.20906f ; **FLOATING
C4163 _225_.A.n2 GND 1.13827f ; **FLOATING
C4164 _225_.A.n3 GND 1.88338f ; **FLOATING
C4165 _225_.A.n4 GND 1.74837f ; **FLOATING
C4166 _225_.A.n5 GND 1.44634f ; **FLOATING
C4167 _225_.A.n6 GND 1.80798f ; **FLOATING
C4168 _225_.A.t0 GND 0.17649f ; **FLOATING
.ends
