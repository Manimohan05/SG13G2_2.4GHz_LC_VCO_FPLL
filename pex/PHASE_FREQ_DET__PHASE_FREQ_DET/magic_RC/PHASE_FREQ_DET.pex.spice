* NGSPICE file created from PHASE_FREQ_DET.ext - technology: ihp-sg13g2

.subckt PHASE_FREQ_DET_PEX FREF UP VDD VSS FDIV DN
X0 VDD.t4 a_291_375.t2 a_252_473.t0 VDD.t2 sg13_lv_pmos ad=1.6452p pd=10.48u as=52.5f ps=0.67u w=0.42u l=0.13u
X1 a_n839_549.t0 a_n1196_476.t4 VDD.t3 VDD.t2 sg13_lv_pmos ad=54.6f pd=0.68u as=0.1563p ps=1.22u w=0.42u l=0.13u
X2 a_864_436.t0 a_63_235.t2 VDD.t7 VDD.t2 sg13_lv_pmos ad=0.34p pd=2.68u as=0.2083p ps=1.5u w=1u l=0.13u
X3 a_864_n636.t1 a_63_n319.t2 VSS.t40 VSS.t11 sg13_lv_nmos ad=0.2176p pd=1.96u as=0.1331p ps=1.12u w=0.64u l=0.13u
X4 sg13g2_dfrbp_2_1.Q_N.t0 a_63_n319.t2 VDD.t30 VDD.t0 sg13_lv_pmos ad=0.2128p pd=1.5u as=0.2014p ps=1.53u w=1.12u l=0.13u
X5 VDD.t13 a_n787_n669.t3 a_n685_n669.t0 VDD.t0 sg13_lv_pmos ad=1.4292p pd=9.04u as=0.3864p ps=2.93u w=1.12u l=0.13u
X6 VDD.t3 sg13g2_nand2_2_0.Y.t6 a_n1222_381.t2 VDD.t2 sg13_lv_pmos ad=0.1563p pd=1.22u as=0.147p ps=1.54u w=0.42u l=0.13u
X7 a_63_235.t1 a_n787_415.t2 a_n1196_476.t2 VDD.t2 sg13_lv_pmos ad=0.19115p pd=1.565u as=0.34p ps=2.68u w=1u l=0.13u
X8 VDD.t15 a_864_436.t2 sg13g2_nand2_2_0.A.t0 VDD.t2 sg13_lv_pmos ad=0.3808p pd=2.92u as=0.2156p ps=1.505u w=1.12u l=0.13u
X9 a_252_n557.t0 a_n685_n669.t2 a_63_n319.t0 VDD.t0 sg13_lv_pmos ad=52.5f pd=0.67u as=0.19115p ps=1.565u w=0.42u l=0.13u
X10 a_291_n441.t0 sg13g2_nand2_2_0.Y.t3 VDD.t13 VDD.t0 sg13_lv_pmos ad=79.8f pd=0.8u as=1.4292p ps=9.04u w=0.42u l=0.13u
X11 a_n1482_158.t2 a_n685_502.t3 a_n1222_381.t1 VDD.t2 sg13_lv_pmos ad=0.1428p pd=1.52u as=79.8f ps=0.8u w=0.42u l=0.13u
X12 a_n1196_476.t3 a_n685_502.t2 a_63_235.t0 VSS.t1 sg13_lv_nmos ad=0.3473p pd=2.71u as=0.12665p ps=1.145u w=0.74u l=0.13u
X13 VSS.t29 sg13g2_nand2_2_0.Y.t4 a_n1388_n242.t0 VSS.t23 sg13_lv_nmos ad=0.1626p pd=1.415u as=60.89999f ps=0.71u w=0.42u l=0.13u
X14 VSS.t9 a_864_n636.t2 DN.t1 VSS.t8 sg13_lv_nmos ad=0.2516p pd=2.16u as=0.1406p ps=1.12u w=0.74u l=0.13u
X15 a_n1222_381.t1 a_n787_415.t3 a_n839_549.t0 VDD.t2 sg13_lv_pmos ad=79.8f pd=0.8u as=54.6f ps=0.68u w=0.42u l=0.13u
X16 a_n1222_n712.t1 a_n787_n669.t3 a_n1482_n242.t1 VSS.t18 sg13_lv_nmos ad=81f pd=0.81u as=0.1296p ps=1.52u w=0.42u l=0.13u
X17 sg13g2_nand2_2_0.Y.t1 sg13g2_nand2_2_0.A.t2 a_1402_159.t0 VSS.t16 sg13_lv_nmos ad=0.1368p pd=1.1u as=0.2448p ps=2.12u w=0.72u l=0.13u
X18 a_63_n319.t1 a_n787_n669.t2 a_n31_n319.t0 VSS.t3 sg13_lv_nmos ad=0.12665p pd=1.145u as=0.1428p ps=1.52u w=0.42u l=0.13u
X19 a_n907_171.t1 a_n685_502.t3 a_n1222_381.t0 VSS.t2 sg13_lv_nmos ad=0.2163p pd=1.87u as=81f ps=0.81u w=0.42u l=0.13u
X20 a_n907_n255.t0 a_n1196_n676.t4 a_n970_n255.t0 VSS.t0 sg13_lv_nmos ad=0.1596p pd=1.6u as=38.85f ps=0.605u w=0.42u l=0.13u
X21 a_482_n242.t0 sg13g2_nand2_2_0.Y.t3 VSS.t31 VSS.t30 sg13_lv_nmos ad=37.8f pd=0.6u as=79.8f ps=0.8u w=0.42u l=0.13u
X22 a_n1482_n242.t0 VDD.t26 VDD.t27 VDD.t0 sg13_lv_pmos ad=79.8f pd=0.8u as=0.1428p ps=1.52u w=0.42u l=0.13u
X23 sg13g2_nand2_2_0.Y.t0 sg13g2_nand2_2_0.A.t2 VDD.t11 VDD.t2 sg13_lv_pmos ad=0.2128p pd=1.5u as=0.392p ps=2.94u w=1.12u l=0.13u
X24 a_1402_159.t1 sg13g2_nand2_2_0.A.t2 sg13g2_nand2_2_0.Y.t1 VSS.t17 sg13_lv_nmos ad=0.1404p pd=1.11u as=0.1368p ps=1.1u w=0.72u l=0.13u
X25 a_n1196_n676.t2 a_n1222_n712.t3 VSS.t29 VSS.t32 sg13_lv_nmos ad=0.2516p pd=2.16u as=0.1626p ps=1.415u w=0.74u l=0.13u
X26 a_n1222_381.t0 a_n787_415.t3 a_n1482_158.t1 VSS.t18 sg13_lv_nmos ad=81f pd=0.81u as=0.1296p ps=1.52u w=0.42u l=0.13u
X27 VSS.t5 a_291_375.t2 a_n31_235.t0 VSS.t4 sg13_lv_nmos ad=79.8f pd=0.8u as=0.1428p ps=1.52u w=0.42u l=0.13u
X28 VDD.t32 a_63_n319.t2 sg13g2_dfrbp_2_1.Q_N.t0 VDD.t0 sg13_lv_pmos ad=0.2083p pd=1.5u as=0.2128p ps=1.5u w=1.12u l=0.13u
X29 VDD.t12 sg13g2_nand2_2_0.A.t2 sg13g2_nand2_2_0.Y.t0 VDD.t2 sg13_lv_pmos ad=0.2184p pd=1.51u as=0.2128p ps=1.5u w=1.12u l=0.13u
X30 VDD.t4 a_n787_415.t3 a_n685_502.t0 VDD.t2 sg13_lv_pmos ad=1.6452p pd=10.48u as=0.3864p ps=2.93u w=1.12u l=0.13u
X31 a_482_158.t0 sg13g2_nand2_2_0.Y.t5 VSS.t5 VSS.t4 sg13_lv_nmos ad=37.8f pd=0.6u as=79.8f ps=0.8u w=0.42u l=0.13u
X32 VDD.t30 a_63_n319.t2 a_291_n441.t0 VDD.t0 sg13_lv_pmos ad=0.2014p pd=1.53u as=79.8f ps=0.8u w=0.42u l=0.13u
X33 a_291_375.t0 a_63_235.t2 a_482_158.t0 VSS.t10 sg13_lv_nmos ad=0.1428p pd=1.52u as=37.8f ps=0.6u w=0.42u l=0.13u
X34 VDD.t13 a_291_n441.t2 a_252_n557.t0 VDD.t0 sg13_lv_pmos ad=1.4292p pd=9.04u as=52.5f ps=0.67u w=0.42u l=0.13u
X35 a_252_473.t0 a_n685_502.t2 a_63_235.t1 VDD.t2 sg13_lv_pmos ad=52.5f pd=0.67u as=0.19115p ps=1.565u w=0.42u l=0.13u
X36 UP.t1 a_63_235.t2 VSS.t14 VSS.t13 sg13_lv_nmos ad=0.1406p pd=1.12u as=0.2516p ps=2.16u w=0.74u l=0.13u
X37 a_291_375.t1 sg13g2_nand2_2_0.Y.t5 VDD.t4 VDD.t2 sg13_lv_pmos ad=79.8f pd=0.8u as=1.6452p ps=10.48u w=0.42u l=0.13u
X38 VSS.t20 a_n787_415.t3 a_n685_502.t1 VSS.t33 sg13_lv_nmos ad=3.31765p pd=10.945u as=0.2516p ps=2.16u w=0.74u l=0.13u
X39 VSS.t12 a_63_235.t2 UP.t1 VSS.t15 sg13_lv_nmos ad=0.1331p pd=1.12u as=0.1406p ps=1.12u w=0.74u l=0.13u
X40 VSS.t20 a_n787_n669.t3 a_n685_n669.t1 VSS.t19 sg13_lv_nmos ad=3.31765p pd=10.945u as=0.2516p ps=2.16u w=0.74u l=0.13u
X41 VDD.t16 sg13g2_nand2_2_0.Y.t6 a_n1482_158.t0 VDD.t2 sg13_lv_pmos ad=0.36237p pd=2.605u as=79.8f ps=0.8u w=0.42u l=0.13u
X42 a_n787_415.t0 FREF.t0 VDD.t4 VDD.t2 sg13_lv_pmos ad=0.3808p pd=2.92u as=1.6452p ps=10.48u w=1.12u l=0.13u
X43 DN.t0 a_864_n636.t2 VDD.t5 VDD.t0 sg13_lv_pmos ad=0.2156p pd=1.505u as=0.3808p ps=2.92u w=1.12u l=0.13u
X44 VDD.t6 a_864_n636.t2 DN.t0 VDD.t0 sg13_lv_pmos ad=0.3808p pd=2.92u as=0.2156p ps=1.505u w=1.12u l=0.13u
X45 VDD.t8 a_63_235.t2 a_291_375.t1 VDD.t2 sg13_lv_pmos ad=0.2014p pd=1.53u as=79.8f ps=0.8u w=0.42u l=0.13u
X46 a_864_436.t1 a_63_235.t2 VSS.t12 VSS.t11 sg13_lv_nmos ad=0.2176p pd=1.96u as=0.1331p ps=1.12u w=0.64u l=0.13u
X47 a_n787_n669.t1 FDIV.t0 VSS.t20 VSS.t19 sg13_lv_nmos ad=0.2516p pd=2.16u as=3.31765p ps=10.945u w=0.74u l=0.13u
X48 a_n1482_158.t0 VDD.t28 VDD.t29 VDD.t2 sg13_lv_pmos ad=79.8f pd=0.8u as=0.1428p ps=1.52u w=0.42u l=0.13u
X49 a_n1196_476.t0 a_n1222_381.t3 VDD.t16 VDD.t2 sg13_lv_pmos ad=0.34p pd=2.68u as=0.36237p ps=2.605u w=1u l=0.13u
X50 a_n1196_n676.t1 a_n1222_n712.t3 VDD.t19 VDD.t0 sg13_lv_pmos ad=0.34p pd=2.68u as=0.36237p ps=2.605u w=1u l=0.13u
X51 VDD.t1 sg13g2_nand2_2_0.Y.t4 a_n1222_n712.t0 VDD.t0 sg13_lv_pmos ad=0.1563p pd=1.22u as=0.147p ps=1.54u w=0.42u l=0.13u
X52 a_n787_415.t1 FREF.t0 VSS.t20 VSS.t33 sg13_lv_nmos ad=0.2516p pd=2.16u as=3.31765p ps=10.945u w=0.74u l=0.13u
X53 VSS.t35 DN.t2 a_1402_159.t1 VSS.t34 sg13_lv_nmos ad=0.1368p pd=1.1u as=0.1404p ps=1.11u w=0.72u l=0.13u
X54 a_n970_n255.t0 sg13g2_nand2_2_0.Y.t4 VSS.t28 VSS.t25 sg13_lv_nmos ad=38.85f pd=0.605u as=0.1701p ps=1.65u w=0.42u l=0.13u
X55 a_291_n441.t1 a_63_n319.t2 a_482_n242.t0 VSS.t10 sg13_lv_nmos ad=0.1428p pd=1.52u as=37.8f ps=0.6u w=0.42u l=0.13u
X56 sg13g2_dfrbp_2_1.Q_N.t1 a_63_n319.t2 VSS.t39 VSS.t13 sg13_lv_nmos ad=0.1406p pd=1.12u as=0.2516p ps=2.16u w=0.74u l=0.13u
X57 a_n1482_n242.t3 a_n685_n669.t3 a_n1222_n712.t2 VDD.t0 sg13_lv_pmos ad=0.1428p pd=1.52u as=79.8f ps=0.8u w=0.42u l=0.13u
X58 a_n970_171.t0 sg13g2_nand2_2_0.Y.t6 VSS.t26 VSS.t25 sg13_lv_nmos ad=38.85f pd=0.605u as=0.1701p ps=1.65u w=0.42u l=0.13u
X59 a_n907_171.t0 a_n1196_476.t4 a_n970_171.t0 VSS.t0 sg13_lv_nmos ad=0.1596p pd=1.6u as=38.85f ps=0.605u w=0.42u l=0.13u
X60 a_1402_159.t2 DN.t2 VSS.t35 VSS.t36 sg13_lv_nmos ad=0.27p pd=2.19u as=0.1368p ps=1.1u w=0.72u l=0.13u
X61 a_n1388_n242.t0 VDD.t26 a_n1482_n242.t2 VSS.t38 sg13_lv_nmos ad=60.89999f pd=0.71u as=0.1428p ps=1.52u w=0.42u l=0.13u
X62 a_n1196_n676.t3 a_n685_n669.t2 a_63_n319.t1 VSS.t44 sg13_lv_nmos ad=0.3473p pd=2.71u as=0.12665p ps=1.145u w=0.74u l=0.13u
X63 sg13g2_nand2_2_0.Y.t2 DN.t2 VDD.t12 VDD.t2 sg13_lv_pmos ad=0.2128p pd=1.5u as=0.2184p ps=1.51u w=1.12u l=0.13u
X64 sg13g2_nand2_2_0.A.t1 a_864_436.t2 VSS.t21 VSS.t6 sg13_lv_nmos ad=0.1406p pd=1.12u as=0.2516p ps=2.16u w=0.74u l=0.13u
X65 VDD.t25 DN.t2 sg13g2_nand2_2_0.Y.t2 VDD.t2 sg13_lv_pmos ad=0.4032p pd=2.96u as=0.2128p ps=1.5u w=1.12u l=0.13u
X66 a_n839_n633.t0 a_n1196_n676.t4 VDD.t1 VDD.t0 sg13_lv_pmos ad=54.6f pd=0.68u as=0.1563p ps=1.22u w=0.42u l=0.13u
X67 a_n787_n669.t0 FDIV.t0 VDD.t13 VDD.t0 sg13_lv_pmos ad=0.3808p pd=2.92u as=1.4292p ps=9.04u w=1.12u l=0.13u
X68 a_864_n636.t0 a_63_n319.t2 VDD.t32 VDD.t0 sg13_lv_pmos ad=0.34p pd=2.68u as=0.2083p ps=1.5u w=1u l=0.13u
X69 a_n1388_158.t0 VDD.t28 a_n1482_158.t3 VSS.t37 sg13_lv_nmos ad=60.89999f pd=0.71u as=0.1428p ps=1.52u w=0.42u l=0.13u
X70 VSS.t22 a_864_436.t2 sg13g2_nand2_2_0.A.t1 VSS.t8 sg13_lv_nmos ad=0.2516p pd=2.16u as=0.1406p ps=1.12u w=0.74u l=0.13u
X71 a_63_235.t0 a_n787_415.t2 a_n31_235.t1 VSS.t42 sg13_lv_nmos ad=0.12665p pd=1.145u as=0.1428p ps=1.52u w=0.42u l=0.13u
X72 sg13g2_nand2_2_0.A.t0 a_864_436.t2 VDD.t14 VDD.t2 sg13_lv_pmos ad=0.2156p pd=1.505u as=0.3808p ps=2.92u w=1.12u l=0.13u
X73 DN.t1 a_864_n636.t2 VSS.t7 VSS.t6 sg13_lv_nmos ad=0.1406p pd=1.12u as=0.2516p ps=2.16u w=0.74u l=0.13u
X74 a_n907_n255.t1 a_n685_n669.t3 a_n1222_n712.t1 VSS.t2 sg13_lv_nmos ad=0.2163p pd=1.87u as=81f ps=0.81u w=0.42u l=0.13u
X75 VSS.t40 a_63_n319.t2 sg13g2_dfrbp_2_1.Q_N.t1 VSS.t15 sg13_lv_nmos ad=0.1331p pd=1.12u as=0.1406p ps=1.12u w=0.74u l=0.13u
X76 a_63_n319.t0 a_n787_n669.t2 a_n1196_n676.t0 VDD.t0 sg13_lv_pmos ad=0.19115p pd=1.565u as=0.34p ps=2.68u w=1u l=0.13u
X77 VSS.t24 sg13g2_nand2_2_0.Y.t6 a_n1388_158.t0 VSS.t23 sg13_lv_nmos ad=0.1626p pd=1.415u as=60.89999f ps=0.71u w=0.42u l=0.13u
X78 a_n1196_476.t1 a_n1222_381.t3 VSS.t24 VSS.t32 sg13_lv_nmos ad=0.2516p pd=2.16u as=0.1626p ps=1.415u w=0.74u l=0.13u
X79 UP.t0 a_63_235.t2 VDD.t8 VDD.t2 sg13_lv_pmos ad=0.2128p pd=1.5u as=0.2014p ps=1.53u w=1.12u l=0.13u
X80 a_n1222_n712.t2 a_n787_n669.t3 a_n839_n633.t0 VDD.t0 sg13_lv_pmos ad=79.8f pd=0.8u as=54.6f ps=0.68u w=0.42u l=0.13u
X81 VDD.t7 a_63_235.t2 UP.t0 VDD.t2 sg13_lv_pmos ad=0.2083p pd=1.5u as=0.2128p ps=1.5u w=1.12u l=0.13u
X82 VSS.t31 a_291_n441.t2 a_n31_n319.t1 VSS.t30 sg13_lv_nmos ad=79.8f pd=0.8u as=0.1428p ps=1.52u w=0.42u l=0.13u
X83 VDD.t19 sg13g2_nand2_2_0.Y.t4 a_n1482_n242.t0 VDD.t0 sg13_lv_pmos ad=0.36237p pd=2.605u as=79.8f ps=0.8u w=0.42u l=0.13u
C0 sg13g2_nand2_2_0.Y DN 0.38031f
C1 VDD DN 0.5768f
C2 VDD sg13g2_dfrbp_2_1.Q_N 0.32355f
C3 sg13g2_nand2_2_0.Y VDD 3.00631f
C4 sg13g2_nand2_2_0.A DN 0.03729f
C5 DN UP 0.0273f
C6 sg13g2_nand2_2_0.Y FREF 0.04016f
C7 VDD FREF 0.17949f
C8 sg13g2_nand2_2_0.A sg13g2_nand2_2_0.Y 0.37953f
C9 sg13g2_nand2_2_0.A VDD 0.61553f
C10 sg13g2_nand2_2_0.Y UP 0.12212f
C11 VDD UP 0.59098f
C12 FREF UP 0.01154f
C13 sg13g2_nand2_2_0.Y FDIV 0.04016f
C14 sg13g2_nand2_2_0.A UP 0.1077f
C15 VDD FDIV 0.18211f
R0 FDIV.n0 FDIV.t0 15.0637
R1 FDIV.n0 FDIV 9.71057
R2 FDIV FDIV.n0 0.0270833
R3 UP.n0 UP 10.9956
R4 UP.n1 UP.t1 8.52386
R5 UP.n0 UP.t0 6.0702
R6 UP.n1 UP.n0 0.176092
R7 UP UP.n1 0.0111588
R8 DN.n0 DN.t2 15.0712
R9 DN.n2 DN.n1 10.1767
R10 DN.n1 DN.n0 10.0262
R11 DN.n2 DN.t1 8.53421
R12 DN.n2 DN.t0 6.13626
R13 DN.n0 DN 0.04175
R14 DN DN.n2 0.0326348
R15 DN.n1 DN 0.0308448
R16 FREF.n0 FREF.t0 15.0005
R17 FREF.n0 FREF 9.61119
R18 FREF FREF.n0 0.06562
R19 VDD.n12 VDD.t29 17.378
R20 VDD.n0 VDD.t27 17.378
R21 VDD.n28 VDD.t3 17.3693
R22 VDD.n4 VDD.t1 17.3693
R23 VDD.n17 VDD.t12 17.2247
R24 VDD.n12 VDD.t16 17.0005
R25 VDD.t4 VDD.n20 17.0005
R26 VDD.t4 VDD.n15 17.0005
R27 VDD.n30 VDD.t4 17.0005
R28 VDD.n0 VDD.t19 17.0005
R29 VDD.n11 VDD.t13 17.0005
R30 VDD VDD.t28 15.0303
R31 VDD VDD.t26 15.0303
R32 VDD.n27 VDD.t8 8.80385
R33 VDD.n6 VDD.t30 8.80285
R34 VDD.t4 VDD.n16 8.47111
R35 VDD.t4 VDD.n24 8.47111
R36 VDD.t4 VDD.n26 8.47111
R37 VDD.t13 VDD.n7 8.47111
R38 VDD.t13 VDD.n10 8.47111
R39 VDD.n2 VDD.t6 6.08478
R40 VDD.n18 VDD.t25 6.07408
R41 VDD.n25 VDD.t7 6.07366
R42 VDD.n8 VDD.t32 6.07323
R43 VDD.n23 VDD.t14 5.98925
R44 VDD.n21 VDD.t15 5.98925
R45 VDD.n9 VDD.t5 5.98882
R46 VDD.n19 VDD.t11 5.98324
R47 VDD.t4 VDD.n18 5.63219
R48 VDD.t4 VDD.n22 5.61485
R49 VDD.t13 VDD.n2 4.20482
R50 VDD.t4 VDD.n14 3.30723
R51 VDD.t13 VDD.n3 3.30723
R52 VDD.n29 VDD.n27 0.854038
R53 VDD.n6 VDD.n5 0.846432
R54 VDD.n5 VDD.n4 0.811538
R55 VDD.n29 VDD.n28 0.803932
R56 VDD.t4 VDD.n29 0.802654
R57 VDD.t13 VDD.n5 0.802654
R58 VDD.t13 VDD.t0 0.567167
R59 VDD.n31 VDD 0.55675
R60 VDD.n32 VDD 0.55675
R61 VDD VDD.n31 0.50925
R62 VDD.t4 VDD.t2 0.472722
R63 VDD.n28 VDD.n14 0.336433
R64 VDD.n4 VDD.n3 0.335195
R65 VDD.n3 VDD.n1 0.333933
R66 VDD.n14 VDD.n13 0.332695
R67 VDD.n32 VDD 0.28925
R68 VDD.n31 VDD 0.178104
R69 VDD VDD.n32 0.178104
R70 VDD.n18 VDD.n17 0.17565
R71 VDD.n24 VDD.n23 0.172039
R72 VDD.n10 VDD.n9 0.172039
R73 VDD.n9 VDD.n2 0.161393
R74 VDD.n19 VDD.n16 0.150789
R75 VDD.n26 VDD.n25 0.140789
R76 VDD.n8 VDD.n7 0.140789
R77 VDD.n13 VDD.n12 0.136382
R78 VDD.n1 VDD.n0 0.136382
R79 VDD.n23 VDD.n22 0.129236
R80 VDD.n22 VDD.n21 0.128325
R81 VDD.n27 VDD.n26 0.115789
R82 VDD.n7 VDD.n6 0.115789
R83 VDD.n21 VDD.n15 0.113
R84 VDD.n17 VDD.n16 0.108289
R85 VDD.n25 VDD.n24 0.100789
R86 VDD.n10 VDD.n8 0.100789
R87 VDD.n20 VDD 0.0605
R88 VDD VDD.n15 0.0605
R89 VDD VDD.n30 0.0605
R90 VDD VDD.n11 0.0605
R91 VDD.n20 VDD.n19 0.0305
R92 VDD.n30 VDD.n13 0.0255
R93 VDD.n11 VDD.n1 0.0255
R94 VSS.n32 VSS.t37 1397.01
R95 VSS.n17 VSS.t38 1397.01
R96 VSS.n28 VSS.t4 480
R97 VSS.n11 VSS.t30 480
R98 VSS.n32 VSS.n31 394.031
R99 VSS.n31 VSS.n17 394.031
R100 VSS.n8 VSS.t13 389.159
R101 VSS.n36 VSS.t15 364.974
R102 VSS.t11 VSS.n26 342.925
R103 VSS.n22 VSS.t34 338.832
R104 VSS.n23 VSS.t17 308.377
R105 VSS.n24 VSS.t16 301.426
R106 VSS.n30 VSS.t32 286.233
R107 VSS.t6 VSS.n25 277.92
R108 VSS.t8 VSS.n24 263.022
R109 VSS.t25 VSS.t0 228.262
R110 VSS.n29 VSS.t18 224.638
R111 VSS.t2 VSS.n12 211.004
R112 VSS.n29 VSS.t2 144.929
R113 VSS.n27 VSS.n12 138.541
R114 VSS.t4 VSS.t1 138.463
R115 VSS.t30 VSS.t44 138.463
R116 VSS.n28 VSS.n27 135.386
R117 VSS.n27 VSS.n11 135.386
R118 VSS.t23 VSS.n30 134.059
R119 VSS.t18 VSS.n13 131.293
R120 VSS.n27 VSS.t10 128.343
R121 VSS.n25 VSS.t8 110.406
R122 VSS.n26 VSS.t6 95.6867
R123 VSS.t0 VSS.n13 95.0623
R124 VSS.t16 VSS.n23 79.9497
R125 VSS.t33 VSS.t42 73.8467
R126 VSS.t19 VSS.t3 73.8467
R127 VSS.t32 VSS.n18 69.893
R128 VSS.t10 VSS.n8 60.2808
R129 VSS.n31 VSS.t23 57.9715
R130 VSS.t17 VSS.n22 57.1071
R131 VSS.n36 VSS.t11 44.1181
R132 VSS.t34 VSS.n21 42.0698
R133 VSS.n18 VSS.t25 40.9077
R134 VSS.t15 VSS.n5 28.1959
R135 VSS.t1 VSS.t33 24.6159
R136 VSS.t44 VSS.t19 24.6159
R137 VSS.n21 VSS.t36 18.2169
R138 VSS.n33 VSS.t26 17.2395
R139 VSS.n33 VSS.t28 17.2395
R140 VSS.n9 VSS.t14 17.2297
R141 VSS.n9 VSS.t39 17.2297
R142 VSS.n34 VSS.t5 17.2268
R143 VSS.n34 VSS.t31 17.2268
R144 VSS.n15 VSS.t24 17.2268
R145 VSS.n15 VSS.t29 17.2268
R146 VSS.n19 VSS.t35 17.2142
R147 VSS.n6 VSS.t12 17.212
R148 VSS.n6 VSS.t40 17.212
R149 VSS.n1 VSS.t22 17.2025
R150 VSS.n1 VSS.t9 17.2025
R151 VSS.t20 VSS.n23 17.0005
R152 VSS.t20 VSS.n22 17.0005
R153 VSS.t13 VSS.n5 12.1524
R154 VSS.n3 VSS.t7 8.74885
R155 VSS.n3 VSS.t21 8.74785
R156 VSS.t20 VSS.n32 8.5005
R157 VSS.t20 VSS.n30 8.5005
R158 VSS.t20 VSS.n29 8.5005
R159 VSS.t20 VSS.n25 8.5005
R160 VSS.t20 VSS.n17 8.5005
R161 VSS.t20 VSS.n36 8.5005
R162 VSS.n37 VSS.t20 8.5005
R163 VSS.t20 VSS.n20 8.48603
R164 VSS.t20 VSS.n7 4.23624
R165 VSS.t20 VSS.n4 4.23624
R166 VSS.t20 VSS.n2 4.23624
R167 VSS.t20 VSS.n14 4.23618
R168 VSS.t20 VSS.n0 4.21388
R169 VSS.t20 VSS.n10 2.80801
R170 VSS.t20 VSS.n16 2.8076
R171 VSS.t20 VSS.n28 1.7005
R172 VSS.t20 VSS.n11 1.7005
R173 VSS.t20 VSS.n21 0.857213
R174 VSS.t20 VSS.n35 0.441549
R175 VSS.n35 VSS.n34 0.421573
R176 VSS.n35 VSS.n33 0.415252
R177 VSS.t20 VSS.n24 0.370826
R178 VSS.t20 VSS.n13 0.199408
R179 VSS.t20 VSS.n12 0.199408
R180 VSS.t20 VSS.n26 0.189898
R181 VSS.t20 VSS.n8 0.181084
R182 VSS.t20 VSS.n5 0.181084
R183 VSS VSS.n0 0.121338
R184 VSS.n19 VSS.n0 0.119094
R185 VSS.n16 VSS 0.0925618
R186 VSS.n10 VSS.n9 0.0906481
R187 VSS.n15 VSS.n14 0.0830159
R188 VSS.n34 VSS.n10 0.0809896
R189 VSS.n2 VSS.n1 0.0800177
R190 VSS.n4 VSS.n3 0.0737677
R191 VSS.n16 VSS.n15 0.0713118
R192 VSS.n7 VSS.n6 0.0662677
R193 VSS.n20 VSS.n19 0.0634472
R194 VSS.n9 VSS.n7 0.0627695
R195 VSS.n33 VSS.n14 0.0576427
R196 VSS.n6 VSS.n4 0.0565195
R197 VSS.n3 VSS.n2 0.0490195
R198 VSS.n20 VSS 0.0409471
R199 VSS VSS.n37 0.0305
R200 VSS.n37 VSS.n1 0.01175
R201 VSS.t20 VSS.n18 0.00588083
R202 sg13g2_dfrbp_2_1.Q_N sg13g2_dfrbp_2_1.Q_N.n0 0.0323421
R203 sg13g2_dfrbp_2_1.Q_N.n0 sg13g2_dfrbp_2_1.Q_N.t1 8.69846
R204 sg13g2_dfrbp_2_1.Q_N.n0 sg13g2_dfrbp_2_1.Q_N.t0 6.0702
R205 a_n31_n319.t0 a_n31_n319.t1 35.1591
R206 a_864_n636.t1 a_864_n636.n0 8.76769
R207 a_864_n636.n0 a_864_n636.t2 15.0661
R208 a_864_n636.n0 a_864_n636.t0 5.94842
R209 a_63_n319.t1 a_63_n319.n0 17.5293
R210 a_63_n319.n0 a_63_n319.t0 17.726
R211 a_63_n319.n0 a_63_n319.t2 15.773
R212 a_291_n441.t0 a_291_n441.n0 17.0005
R213 a_291_n441.n0 a_291_n441.t1 18.2612
R214 a_291_n441.n0 a_291_n441.t2 15.5529
R215 a_n685_n669.t1 a_n685_n669.n1 17.3368
R216 a_n685_n669.n0 a_n685_n669.t0 8.47322
R217 a_n685_n669.n0 a_n685_n669.t2 17.4516
R218 a_n685_n669.n1 a_n685_n669.n0 0.103627
R219 a_n685_n669.n1 a_n685_n669.t3 15.0435
R220 a_n907_n255.t0 a_n907_n255.t1 35.2612
R221 a_n787_n669.n0 a_n787_n669.t3 15.0005
R222 a_n787_n669.t1 a_n787_n669.n0 17.9114
R223 a_n787_n669.n1 a_n787_n669.t0 17.0005
R224 a_n787_n669.n0 a_n787_n669.n1 0.655551
R225 a_n787_n669.n1 a_n787_n669.t2 15.2176
R226 a_n1196_n676.t2 a_n1196_n676.n2 17.1232
R227 a_n1196_n676.n2 a_n1196_n676.n0 0.498937
R228 a_n1196_n676.n2 a_n1196_n676.t1 18.4279
R229 a_n1196_n676.n0 a_n1196_n676.n1 3.38628
R230 a_n1196_n676.n1 a_n1196_n676.t0 18.3531
R231 a_n1196_n676.n1 a_n1196_n676.t3 17.9378
R232 a_n1196_n676.n0 a_n1196_n676.t4 15.4204
R233 a_n1222_n712.t0 a_n1222_n712.n1 17.3305
R234 a_n1222_n712.n1 a_n1222_n712.n0 0.948441
R235 a_n1222_n712.n0 a_n1222_n712.t2 17.2651
R236 a_n1222_n712.n0 a_n1222_n712.t1 17.3352
R237 a_n1222_n712.n1 a_n1222_n712.t3 15.4436
R238 a_n1482_n242.t0 a_n1482_n242.n1 17.0005
R239 a_n1482_n242.n0 a_n1482_n242.t3 17.0005
R240 a_n1482_n242.n1 a_n1482_n242.n0 3.28463
R241 a_n1482_n242.n0 a_n1482_n242.t1 18.6222
R242 a_n1482_n242.n1 a_n1482_n242.t2 18.3191
R243 a_1402_159.t1 a_1402_159.n0 8.46601
R244 a_1402_159.n0 a_1402_159.t2 9.14806
R245 a_1402_159.n0 a_1402_159.t0 9.03604
R246 a_n31_235.t0 a_n31_235.t1 35.1591
R247 a_n907_171.t0 a_n907_171.t1 35.2643
R248 sg13g2_nand2_2_0.A.t1 sg13g2_nand2_2_0.A.n0 8.53521
R249 sg13g2_nand2_2_0.A sg13g2_nand2_2_0.A.n0 0.0326348
R250 sg13g2_nand2_2_0.A.n0 sg13g2_nand2_2_0.A.n1 18.6092
R251 sg13g2_nand2_2_0.A.n1 sg13g2_nand2_2_0.A.t2 15.0005
R252 sg13g2_nand2_2_0.A sg13g2_nand2_2_0.A.n1 0.0470385
R253 sg13g2_nand2_2_0.A.n0 sg13g2_nand2_2_0.A.t0 6.13626
R254 a_864_436.t1 a_864_436.n0 8.76769
R255 a_864_436.n0 a_864_436.t2 15.0661
R256 a_864_436.n0 a_864_436.t0 5.94842
R257 a_291_375.n0 a_291_375.t1 17.0005
R258 a_291_375.t0 a_291_375.n0 18.2612
R259 a_291_375.n0 a_291_375.t2 15.5529
R260 a_63_235.t1 a_63_235.n0 17.726
R261 a_63_235.n0 a_63_235.t2 15.773
R262 a_63_235.n0 a_63_235.t0 17.5293
R263 a_n685_502.t1 a_n685_502.n1 17.3368
R264 a_n685_502.n0 a_n685_502.t0 8.47322
R265 a_n685_502.n1 a_n685_502.n0 0.103627
R266 a_n685_502.n0 a_n685_502.t2 17.4516
R267 a_n685_502.n1 a_n685_502.t3 15.0435
R268 a_n787_415.n0 a_n787_415.t3 15.0005
R269 a_n787_415.t1 a_n787_415.n0 17.9114
R270 a_n787_415.n1 a_n787_415.t0 17.0005
R271 a_n787_415.n0 a_n787_415.n1 0.655551
R272 a_n787_415.n1 a_n787_415.t2 15.2176
R273 a_n1196_476.t1 a_n1196_476.n2 17.1232
R274 a_n1196_476.n2 a_n1196_476.n0 0.498937
R275 a_n1196_476.n2 a_n1196_476.t0 18.4279
R276 a_n1196_476.n0 a_n1196_476.n1 3.38952
R277 a_n1196_476.n1 a_n1196_476.t2 18.3531
R278 a_n1196_476.n1 a_n1196_476.t3 17.9378
R279 a_n1196_476.n0 a_n1196_476.t4 15.4204
R280 a_n1482_158.t0 a_n1482_158.n1 17.0005
R281 a_n1482_158.n1 a_n1482_158.t3 18.3191
R282 a_n1482_158.n0 a_n1482_158.t2 17.0005
R283 a_n1482_158.n1 a_n1482_158.n0 3.28463
R284 a_n1482_158.n0 a_n1482_158.t1 18.6222
R285 sg13g2_nand2_2_0.Y.t1 sg13g2_nand2_2_0.Y.n5 17.3643
R286 sg13g2_nand2_2_0.Y sg13g2_nand2_2_0.Y.n5 0.0371667
R287 sg13g2_nand2_2_0.Y.n5 sg13g2_nand2_2_0.Y.n0 0.0302917
R288 sg13g2_nand2_2_0.Y.n0 sg13g2_nand2_2_0.Y.n4 0.493208
R289 sg13g2_nand2_2_0.Y.n4 sg13g2_nand2_2_0.Y.t0 8.71106
R290 sg13g2_nand2_2_0.Y.n4 sg13g2_nand2_2_0.Y.t2 8.65606
R291 sg13g2_nand2_2_0.Y.n0 sg13g2_nand2_2_0.Y.n3 15.4883
R292 sg13g2_nand2_2_0.Y.n2 sg13g2_nand2_2_0.Y.t4 15.0005
R293 sg13g2_nand2_2_0.Y sg13g2_nand2_2_0.Y.n2 0.0972033
R294 sg13g2_nand2_2_0.Y.n3 sg13g2_nand2_2_0.Y.n2 9.55854
R295 sg13g2_nand2_2_0.Y.t4 sg13g2_nand2_2_0.Y.t3 33.4092
R296 sg13g2_nand2_2_0.Y.n1 sg13g2_nand2_2_0.Y.t6 15.0005
R297 sg13g2_nand2_2_0.Y sg13g2_nand2_2_0.Y.n1 0.0972033
R298 sg13g2_nand2_2_0.Y.n3 sg13g2_nand2_2_0.Y.n1 9.55854
R299 sg13g2_nand2_2_0.Y.t6 sg13g2_nand2_2_0.Y.t5 33.4092
R300 a_n1222_381.t0 a_n1222_381.n1 17.3352
R301 a_n1222_381.n1 a_n1222_381.t1 17.2651
R302 a_n1222_381.n1 a_n1222_381.n0 0.948441
R303 a_n1222_381.n0 a_n1222_381.t2 17.3305
R304 a_n1222_381.n0 a_n1222_381.t3 15.4436
C16 FDIV VSS 0.50967f
C17 UP VSS 1.04826f
C18 DN VSS 0.85865f
C19 FREF VSS 0.54613f
C20 VDD VSS 2.31691f
C21 sg13g2_dfrbp_2_1.Q_N VSS 0.1541f $ **FLOATING
C22 sg13g2_nand2_2_0.A VSS 0.43987f $ **FLOATING
C23 sg13g2_nand2_2_0.Y VSS 2.42533f $ **FLOATING
C24 a_n1222_381.t0 VSS 0.14293f $ **FLOATING
C25 a_n1222_381.t1 VSS 0.14442f $ **FLOATING
C26 a_n1222_381.t2 VSS 0.13342f $ **FLOATING
C27 a_n1222_381.t3 VSS 0.30435f $ **FLOATING
C28 a_n1222_381.n0 VSS 0.42693f $ **FLOATING
C29 a_n1222_381.n1 VSS 0.33437f $ **FLOATING
C30 sg13g2_nand2_2_0.Y.t1 VSS 0.16624f $ **FLOATING
C31 sg13g2_nand2_2_0.Y.n0 VSS 0.46557f $ **FLOATING
C32 sg13g2_nand2_2_0.Y.t6 VSS 1.10269f $ **FLOATING
C33 sg13g2_nand2_2_0.Y.t5 VSS 0.53103f $ **FLOATING
C34 sg13g2_nand2_2_0.Y.n1 VSS 0.10611f $ **FLOATING
C35 sg13g2_nand2_2_0.Y.t4 VSS 1.10269f $ **FLOATING
C36 sg13g2_nand2_2_0.Y.t3 VSS 0.53103f $ **FLOATING
C37 sg13g2_nand2_2_0.Y.n2 VSS 0.10611f $ **FLOATING
C38 sg13g2_nand2_2_0.Y.n3 VSS 2.07431f $ **FLOATING
C39 sg13g2_nand2_2_0.Y.t2 VSS 0.25799f $ **FLOATING
C40 sg13g2_nand2_2_0.Y.t0 VSS 0.25886f $ **FLOATING
C41 sg13g2_nand2_2_0.Y.n4 VSS 0.36516f $ **FLOATING
C42 sg13g2_nand2_2_0.Y.n5 VSS 0.1256f $ **FLOATING
C43 a_n1482_158.t0 VSS 0.18088f $ **FLOATING
C44 a_n1482_158.t2 VSS 0.16184f $ **FLOATING
C45 a_n1482_158.n0 VSS 1.05431f $ **FLOATING
C46 a_n1482_158.t1 VSS 0.16762f $ **FLOATING
C47 a_n1482_158.t3 VSS 0.17989f $ **FLOATING
C48 a_n1482_158.n1 VSS 0.97254f $ **FLOATING
C49 a_n1196_476.t1 VSS 0.19406f $ **FLOATING
C50 a_n1196_476.t4 VSS 0.25052f $ **FLOATING
C51 a_n1196_476.n0 VSS 0.51458f $ **FLOATING
C52 a_n1196_476.t3 VSS 0.27313f $ **FLOATING
C53 a_n1196_476.t2 VSS 0.27541f $ **FLOATING
C54 a_n1196_476.n1 VSS 0.82903f $ **FLOATING
C55 a_n1196_476.t0 VSS 0.27951f $ **FLOATING
C56 a_n1196_476.n2 VSS 0.5029f $ **FLOATING
C57 a_n787_415.t1 VSS 0.1555f $ **FLOATING
C58 a_n787_415.t3 VSS 0.60339f $ **FLOATING
C59 a_n787_415.n0 VSS 0.31954f $ **FLOATING
C60 a_n787_415.t0 VSS 0.22756f $ **FLOATING
C61 a_n787_415.n1 VSS 0.18098f $ **FLOATING
C62 a_n787_415.t2 VSS 0.25167f $ **FLOATING
C63 a_n685_502.t1 VSS 0.20061f $ **FLOATING
C64 a_n685_502.t3 VSS 0.28258f $ **FLOATING
C65 a_n685_502.n0 VSS 0.6344f $ **FLOATING
C66 a_n685_502.t0 VSS 0.30488f $ **FLOATING
C67 a_n685_502.t2 VSS 0.27261f $ **FLOATING
C68 a_n685_502.n1 VSS 0.34137f $ **FLOATING
C69 a_63_235.t1 VSS 0.23633f $ **FLOATING
C70 a_63_235.t0 VSS 0.15583f $ **FLOATING
C71 a_63_235.t2 VSS 0.78645f $ **FLOATING
C72 a_63_235.n0 VSS 0.44211f $ **FLOATING
C73 a_291_375.t0 VSS 0.10882f $ **FLOATING
C74 a_291_375.t1 VSS 0.1096f $ **FLOATING
C75 a_291_375.n0 VSS 0.47679f $ **FLOATING
C76 a_291_375.t2 VSS 0.21849f $ **FLOATING
C77 a_864_436.t1 VSS 0.09175f $ **FLOATING
C78 a_864_436.t2 VSS 0.30404f $ **FLOATING
C79 a_864_436.t0 VSS 0.14637f $ **FLOATING
C80 a_864_436.n0 VSS 0.34404f $ **FLOATING
C81 sg13g2_nand2_2_0.A.t1 VSS 0.12657f $ **FLOATING
C82 sg13g2_nand2_2_0.A.t0 VSS 0.20624f $ **FLOATING
C83 sg13g2_nand2_2_0.A.n0 VSS 0.50377f $ **FLOATING
C84 sg13g2_nand2_2_0.A.t2 VSS 0.31337f $ **FLOATING
C85 sg13g2_nand2_2_0.A.n1 VSS 0.1964f $ **FLOATING
C86 a_252_473.t0 VSS 0.01001f $ **FLOATING
C87 a_n907_171.t0 VSS 0.39263f $ **FLOATING
C88 a_n907_171.t1 VSS 0.4518f $ **FLOATING
C89 a_n31_235.t0 VSS 0.37594f $ **FLOATING
C90 a_n31_235.t1 VSS 0.37459f $ **FLOATING
C91 a_1402_159.t1 VSS 0.07818f $ **FLOATING
C92 a_1402_159.t0 VSS 0.073f $ **FLOATING
C93 a_1402_159.t2 VSS 0.08025f $ **FLOATING
C94 a_1402_159.n0 VSS 0.22653f $ **FLOATING
C95 a_n1482_n242.t0 VSS 0.18086f $ **FLOATING
C96 a_n1482_n242.t2 VSS 0.17987f $ **FLOATING
C97 a_n1482_n242.t3 VSS 0.16182f $ **FLOATING
C98 a_n1482_n242.n0 VSS 1.05419f $ **FLOATING
C99 a_n1482_n242.t1 VSS 0.16759f $ **FLOATING
C100 a_n1482_n242.n1 VSS 0.97242f $ **FLOATING
C101 a_n1222_n712.t0 VSS 0.13342f $ **FLOATING
C102 a_n1222_n712.t3 VSS 0.30434f $ **FLOATING
C103 a_n1222_n712.t2 VSS 0.14441f $ **FLOATING
C104 a_n1222_n712.t1 VSS 0.14293f $ **FLOATING
C105 a_n1222_n712.n0 VSS 0.33436f $ **FLOATING
C106 a_n1222_n712.n1 VSS 0.42691f $ **FLOATING
C107 a_n1196_n676.t2 VSS 0.194f $ **FLOATING
C108 a_n1196_n676.t4 VSS 0.25044f $ **FLOATING
C109 a_n1196_n676.n0 VSS 0.51464f $ **FLOATING
C110 a_n1196_n676.t3 VSS 0.27303f $ **FLOATING
C111 a_n1196_n676.t0 VSS 0.27532f $ **FLOATING
C112 a_n1196_n676.n1 VSS 0.82851f $ **FLOATING
C113 a_n1196_n676.t1 VSS 0.27942f $ **FLOATING
C114 a_n1196_n676.n2 VSS 0.50273f $ **FLOATING
C115 a_n787_n669.t1 VSS 0.15535f $ **FLOATING
C116 a_n787_n669.t3 VSS 0.60282f $ **FLOATING
C117 a_n787_n669.n0 VSS 0.31924f $ **FLOATING
C118 a_n787_n669.t0 VSS 0.22735f $ **FLOATING
C119 a_n787_n669.n1 VSS 0.18082f $ **FLOATING
C120 a_n787_n669.t2 VSS 0.25143f $ **FLOATING
C121 a_n907_n255.t0 VSS 0.39259f $ **FLOATING
C122 a_n907_n255.t1 VSS 0.45177f $ **FLOATING
C123 a_n685_n669.t1 VSS 0.20056f $ **FLOATING
C124 a_n685_n669.t3 VSS 0.28252f $ **FLOATING
C125 a_n685_n669.n0 VSS 0.63425f $ **FLOATING
C126 a_n685_n669.t0 VSS 0.30481f $ **FLOATING
C127 a_n685_n669.t2 VSS 0.27255f $ **FLOATING
C128 a_n685_n669.n1 VSS 0.34129f $ **FLOATING
C129 a_291_n441.t0 VSS 0.10852f $ **FLOATING
C130 a_291_n441.t2 VSS 0.21631f $ **FLOATING
C131 a_291_n441.t1 VSS 0.10774f $ **FLOATING
C132 a_291_n441.n0 VSS 0.47205f $ **FLOATING
C133 a_63_n319.t1 VSS 0.15421f $ **FLOATING
C134 a_63_n319.t2 VSS 0.77827f $ **FLOATING
C135 a_63_n319.n0 VSS 0.43751f $ **FLOATING
C136 a_63_n319.t0 VSS 0.23387f $ **FLOATING
C137 a_864_n636.t1 VSS 0.08468f $ **FLOATING
C138 a_864_n636.t2 VSS 0.28063f $ **FLOATING
C139 a_864_n636.t0 VSS 0.1351f $ **FLOATING
C140 a_864_n636.n0 VSS 0.31754f $ **FLOATING
C141 a_n31_n319.t0 VSS 0.37456f $ **FLOATING
C142 a_n31_n319.t1 VSS 0.37591f $ **FLOATING
C143 sg13g2_dfrbp_2_1.Q_N.t1 VSS 0.11619f $ **FLOATING
C144 sg13g2_dfrbp_2_1.Q_N.t0 VSS 0.18076f $ **FLOATING
C145 sg13g2_dfrbp_2_1.Q_N.n0 VSS 0.31316f $ **FLOATING
C146 VDD.t26 VSS 0.02706f $ **FLOATING
C147 VDD.t27 VSS 0.01303f $ **FLOATING
C148 VDD.t19 VSS 0.06466f $ **FLOATING
C149 VDD.n0 VSS 0.02672f $ **FLOATING
C150 VDD.n1 VSS 0.03845f $ **FLOATING
C151 VDD.t6 VSS 0.03662f $ **FLOATING
C152 VDD.n2 VSS 0.08117f $ **FLOATING
C153 VDD.n3 VSS 0.03961f $ **FLOATING
C154 VDD.t1 VSS 0.02802f $ **FLOATING
C155 VDD.n4 VSS 0.13669f $ **FLOATING
C156 VDD.n5 VSS 0.10808f $ **FLOATING
C157 VDD.t30 VSS 0.03654f $ **FLOATING
C158 VDD.n6 VSS 0.13159f $ **FLOATING
C159 VDD.n7 VSS 0.01551f $ **FLOATING
C160 VDD.t32 VSS 0.03894f $ **FLOATING
C161 VDD.n8 VSS 0.0586f $ **FLOATING
C162 VDD.t5 VSS 0.03543f $ **FLOATING
C163 VDD.n9 VSS 0.06547f $ **FLOATING
C164 VDD.n10 VSS 0.01678f $ **FLOATING
C165 VDD.t0 VSS 3.02477f $ **FLOATING
C166 VDD.t13 VSS 0.51016f $ **FLOATING
C167 VDD.t29 VSS 0.01303f $ **FLOATING
C168 VDD.t16 VSS 0.06466f $ **FLOATING
C169 VDD.n12 VSS 0.02672f $ **FLOATING
C170 VDD.n13 VSS 0.03848f $ **FLOATING
C171 VDD.n14 VSS 0.03961f $ **FLOATING
C172 VDD.n15 VSS 0.01354f $ **FLOATING
C173 VDD.n16 VSS 0.01567f $ **FLOATING
C174 VDD.t25 VSS 0.03832f $ **FLOATING
C175 VDD.t12 VSS 0.03909f $ **FLOATING
C176 VDD.n17 VSS 0.04274f $ **FLOATING
C177 VDD.n18 VSS 0.07397f $ **FLOATING
C178 VDD.t11 VSS 0.03631f $ **FLOATING
C179 VDD.n19 VSS 0.04718f $ **FLOATING
C180 VDD.t15 VSS 0.03543f $ **FLOATING
C181 VDD.n21 VSS 0.05749f $ **FLOATING
C182 VDD.t14 VSS 0.03543f $ **FLOATING
C183 VDD.n23 VSS 0.06385f $ **FLOATING
C184 VDD.n24 VSS 0.01678f $ **FLOATING
C185 VDD.t7 VSS 0.03894f $ **FLOATING
C186 VDD.n25 VSS 0.0586f $ **FLOATING
C187 VDD.n26 VSS 0.01551f $ **FLOATING
C188 VDD.t8 VSS 0.03655f $ **FLOATING
C189 VDD.n27 VSS 0.1314f $ **FLOATING
C190 VDD.t3 VSS 0.02802f $ **FLOATING
C191 VDD.n28 VSS 0.13689f $ **FLOATING
C192 VDD.n29 VSS 0.10803f $ **FLOATING
C193 VDD.t2 VSS 3.64656f $ **FLOATING
C194 VDD.t4 VSS 0.58716f $ **FLOATING
C195 VDD.t28 VSS 0.02706f $ **FLOATING
C196 VDD.n31 VSS 0.11165f $ **FLOATING
C197 VDD.n32 VSS 0.09438f $ **FLOATING
C198 FREF.t0 VSS 0.19559f $ **FLOATING
C199 FREF.n0 VSS 0.1443f $ **FLOATING
C200 DN.t0 VSS 0.14864f $ **FLOATING
C201 DN.t1 VSS 0.09122f $ **FLOATING
C202 DN.t2 VSS 0.22719f $ **FLOATING
C203 DN.n0 VSS 0.07168f $ **FLOATING
C204 DN.n1 VSS 0.44933f $ **FLOATING
C205 DN.n2 VSS 0.30465f $ **FLOATING
C206 UP.t0 VSS 0.15125f $ **FLOATING
C207 UP.n0 VSS 0.2542f $ **FLOATING
C208 UP.t1 VSS 0.09563f $ **FLOATING
C209 UP.n1 VSS 0.03879f $ **FLOATING
C210 FDIV.t0 VSS 0.19398f $ **FLOATING
C211 FDIV.n0 VSS 0.18368f $ **FLOATING
.ends
