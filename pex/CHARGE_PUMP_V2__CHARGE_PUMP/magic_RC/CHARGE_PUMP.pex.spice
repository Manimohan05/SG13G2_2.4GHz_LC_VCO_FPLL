* NGSPICE file created from CHARGE_PUMP.ext - technology: ihp-sg13g2

.subckt CHARGE_PUMP_PEX UP VDD VCP VBGR GND DN
X0 VCP a_n11685_3060.t61 a_n6777_3460# VDD.t0 sg13_lv_pmos ad=2.7812p pd=17.04u as=1.5542p ps=8.56u w=8.18u l=2u
X1 a_n6777_3460# a_n11685_3060.t31 VCP VDD.t0 sg13_lv_pmos ad=1.5542p pd=8.56u as=1.5542p ps=8.56u w=8.18u l=2u
X2 a_n11849_145# a_n11685_3060.t62 a_n9213_3460# VDD.t0 sg13_lv_pmos ad=2.7812p pd=17.04u as=1.5542p ps=8.56u w=8.18u l=2u
X3 a_n11685_3060.t1 a_n11685_3060.t19 a_n11649_3460# VDD.t0 sg13_lv_pmos ad=1.5542p pd=8.56u as=1.5542p ps=8.56u w=8.18u l=2u
X4 a_n11849_145# a_n11849_145# a_n11917_334# GND.t0 sg13_lv_nmos ad=1.5466p pd=8.52u as=2.7676p ps=16.96u w=8.14u l=2u
X5 a_n6777_3460# a_n11685_3060.t55 VCP VDD.t0 sg13_lv_pmos ad=1.5542p pd=8.56u as=1.5542p ps=8.56u w=8.18u l=2u
X6 a_n11849_145# a_n11685_3060.t30 a_n9213_3460# VDD.t0 sg13_lv_pmos ad=1.5542p pd=8.56u as=1.5542p ps=8.56u w=8.18u l=2u
X7 a_n9213_3460# GND.t22 VDD.t2 VDD.t0 sg13_lv_pmos ad=1.1248p pd=6.3u as=1.1248p ps=6.3u w=5.92u l=2u
X8 a_n9213_3460# a_n11685_3060.t56 a_n11849_145# VDD.t0 sg13_lv_pmos ad=1.5542p pd=8.56u as=1.5542p ps=8.56u w=8.18u l=2u
X9 a_n6777_3460# a_n11685_3060.t43 VCP VDD.t0 sg13_lv_pmos ad=1.5542p pd=8.56u as=1.5542p ps=8.56u w=8.18u l=2u
X10 a_n9131_334# a_n11849_145# VCP GND.t8 sg13_lv_nmos ad=1.5466p pd=8.52u as=1.5466p ps=8.52u w=8.14u l=2u
X11 a_n11685_3060.t1 a_n11685_3060.t7 a_n11649_3460# VDD.t0 sg13_lv_pmos ad=1.5542p pd=8.56u as=1.5542p ps=8.56u w=8.18u l=2u
X12 a_n11849_145# a_n11685_3060.t42 a_n9213_3460# VDD.t0 sg13_lv_pmos ad=1.5542p pd=8.56u as=1.5542p ps=8.56u w=8.18u l=2u
X13 VDD.t8 UP a_n6777_3460# VDD.t0 sg13_lv_pmos ad=1.1248p pd=6.3u as=1.1248p ps=6.3u w=5.92u l=2u
X14 a_n11649_3460# a_n11685_3060.t16 a_n11685_3060.t1 VDD.t0 sg13_lv_pmos ad=1.5542p pd=8.56u as=1.5542p ps=8.56u w=8.18u l=2u
X15 VCP a_n11849_145# a_n9131_334# GND.t7 sg13_lv_nmos ad=1.5466p pd=8.52u as=1.5466p ps=8.52u w=8.14u l=2u
X16 VCP a_n11685_3060.t37 a_n6777_3460# VDD.t0 sg13_lv_pmos ad=1.5542p pd=8.56u as=1.5542p ps=8.56u w=8.18u l=2u
X17 a_n6777_3460# a_n11685_3060.t35 VCP VDD.t0 sg13_lv_pmos ad=1.5542p pd=8.56u as=1.5542p ps=8.56u w=8.18u l=2u
X18 a_n11649_3460# a_n11685_3060.t10 a_n11685_3060.t1 VDD.t0 sg13_lv_pmos ad=1.5542p pd=8.56u as=1.5542p ps=8.56u w=8.18u l=2u
X19 a_n9213_3460# a_n11685_3060.t24 a_n11849_145# VDD.t0 sg13_lv_pmos ad=1.5542p pd=8.56u as=2.7812p ps=17.04u w=8.18u l=2u
X20 a_n9131_334# a_n11849_145# VCP GND.t6 sg13_lv_nmos ad=1.5466p pd=8.52u as=1.5466p ps=8.52u w=8.14u l=2u
X21 a_n6777_3460# a_n11685_3060.t59 VCP VDD.t0 sg13_lv_pmos ad=1.5542p pd=8.56u as=1.5542p ps=8.56u w=8.18u l=2u
X22 a_n9213_3460# a_n11685_3060.t48 a_n11849_145# VDD.t0 sg13_lv_pmos ad=1.5542p pd=8.56u as=1.5542p ps=8.56u w=8.18u l=2u
X23 VDD.t1 GND.t21 a_n11649_3460# VDD.t0 sg13_lv_pmos ad=1.1248p pd=6.3u as=1.1248p ps=6.3u w=5.92u l=2u
X24 VDD.t4 GND.t16 a_n9213_3460# VDD.t0 sg13_lv_pmos ad=1.1248p pd=6.3u as=2.0128p ps=12.52u w=5.92u l=2u
X25 a_n9213_3460# a_n11685_3060.t60 a_n11849_145# VDD.t0 sg13_lv_pmos ad=1.5542p pd=8.56u as=1.5542p ps=8.56u w=8.18u l=2u
X26 VCP a_n11685_3060.t29 a_n6777_3460# VDD.t0 sg13_lv_pmos ad=1.5542p pd=8.56u as=1.5542p ps=8.56u w=8.18u l=2u
X27 VCP a_n11849_145# a_n9131_334# GND.t5 sg13_lv_nmos ad=1.5466p pd=8.52u as=2.7676p ps=16.96u w=8.14u l=2u
X28 a_n11685_3060.t22 VBGR GND.t13 GND.t12 sg13_lv_nmos ad=1.326p pd=8.48u as=1.326p ps=8.48u w=3.9u l=2u
X29 VDD.t7 UP a_n6777_3460# VDD.t0 sg13_lv_pmos ad=2.0128p pd=12.52u as=1.1248p ps=6.3u w=5.92u l=2u
X30 a_n11685_3060.t1 a_n11685_3060.t3 a_n11649_3460# VDD.t0 sg13_lv_pmos ad=1.5542p pd=8.56u as=1.5542p ps=8.56u w=8.18u l=2u
X31 a_n11685_3060.t1 a_n11685_3060.t13 a_n11649_3460# VDD.t0 sg13_lv_pmos ad=1.5542p pd=8.56u as=1.5542p ps=8.56u w=8.18u l=2u
X32 a_n11649_3460# a_n11685_3060.t14 a_n11685_3060.t1 VDD.t0 sg13_lv_pmos ad=1.5542p pd=8.56u as=1.5542p ps=8.56u w=8.18u l=2u
X33 VCP a_n11685_3060.t41 a_n6777_3460# VDD.t0 sg13_lv_pmos ad=1.5542p pd=8.56u as=1.5542p ps=8.56u w=8.18u l=2u
X34 a_n9213_3460# a_n11685_3060.t40 a_n11849_145# VDD.t0 sg13_lv_pmos ad=1.5542p pd=8.56u as=1.5542p ps=8.56u w=8.18u l=2u
X35 a_n6777_3460# UP VDD.t10 VDD.t0 sg13_lv_pmos ad=1.1248p pd=6.3u as=1.1248p ps=6.3u w=5.92u l=2u
X36 VCP a_n11685_3060.t53 a_n6777_3460# VDD.t0 sg13_lv_pmos ad=1.5542p pd=8.56u as=1.5542p ps=8.56u w=8.18u l=2u
X37 a_n9213_3460# a_n11685_3060.t28 a_n11849_145# VDD.t0 sg13_lv_pmos ad=1.5542p pd=8.56u as=1.5542p ps=8.56u w=8.18u l=2u
X38 a_n11849_145# a_n11685_3060.t54 a_n9213_3460# VDD.t0 sg13_lv_pmos ad=1.5542p pd=8.56u as=1.5542p ps=8.56u w=8.18u l=2u
X39 a_n9213_3460# a_n11685_3060.t52 a_n11849_145# VDD.t0 sg13_lv_pmos ad=1.5542p pd=8.56u as=1.5542p ps=8.56u w=8.18u l=2u
X40 a_n11685_3060.t1 a_n11685_3060.t17 a_n11649_3460# VDD.t0 sg13_lv_pmos ad=1.5542p pd=8.56u as=1.5542p ps=8.56u w=8.18u l=2u
X41 VDD.t13 GND.t25 a_n11649_3460# VDD.t0 sg13_lv_pmos ad=2.0128p pd=12.52u as=1.1248p ps=6.3u w=5.92u l=2u
X42 a_n6777_3460# a_n11685_3060.t23 VCP VDD.t0 sg13_lv_pmos ad=1.5542p pd=8.56u as=2.7812p ps=17.04u w=8.18u l=2u
X43 a_n11849_145# a_n11849_145# a_n11917_334# GND.t4 sg13_lv_nmos ad=2.7676p pd=16.96u as=1.5466p ps=8.52u w=8.14u l=2u
X44 a_n6777_3460# a_n11685_3060.t47 VCP VDD.t0 sg13_lv_pmos ad=1.5542p pd=8.56u as=1.5542p ps=8.56u w=8.18u l=2u
X45 a_n11649_3460# GND.t19 VDD.t3 VDD.t0 sg13_lv_pmos ad=1.1248p pd=6.3u as=1.1248p ps=6.3u w=5.92u l=2u
X46 a_n11685_3060.t1 a_n11685_3060.t0 a_n11649_3460# VDD.t0 sg13_lv_pmos ad=2.7812p pd=17.04u as=1.5542p ps=8.56u w=8.18u l=2u
X47 a_n11849_145# a_n11685_3060.t46 a_n9213_3460# VDD.t0 sg13_lv_pmos ad=1.5542p pd=8.56u as=1.5542p ps=8.56u w=8.18u l=2u
X48 a_n11685_3060.t1 a_n11685_3060.t11 a_n11649_3460# VDD.t0 sg13_lv_pmos ad=1.5542p pd=8.56u as=1.5542p ps=8.56u w=8.18u l=2u
X49 a_n11849_145# a_n11685_3060.t34 a_n9213_3460# VDD.t0 sg13_lv_pmos ad=1.5542p pd=8.56u as=1.5542p ps=8.56u w=8.18u l=2u
X50 a_n11917_334# VDD.t16 GND.t11 GND.t10 sg13_lv_nmos ad=2.04p pd=12.68u as=2.04p ps=12.68u w=6u l=2u
X51 a_n6777_3460# UP VDD.t8 VDD.t0 sg13_lv_pmos ad=1.1248p pd=6.3u as=1.1248p ps=6.3u w=5.92u l=2u
X52 a_n11917_334# a_n11849_145# a_n11849_145# GND.t3 sg13_lv_nmos ad=1.5466p pd=8.52u as=1.5466p ps=8.52u w=8.14u l=2u
X53 a_n11649_3460# a_n11685_3060.t4 a_n11685_3060.t1 VDD.t0 sg13_lv_pmos ad=1.5542p pd=8.56u as=1.5542p ps=8.56u w=8.18u l=2u
X54 a_n6777_3460# a_n11685_3060.t39 VCP VDD.t0 sg13_lv_pmos ad=1.5542p pd=8.56u as=1.5542p ps=8.56u w=8.18u l=2u
X55 a_n9131_334# DN GND.t15 GND.t14 sg13_lv_nmos ad=2.04p pd=12.68u as=2.04p ps=12.68u w=6u l=2u
X56 a_n6777_3460# a_n11685_3060.t27 VCP VDD.t0 sg13_lv_pmos ad=1.5542p pd=8.56u as=1.5542p ps=8.56u w=8.18u l=2u
X57 a_n11849_145# a_n11685_3060.t26 a_n9213_3460# VDD.t0 sg13_lv_pmos ad=1.5542p pd=8.56u as=1.5542p ps=8.56u w=8.18u l=2u
X58 a_n11649_3460# a_n11685_3060.t20 a_n11685_3060.t21 VDD.t0 sg13_lv_pmos ad=1.5542p pd=8.56u as=2.7812p ps=17.04u w=8.18u l=2u
X59 a_n11649_3460# a_n11685_3060.t8 a_n11685_3060.t1 VDD.t0 sg13_lv_pmos ad=1.5542p pd=8.56u as=1.5542p ps=8.56u w=8.18u l=2u
X60 a_n11849_145# a_n11849_145# a_n11917_334# GND.t2 sg13_lv_nmos ad=1.5466p pd=8.52u as=1.5466p ps=8.52u w=8.14u l=2u
X61 a_n11649_3460# GND.t23 VDD.t1 VDD.t0 sg13_lv_pmos ad=1.1248p pd=6.3u as=1.1248p ps=6.3u w=5.92u l=2u
X62 VDD.t2 GND.t20 a_n9213_3460# VDD.t0 sg13_lv_pmos ad=1.1248p pd=6.3u as=1.1248p ps=6.3u w=5.92u l=2u
X63 a_n6777_3460# a_n11685_3060.t51 VCP VDD.t0 sg13_lv_pmos ad=1.5542p pd=8.56u as=1.5542p ps=8.56u w=8.18u l=2u
X64 a_n11917_334# a_n11849_145# a_n11849_145# GND.t1 sg13_lv_nmos ad=1.5466p pd=8.52u as=1.5466p ps=8.52u w=8.14u l=2u
X65 a_n11849_145# a_n11685_3060.t50 a_n9213_3460# VDD.t0 sg13_lv_pmos ad=1.5542p pd=8.56u as=1.5542p ps=8.56u w=8.18u l=2u
X66 VDD.t10 UP a_n6777_3460# VDD.t0 sg13_lv_pmos ad=1.1248p pd=6.3u as=2.0128p ps=12.52u w=5.92u l=2u
X67 a_n11649_3460# a_n11685_3060.t2 a_n11685_3060.t1 VDD.t0 sg13_lv_pmos ad=1.5542p pd=8.56u as=1.5542p ps=8.56u w=8.18u l=2u
X68 a_n11649_3460# a_n11685_3060.t12 a_n11685_3060.t1 VDD.t0 sg13_lv_pmos ad=1.5542p pd=8.56u as=1.5542p ps=8.56u w=8.18u l=2u
X69 VCP a_n11685_3060.t45 a_n6777_3460# VDD.t0 sg13_lv_pmos ad=1.5542p pd=8.56u as=1.5542p ps=8.56u w=8.18u l=2u
X70 VCP a_n11685_3060.t33 a_n6777_3460# VDD.t0 sg13_lv_pmos ad=1.5542p pd=8.56u as=1.5542p ps=8.56u w=8.18u l=2u
X71 a_n9213_3460# a_n11685_3060.t32 a_n11849_145# VDD.t0 sg13_lv_pmos ad=1.5542p pd=8.56u as=1.5542p ps=8.56u w=8.18u l=2u
X72 a_n11649_3460# a_n11685_3060.t18 a_n11685_3060.t1 VDD.t0 sg13_lv_pmos ad=1.5542p pd=8.56u as=1.5542p ps=8.56u w=8.18u l=2u
X73 VCP a_n11849_145# a_n9131_334# GND.t9 sg13_lv_nmos ad=2.7676p pd=16.96u as=1.5466p ps=8.52u w=8.14u l=2u
X74 VCP a_n11685_3060.t57 a_n6777_3460# VDD.t0 sg13_lv_pmos ad=1.5542p pd=8.56u as=1.5542p ps=8.56u w=8.18u l=2u
X75 a_n11649_3460# a_n11685_3060.t6 a_n11685_3060.t1 VDD.t0 sg13_lv_pmos ad=1.5542p pd=8.56u as=1.5542p ps=8.56u w=8.18u l=2u
X76 a_n9213_3460# a_n11685_3060.t44 a_n11849_145# VDD.t0 sg13_lv_pmos ad=1.5542p pd=8.56u as=1.5542p ps=8.56u w=8.18u l=2u
X77 VDD.t14 GND.t24 a_n9213_3460# VDD.t0 sg13_lv_pmos ad=2.0128p pd=12.52u as=1.1248p ps=6.3u w=5.92u l=2u
X78 VDD.t3 GND.t17 a_n11649_3460# VDD.t0 sg13_lv_pmos ad=1.1248p pd=6.3u as=2.0128p ps=12.52u w=5.92u l=2u
X79 a_n11849_145# a_n11685_3060.t58 a_n9213_3460# VDD.t0 sg13_lv_pmos ad=1.5542p pd=8.56u as=1.5542p ps=8.56u w=8.18u l=2u
X80 VCP a_n11685_3060.t25 a_n6777_3460# VDD.t0 sg13_lv_pmos ad=1.5542p pd=8.56u as=1.5542p ps=8.56u w=8.18u l=2u
X81 a_n9213_3460# GND.t18 VDD.t4 VDD.t0 sg13_lv_pmos ad=1.1248p pd=6.3u as=1.1248p ps=6.3u w=5.92u l=2u
X82 a_n11685_3060.t1 a_n11685_3060.t5 a_n11649_3460# VDD.t0 sg13_lv_pmos ad=1.5542p pd=8.56u as=1.5542p ps=8.56u w=8.18u l=2u
X83 a_n11685_3060.t1 a_n11685_3060.t9 a_n11649_3460# VDD.t0 sg13_lv_pmos ad=1.5542p pd=8.56u as=1.5542p ps=8.56u w=8.18u l=2u
X84 a_n11849_145# a_n11685_3060.t38 a_n9213_3460# VDD.t0 sg13_lv_pmos ad=1.5542p pd=8.56u as=1.5542p ps=8.56u w=8.18u l=2u
X85 a_n9213_3460# a_n11685_3060.t36 a_n11849_145# VDD.t0 sg13_lv_pmos ad=1.5542p pd=8.56u as=1.5542p ps=8.56u w=8.18u l=2u
X86 a_n11685_3060.t1 a_n11685_3060.t15 a_n11649_3460# VDD.t0 sg13_lv_pmos ad=1.5542p pd=8.56u as=1.5542p ps=8.56u w=8.18u l=2u
X87 VCP a_n11685_3060.t49 a_n6777_3460# VDD.t0 sg13_lv_pmos ad=1.5542p pd=8.56u as=1.5542p ps=8.56u w=8.18u l=2u
C0 a_n6777_3460# UP 2.8409f
C1 VCP a_n9213_3460# 0.02343f
C2 a_n9213_3460# VDD 4.36533f
C3 a_n11649_3460# VDD 4.45731f
C4 a_n9213_3460# a_n11849_145# 2.03006f
C5 a_n11649_3460# a_n11849_145# 0.03156f
C6 VBGR VDD 0.09067f
C7 VCP VDD 3.47823f
C8 VCP a_n11849_145# 4.15245f
C9 VCP a_n9131_334# 0.41839f
C10 a_n11849_145# VDD 3.32824f
C11 a_n9131_334# a_n11849_145# 3.43032f
C12 VCP a_n6777_3460# 2.03096f
C13 a_n6777_3460# VDD 5.98713f
C14 a_n11917_334# VDD 0.4943f
C15 a_n11917_334# a_n11849_145# 3.74961f
C16 a_n11917_334# a_n9131_334# 0.0154f
C17 DN VDD 0.02373f
C18 DN a_n9131_334# 0.48191f
C19 UP VDD 12.0856f
R0 VDD.n2 VDD.n0 10.2629
R1 VDD.n3 VDD.n459 20.5485
R2 VDD.n4 VDD.n2 0.0252317
R3 VDD.n107 VDD.n21 8.46995
R4 VDD.n21 VDD.n293 17.0005
R5 VDD.n21 VDD.n297 17.0005
R6 VDD.n21 VDD.n53 8.46995
R7 VDD.n21 VDD.n295 17.0005
R8 VDD.n21 VDD.n296 17.0005
R9 VDD.n27 VDD.n28 0.0631056
R10 VDD.n21 VDD.n28 8.46995
R11 VDD.n21 VDD.n299 17.0005
R12 VDD.n21 VDD.n18 5.62815
R13 VDD.n21 VDD.n298 17.0005
R14 VDD.n21 VDD.n302 17.0005
R15 VDD.n26 VDD.n21 8.46995
R16 VDD.n21 VDD.n300 17.0005
R17 VDD.n52 VDD.n21 8.46995
R18 VDD.n21 VDD.n301 17.0005
R19 VDD.n21 VDD.n305 17.0005
R20 VDD.n21 VDD.n306 17.0005
R21 VDD.n16 VDD.n21 5.62815
R22 VDD.n21 VDD.n307 17.0005
R23 VDD.n21 VDD.n13 5.62815
R24 VDD.n11 VDD.n10 0.0631056
R25 VDD.n21 VDD.n11 8.46995
R26 VDD.n21 VDD.n189 17.0005
R27 VDD.n21 VDD.n8 5.62815
R28 VDD.n21 VDD.n187 17.0005
R29 VDD.n21 VDD.n185 17.0005
R30 VDD.n21 VDD.n183 17.0005
R31 VDD.n21 VDD.n181 17.0005
R32 VDD.n21 VDD.n108 8.46995
R33 VDD.n21 VDD.n180 17.0005
R34 VDD.n21 VDD.n178 17.0005
R35 VDD.n109 VDD.n21 8.46995
R36 VDD.n21 VDD.n177 17.0005
R37 VDD.n21 VDD.n175 17.0005
R38 VDD.n21 VDD.n174 17.0005
R39 VDD.n21 VDD.n172 17.0005
R40 VDD.n21 VDD.n110 8.46995
R41 VDD.n21 VDD.n171 17.0005
R42 VDD.n21 VDD.n169 17.0005
R43 VDD.n21 VDD.n167 17.0005
R44 VDD.n336 VDD.t0 17.0005
R45 VDD.n334 VDD.t0 17.0005
R46 VDD.n330 VDD.t0 17.0005
R47 VDD.n326 VDD.t0 17.0005
R48 VDD.n322 VDD.t0 17.0005
R49 VDD.t0 VDD.n105 1.32551
R50 VDD.n454 VDD.t0 17.0005
R51 VDD.n450 VDD.t0 17.0005
R52 VDD.n446 VDD.t0 17.0005
R53 VDD.n442 VDD.t0 17.0005
R54 VDD.n440 VDD.t0 17.0005
R55 VDD.n436 VDD.t0 17.0005
R56 VDD.n432 VDD.t0 17.0005
R57 VDD.n428 VDD.t0 17.0005
R58 VDD.n424 VDD.t0 17.0005
R59 VDD.n420 VDD.t0 17.0005
R60 VDD.n416 VDD.t0 17.0005
R61 VDD.n412 VDD.t0 17.0005
R62 VDD.n408 VDD.t0 17.0005
R63 VDD.n404 VDD.t0 17.0005
R64 VDD.n402 VDD.t0 17.0005
R65 VDD.n398 VDD.t0 17.0005
R66 VDD.n394 VDD.t0 17.0005
R67 VDD.n390 VDD.t0 17.0005
R68 VDD.n386 VDD.t0 17.0005
R69 VDD.n382 VDD.t0 17.0005
R70 VDD.n378 VDD.t0 17.0005
R71 VDD.n374 VDD.t0 17.0005
R72 VDD.n372 VDD.t0 17.0005
R73 VDD.n368 VDD.t0 17.0005
R74 VDD.n364 VDD.t0 17.0005
R75 VDD.n360 VDD.t0 17.0005
R76 VDD.n356 VDD.t0 17.0005
R77 VDD.n352 VDD.t0 17.0005
R78 VDD.n348 VDD.t0 17.0005
R79 VDD.n344 VDD.t0 17.0005
R80 VDD.n340 VDD.t0 17.0005
R81 VDD.n21 VDD.n273 17.0005
R82 VDD.n21 VDD.n272 17.0005
R83 VDD.n21 VDD.n271 17.0005
R84 VDD.n21 VDD.n270 17.0005
R85 VDD.n21 VDD.n269 17.0005
R86 VDD.n21 VDD.n268 17.0005
R87 VDD.n21 VDD.n267 17.0005
R88 VDD.n21 VDD.n266 17.0005
R89 VDD.n21 VDD.n265 17.0005
R90 VDD.n21 VDD.n264 17.0005
R91 VDD.n21 VDD.n263 17.0005
R92 VDD.n21 VDD.n262 17.0005
R93 VDD.n21 VDD.n261 17.0005
R94 VDD.n21 VDD.n260 17.0005
R95 VDD.n21 VDD.n259 17.0005
R96 VDD.n21 VDD.n258 17.0005
R97 VDD.n21 VDD.n238 17.0005
R98 VDD.n21 VDD.n237 17.0005
R99 VDD.n21 VDD.n236 17.0005
R100 VDD.n21 VDD.n235 17.0005
R101 VDD.n21 VDD.n234 17.0005
R102 VDD.n21 VDD.n233 17.0005
R103 VDD.n21 VDD.n232 17.0005
R104 VDD.n21 VDD.n231 17.0005
R105 VDD.n21 VDD.n230 17.0005
R106 VDD.n21 VDD.n229 17.0005
R107 VDD.n21 VDD.n228 17.0005
R108 VDD.n21 VDD.n227 17.0005
R109 VDD.n21 VDD.n226 17.0005
R110 VDD.n21 VDD.n225 17.0005
R111 VDD.n21 VDD.n224 17.0005
R112 VDD.n21 VDD.n206 17.0005
R113 VDD.n21 VDD.n205 17.0005
R114 VDD.n21 VDD.n204 17.0005
R115 VDD.n21 VDD.n203 17.0005
R116 VDD.n21 VDD.n202 17.0005
R117 VDD.n21 VDD.n201 17.0005
R118 VDD.n21 VDD.n200 17.0005
R119 VDD.n21 VDD.n199 17.0005
R120 VDD.n21 VDD.n198 17.0005
R121 VDD.n21 VDD.n197 17.0005
R122 VDD.n21 VDD.n196 17.0005
R123 VDD.n21 VDD.n195 17.0005
R124 VDD.n21 VDD.n194 17.0005
R125 VDD.n21 VDD.n193 17.0005
R126 VDD.n21 VDD.n192 17.0005
R127 VDD.n21 VDD.n22 1.29653
R128 VDD.t7 VDD.n37 17.0005
R129 VDD.n70 VDD.n69 0.120467
R130 VDD.t7 VDD.n70 8.44127
R131 VDD.n67 VDD.n66 0.120467
R132 VDD.t7 VDD.n67 8.44127
R133 VDD.n59 VDD.n63 0.120467
R134 VDD.t7 VDD.n59 8.44127
R135 VDD.n54 VDD.n58 0.120467
R136 VDD.t7 VDD.n54 8.44127
R137 VDD.n30 VDD.n36 0.120467
R138 VDD.t7 VDD.n30 8.44127
R139 VDD.n44 VDD.n43 0.120467
R140 VDD.t14 VDD.n44 8.44127
R141 VDD.n41 VDD.n40 0.120467
R142 VDD.t14 VDD.n41 8.44127
R143 VDD.n87 VDD.n86 0.120467
R144 VDD.t14 VDD.n87 8.44127
R145 VDD.n83 VDD.n82 0.120467
R146 VDD.t14 VDD.n83 8.44127
R147 VDD.t14 VDD.n246 17.0005
R148 VDD.n78 VDD.n254 0.120467
R149 VDD.t14 VDD.n78 8.44127
R150 VDD.n71 VDD.n77 0.120467
R151 VDD.t14 VDD.n71 8.44127
R152 VDD.n51 VDD.n50 0.120467
R153 VDD.t13 VDD.n51 8.44127
R154 VDD.n48 VDD.n47 0.120467
R155 VDD.t13 VDD.n48 8.44127
R156 VDD.n104 VDD.n103 0.120467
R157 VDD.t13 VDD.n104 8.44127
R158 VDD.n100 VDD.n99 0.120467
R159 VDD.t13 VDD.n100 8.44127
R160 VDD.n92 VDD.n96 0.120467
R161 VDD.t13 VDD.n92 8.44127
R162 VDD.t13 VDD.n91 17.0005
R163 VDD.n25 VDD.n21 0.121427
R164 VDD.n21 VDD.n294 8.46995
R165 VDD.n21 VDD.n191 8.46995
R166 VDD.n21 VDD.n303 8.46995
R167 VDD.n21 VDD.n190 8.46995
R168 VDD.n21 VDD.n304 8.46995
R169 VDD.n21 VDD.n308 8.46995
R170 VDD.n21 VDD.n188 8.46995
R171 VDD.n21 VDD.n186 8.46995
R172 VDD.n21 VDD.n184 8.46995
R173 VDD.n21 VDD.n182 8.46995
R174 VDD.n21 VDD.n179 8.46995
R175 VDD.n21 VDD.n176 8.46995
R176 VDD.n21 VDD.n173 8.46995
R177 VDD.n21 VDD.n170 8.46995
R178 VDD.n21 VDD.n168 8.46995
R179 VDD.n338 VDD.t0 8.46995
R180 VDD.n332 VDD.t0 8.46995
R181 VDD.n324 VDD.t0 8.46995
R182 VDD.n452 VDD.t0 8.46995
R183 VDD.n444 VDD.t0 8.46995
R184 VDD.n438 VDD.t0 8.46995
R185 VDD.n430 VDD.t0 8.46995
R186 VDD.n422 VDD.t0 8.46995
R187 VDD.n414 VDD.t0 8.46995
R188 VDD.n406 VDD.t0 8.46995
R189 VDD.n400 VDD.t0 8.46995
R190 VDD.n392 VDD.t0 8.46995
R191 VDD.n384 VDD.t0 8.46995
R192 VDD.n376 VDD.t0 8.46995
R193 VDD.n370 VDD.t0 8.46995
R194 VDD.n362 VDD.t0 8.46995
R195 VDD.n354 VDD.t0 8.46995
R196 VDD.n346 VDD.t0 8.46995
R197 VDD.n328 VDD.t0 8.46995
R198 VDD.n320 VDD.t0 8.46995
R199 VDD.n456 VDD.t0 8.46995
R200 VDD.n448 VDD.t0 8.46995
R201 VDD.n434 VDD.t0 8.46995
R202 VDD.n426 VDD.t0 8.46995
R203 VDD.n418 VDD.t0 8.46995
R204 VDD.n410 VDD.t0 8.46995
R205 VDD.n396 VDD.t0 8.46995
R206 VDD.n388 VDD.t0 8.46995
R207 VDD.n380 VDD.t0 8.46995
R208 VDD.n366 VDD.t0 8.46995
R209 VDD.n358 VDD.t0 8.46995
R210 VDD.n350 VDD.t0 8.46995
R211 VDD.n342 VDD.t0 8.46995
R212 VDD.n221 VDD.t7 8.44468
R213 VDD.n255 VDD.t14 8.44383
R214 VDD.n291 VDD.t13 8.44383
R215 VDD.t7 VDD.n214 8.44127
R216 VDD.t7 VDD.n219 8.44127
R217 VDD.t14 VDD.n250 8.44127
R218 VDD.t13 VDD.n284 8.44127
R219 VDD.t13 VDD.n289 8.44127
R220 VDD.n274 VDD.n29 0.590269
R221 VDD.n274 VDD.n23 5.11825
R222 VDD.n208 VDD.t10 4.75354
R223 VDD.n240 VDD.t4 4.75133
R224 VDD.n276 VDD.t3 4.75091
R225 VDD.n37 VDD.n208 2.76883
R226 VDD.n43 VDD.n240 2.76883
R227 VDD.n50 VDD.n276 2.76883
R228 VDD.n460 VDD.n112 2.29168
R229 VDD.n465 VDD.n112 2.26579
R230 VDD.n462 VDD.n3 2.25984
R231 VDD.n459 VDD.n115 2.25984
R232 VDD.n208 VDD.t8 2.25976
R233 VDD.n276 VDD.t1 2.25775
R234 VDD.n240 VDD.t2 2.25743
R235 VDD.n461 VDD.t16 2.2505
R236 VDD.n113 VDD.n111 2.2505
R237 VDD.n467 VDD.n466 2.2505
R238 VDD.n462 VDD.n461 2.2505
R239 VDD.n463 VDD.n113 2.2505
R240 VDD.n466 VDD.n114 2.2505
R241 VDD.n465 VDD.n464 2.2505
R242 VDD.n4 VDD.n5 1.11866
R243 VDD.n5 VDD.n114 0.0156729
R244 VDD.n1 VDD.n23 0.751455
R245 VDD.n24 VDD.n115 2.31554
R246 VDD.n21 VDD.n29 0.895277
R247 VDD.t0 VDD.n106 1.39592
R248 VDD.n21 VDD.n20 1.25482
R249 VDD.n256 VDD.n255 1.09505
R250 VDD.n292 VDD.n291 1.09505
R251 VDD.n222 VDD.n221 1.09335
R252 VDD.n21 VDD.n257 1.07402
R253 VDD.n21 VDD.n223 1.07389
R254 VDD.n37 VDD.n22 0.983118
R255 VDD.n32 VDD.n207 0.97675
R256 VDD.n33 VDD.n31 0.97675
R257 VDD.n36 VDD.n35 0.97675
R258 VDD.n34 VDD.n55 0.97675
R259 VDD.n58 VDD.n57 0.97675
R260 VDD.n56 VDD.n60 0.97675
R261 VDD.n63 VDD.n62 0.97675
R262 VDD.n212 VDD.n211 0.97675
R263 VDD.n66 VDD.n65 0.97675
R264 VDD.n64 VDD.n209 0.97675
R265 VDD.n69 VDD.n68 0.97675
R266 VDD.n61 VDD.n220 0.97675
R267 VDD.n218 VDD.n215 0.97675
R268 VDD.n217 VDD.n216 0.97675
R269 VDD.n213 VDD.n210 0.97675
R270 VDD.n43 VDD.n42 0.97675
R271 VDD.n73 VDD.n239 0.97675
R272 VDD.n74 VDD.n72 0.97675
R273 VDD.n77 VDD.n76 0.97675
R274 VDD.n75 VDD.n79 0.97675
R275 VDD.n245 VDD.n244 0.97675
R276 VDD.n82 VDD.n81 0.97675
R277 VDD.n80 VDD.n243 0.97675
R278 VDD.n86 VDD.n85 0.97675
R279 VDD.n84 VDD.n242 0.97675
R280 VDD.n40 VDD.n39 0.97675
R281 VDD.n38 VDD.n241 0.97675
R282 VDD.n254 VDD.n251 0.97675
R283 VDD.n253 VDD.n252 0.97675
R284 VDD.n249 VDD.n248 0.97675
R285 VDD.n247 VDD.n246 0.97675
R286 VDD.n50 VDD.n49 0.97675
R287 VDD.n90 VDD.n275 0.97675
R288 VDD.n91 VDD.n89 0.97675
R289 VDD.n88 VDD.n93 0.97675
R290 VDD.n96 VDD.n95 0.97675
R291 VDD.n282 VDD.n281 0.97675
R292 VDD.n99 VDD.n98 0.97675
R293 VDD.n97 VDD.n279 0.97675
R294 VDD.n103 VDD.n102 0.97675
R295 VDD.n101 VDD.n278 0.97675
R296 VDD.n47 VDD.n46 0.97675
R297 VDD.n45 VDD.n277 0.97675
R298 VDD.n94 VDD.n290 0.97675
R299 VDD.n288 VDD.n285 0.97675
R300 VDD.n287 VDD.n286 0.97675
R301 VDD.n283 VDD.n280 0.97675
R302 VDD.n42 VDD.n223 0.702068
R303 VDD.n257 VDD.n256 0.701798
R304 VDD.n49 VDD.n257 0.697812
R305 VDD.n223 VDD.n222 0.697747
R306 VDD.n292 VDD.n29 0.787926
R307 VDD.n458 VDD.n105 0.489106
R308 VDD.n319 VDD.n116 0.48175
R309 VDD.n321 VDD.n318 0.48175
R310 VDD.n323 VDD.n317 0.48175
R311 VDD.n325 VDD.n316 0.48175
R312 VDD.n327 VDD.n315 0.48175
R313 VDD.n329 VDD.n314 0.48175
R314 VDD.n331 VDD.n313 0.48175
R315 VDD.n333 VDD.n312 0.48175
R316 VDD.n335 VDD.n311 0.48175
R317 VDD.n106 VDD.n20 0.496461
R318 VDD.n457 VDD.n19 0.48175
R319 VDD.n455 VDD.n117 0.48175
R320 VDD.n453 VDD.n118 0.48175
R321 VDD.n451 VDD.n119 0.48175
R322 VDD.n449 VDD.n120 0.48175
R323 VDD.n447 VDD.n121 0.48175
R324 VDD.n445 VDD.n122 0.48175
R325 VDD.n443 VDD.n27 0.48175
R326 VDD.n441 VDD.n123 0.48175
R327 VDD.n437 VDD.n125 0.48175
R328 VDD.n435 VDD.n17 0.48175
R329 VDD.n433 VDD.n126 0.48175
R330 VDD.n431 VDD.n127 0.48175
R331 VDD.n429 VDD.n128 0.48175
R332 VDD.n427 VDD.n129 0.48175
R333 VDD.n425 VDD.n130 0.48175
R334 VDD.n423 VDD.n131 0.48175
R335 VDD.n421 VDD.n132 0.48175
R336 VDD.n419 VDD.n133 0.48175
R337 VDD.n417 VDD.n134 0.48175
R338 VDD.n415 VDD.n135 0.48175
R339 VDD.n413 VDD.n136 0.48175
R340 VDD.n411 VDD.n14 0.48175
R341 VDD.n409 VDD.n15 0.48175
R342 VDD.n407 VDD.n137 0.48175
R343 VDD.n403 VDD.n139 0.48175
R344 VDD.n401 VDD.n12 0.48175
R345 VDD.n399 VDD.n9 0.48175
R346 VDD.n397 VDD.n10 0.48175
R347 VDD.n395 VDD.n140 0.48175
R348 VDD.n391 VDD.n142 0.48175
R349 VDD.n389 VDD.n7 0.48175
R350 VDD.n387 VDD.n6 0.48175
R351 VDD.n385 VDD.n143 0.48175
R352 VDD.n383 VDD.n144 0.48175
R353 VDD.n381 VDD.n145 0.48175
R354 VDD.n379 VDD.n146 0.48175
R355 VDD.n377 VDD.n147 0.48175
R356 VDD.n375 VDD.n148 0.48175
R357 VDD.n373 VDD.n149 0.48175
R358 VDD.n371 VDD.n150 0.48175
R359 VDD.n369 VDD.n151 0.48175
R360 VDD.n367 VDD.n152 0.48175
R361 VDD.n365 VDD.n153 0.48175
R362 VDD.n363 VDD.n154 0.48175
R363 VDD.n361 VDD.n155 0.48175
R364 VDD.n357 VDD.n157 0.48175
R365 VDD.n355 VDD.n158 0.48175
R366 VDD.n353 VDD.n159 0.48175
R367 VDD.n351 VDD.n160 0.48175
R368 VDD.n349 VDD.n161 0.48175
R369 VDD.n347 VDD.n162 0.48175
R370 VDD.n345 VDD.n163 0.48175
R371 VDD.n343 VDD.n164 0.48175
R372 VDD.n341 VDD.n165 0.48175
R373 VDD.n359 VDD.n156 0.48175
R374 VDD.n393 VDD.n141 0.48175
R375 VDD.n405 VDD.n138 0.48175
R376 VDD.n439 VDD.n124 0.48175
R377 VDD.n337 VDD.n310 0.48175
R378 VDD.n339 VDD.n166 0.475767
R379 VDD.n24 VDD.n458 1.45682
R380 VDD.n25 VDD.n309 1.15075
R381 VDD.n274 VDD.n25 1.38273
R382 VDD.n63 VDD.n61 0.241125
R383 VDD.n218 VDD.n217 0.241125
R384 VDD.n213 VDD.n212 0.241125
R385 VDD.n75 VDD.n78 0.120467
R386 VDD.n254 VDD.n253 0.241125
R387 VDD.n249 VDD.n246 0.241125
R388 VDD.n246 VDD.n245 0.241125
R389 VDD.n96 VDD.n94 0.241125
R390 VDD.n288 VDD.n287 0.241125
R391 VDD.n283 VDD.n282 0.241125
R392 VDD.n66 VDD.n64 0.237688
R393 VDD.n82 VDD.n80 0.237688
R394 VDD.n86 VDD.n84 0.237688
R395 VDD.n99 VDD.n97 0.237688
R396 VDD.n103 VDD.n101 0.237688
R397 VDD.n40 VDD.n38 0.23425
R398 VDD.n47 VDD.n45 0.23425
R399 VDD.n10 VDD.n9 0.1765
R400 VDD.n69 VDD.n37 0.244562
R401 VDD.n88 VDD.n92 0.120467
R402 VDD.n91 VDD.n88 0.241125
R403 VDD.n91 VDD.n90 0.241125
R404 VDD.n77 VDD.n75 0.241125
R405 VDD.n74 VDD.n71 0.120467
R406 VDD.n74 VDD.n73 0.241125
R407 VDD.n56 VDD.n59 0.120467
R408 VDD.n58 VDD.n56 0.241125
R409 VDD.n34 VDD.n54 0.120467
R410 VDD.n36 VDD.n34 0.241125
R411 VDD.n33 VDD.n30 0.120467
R412 VDD.n33 VDD.n32 0.241125
R413 VDD.n84 VDD.n41 0.127342
R414 VDD.n38 VDD.n44 0.127342
R415 VDD.n101 VDD.n48 0.127342
R416 VDD.n45 VDD.n51 0.127342
R417 VDD.n212 VDD.n67 0.123905
R418 VDD.n64 VDD.n70 0.123905
R419 VDD.n245 VDD.n83 0.123905
R420 VDD.n80 VDD.n87 0.123905
R421 VDD.n282 VDD.n100 0.123905
R422 VDD.n97 VDD.n104 0.123905
R423 VDD.n248 VDD.n247 0.128833
R424 VDD.n337 VDD.n336 0.125167
R425 VDD.n372 VDD.n371 0.125167
R426 VDD.n405 VDD.n404 0.125167
R427 VDD.n440 VDD.n439 0.125167
R428 VDD.n175 VDD.n156 0.125167
R429 VDD.n109 VDD.n154 0.0704389
R430 VDD.n189 VDD.n141 0.125167
R431 VDD.n307 VDD.n138 0.125167
R432 VDD.n52 VDD.n132 0.0924389
R433 VDD.n26 VDD.n130 0.0997723
R434 VDD.n299 VDD.n124 0.125167
R435 VDD.n296 VDD.n27 0.125167
R436 VDD.n221 VDD.n32 0.123929
R437 VDD.n255 VDD.n73 0.122186
R438 VDD.n291 VDD.n90 0.122186
R439 VDD.n339 VDD.n338 0.122172
R440 VDD.n370 VDD.n369 0.121772
R441 VDD.n407 VDD.n406 0.121772
R442 VDD.n438 VDD.n437 0.121772
R443 VDD.n176 VDD.n155 0.121772
R444 VDD.n188 VDD.n142 0.121772
R445 VDD.n308 VDD.n137 0.121772
R446 VDD.n191 VDD.n123 0.121772
R447 VDD.n214 VDD.n213 0.120467
R448 VDD.n61 VDD.n219 0.120467
R449 VDD.n219 VDD.n218 0.120467
R450 VDD.n217 VDD.n214 0.120467
R451 VDD.n250 VDD.n249 0.120467
R452 VDD.n253 VDD.n250 0.120467
R453 VDD.n287 VDD.n284 0.120467
R454 VDD.n289 VDD.n288 0.120467
R455 VDD.n94 VDD.n289 0.120467
R456 VDD.n284 VDD.n283 0.120467
R457 VDD.n334 VDD.n333 0.117833
R458 VDD.n341 VDD.n340 0.117833
R459 VDD.n368 VDD.n367 0.117833
R460 VDD.n375 VDD.n374 0.117833
R461 VDD.n402 VDD.n401 0.117833
R462 VDD.n409 VDD.n408 0.117833
R463 VDD.n436 VDD.n435 0.117833
R464 VDD.n443 VDD.n442 0.117833
R465 VDD.n174 VDD.n158 0.117833
R466 VDD.n177 VDD.n154 0.117833
R467 VDD.n8 VDD.n7 0.0398384
R468 VDD.n13 VDD.n12 0.0398384
R469 VDD.n16 VDD.n15 0.0398384
R470 VDD.n18 VDD.n17 0.0398384
R471 VDD.n332 VDD.n331 0.114439
R472 VDD.n377 VDD.n376 0.114439
R473 VDD.n400 VDD.n399 0.114439
R474 VDD.n445 VDD.n444 0.114439
R475 VDD.n173 VDD.n159 0.114439
R476 VDD.n343 VDD.n342 0.114439
R477 VDD.n366 VDD.n365 0.114439
R478 VDD.n411 VDD.n410 0.114439
R479 VDD.n434 VDD.n433 0.114439
R480 VDD.n330 VDD.n329 0.1105
R481 VDD.n345 VDD.n344 0.1105
R482 VDD.n364 VDD.n363 0.1105
R483 VDD.n379 VDD.n378 0.1105
R484 VDD.n398 VDD.n397 0.1105
R485 VDD.n413 VDD.n412 0.1105
R486 VDD.n432 VDD.n431 0.1105
R487 VDD.n447 VDD.n446 0.1105
R488 VDD.n172 VDD.n160 0.1105
R489 VDD.n178 VDD.n152 0.1105
R490 VDD.n187 VDD.n143 0.1105
R491 VDD.n306 VDD.n136 0.1105
R492 VDD.n298 VDD.n127 0.1105
R493 VDD.n295 VDD.n121 0.1105
R494 VDD.n347 VDD.n346 0.107106
R495 VDD.n362 VDD.n361 0.107106
R496 VDD.n415 VDD.n414 0.107106
R497 VDD.n430 VDD.n429 0.107106
R498 VDD.n179 VDD.n151 0.107106
R499 VDD.n186 VDD.n144 0.107106
R500 VDD.n304 VDD.n135 0.107106
R501 VDD.n303 VDD.n128 0.107106
R502 VDD.n328 VDD.n327 0.107106
R503 VDD.n381 VDD.n380 0.107106
R504 VDD.n396 VDD.n395 0.107106
R505 VDD.n449 VDD.n448 0.107106
R506 VDD.n49 VDD.n258 0.106833
R507 VDD.n222 VDD.n206 0.106833
R508 VDD.n326 VDD.n325 0.103167
R509 VDD.n349 VDD.n348 0.103167
R510 VDD.n360 VDD.n359 0.103167
R511 VDD.n383 VDD.n382 0.103167
R512 VDD.n394 VDD.n393 0.103167
R513 VDD.n417 VDD.n416 0.103167
R514 VDD.n428 VDD.n427 0.103167
R515 VDD.n451 VDD.n450 0.103167
R516 VDD.n171 VDD.n162 0.103167
R517 VDD.n180 VDD.n150 0.103167
R518 VDD.n185 VDD.n145 0.103167
R519 VDD.n305 VDD.n134 0.103167
R520 VDD.n302 VDD.n129 0.103167
R521 VDD.n297 VDD.n119 0.103167
R522 VDD.n277 VDD.n259 0.103167
R523 VDD.n256 VDD.n238 0.103167
R524 VDD.n42 VDD.n224 0.103167
R525 VDD.n207 VDD.n205 0.103167
R526 VDD.n324 VDD.n323 0.0997723
R527 VDD.n351 VDD.n350 0.0997723
R528 VDD.n358 VDD.n357 0.0997723
R529 VDD.n385 VDD.n384 0.0997723
R530 VDD.n392 VDD.n391 0.0997723
R531 VDD.n419 VDD.n418 0.0997723
R532 VDD.n426 VDD.n425 0.0997723
R533 VDD.n453 VDD.n452 0.0997723
R534 VDD.n170 VDD.n163 0.0997723
R535 VDD.n184 VDD.n146 0.0997723
R536 VDD.n190 VDD.n133 0.0997723
R537 VDD.n294 VDD.n118 0.0997723
R538 VDD.n46 VDD.n260 0.0995
R539 VDD.n239 VDD.n237 0.0995
R540 VDD.n241 VDD.n225 0.0995
R541 VDD.n31 VDD.n204 0.0995
R542 VDD.n319 VDD.n105 0.177059
R543 VDD.n322 VDD.n321 0.0958333
R544 VDD.n353 VDD.n352 0.0958333
R545 VDD.n356 VDD.n355 0.0958333
R546 VDD.n387 VDD.n386 0.0958333
R547 VDD.n390 VDD.n389 0.0958333
R548 VDD.n421 VDD.n420 0.0958333
R549 VDD.n424 VDD.n423 0.0958333
R550 VDD.n455 VDD.n454 0.0958333
R551 VDD.n106 VDD.n457 0.176697
R552 VDD.n123 VDD.n28 0.129106
R553 VDD.n167 VDD.n165 0.0958333
R554 VDD.n169 VDD.n164 0.0958333
R555 VDD.n181 VDD.n148 0.0958333
R556 VDD.n183 VDD.n147 0.0958333
R557 VDD.n301 VDD.n132 0.0958333
R558 VDD.n300 VDD.n131 0.0958333
R559 VDD.n293 VDD.n117 0.0958333
R560 VDD.n20 VDD.n19 0.177423
R561 VDD.n278 VDD.n261 0.0958333
R562 VDD.n72 VDD.n236 0.0958333
R563 VDD.n39 VDD.n226 0.0958333
R564 VDD.n35 VDD.n203 0.0958333
R565 VDD.n354 VDD.n353 0.092439
R566 VDD.n355 VDD.n354 0.092439
R567 VDD.n422 VDD.n421 0.092439
R568 VDD.n423 VDD.n422 0.092439
R569 VDD.n168 VDD.n165 0.092439
R570 VDD.n168 VDD.n164 0.092439
R571 VDD.n182 VDD.n148 0.092439
R572 VDD.n182 VDD.n147 0.092439
R573 VDD.n320 VDD.n319 0.0924389
R574 VDD.n321 VDD.n320 0.0924389
R575 VDD.n388 VDD.n387 0.0924389
R576 VDD.n389 VDD.n388 0.0924389
R577 VDD.n456 VDD.n455 0.0924389
R578 VDD.n457 VDD.n456 0.0924389
R579 VDD.n102 VDD.n262 0.0921667
R580 VDD.n76 VDD.n235 0.0921667
R581 VDD.n242 VDD.n227 0.0921667
R582 VDD.n55 VDD.n202 0.0921667
R583 VDD.n318 VDD.n317 0.0906639
R584 VDD.n317 VDD.n316 0.0906639
R585 VDD.n316 VDD.n315 0.0906639
R586 VDD.n315 VDD.n314 0.0906639
R587 VDD.n314 VDD.n313 0.0906639
R588 VDD.n313 VDD.n312 0.0906639
R589 VDD.n312 VDD.n311 0.0906639
R590 VDD.n311 VDD.n310 0.0906639
R591 VDD.n323 VDD.n322 0.0885
R592 VDD.n352 VDD.n351 0.0885
R593 VDD.n357 VDD.n356 0.0885
R594 VDD.n386 VDD.n385 0.0885
R595 VDD.n391 VDD.n390 0.0885
R596 VDD.n420 VDD.n419 0.0885
R597 VDD.n425 VDD.n424 0.0885
R598 VDD.n454 VDD.n453 0.0885
R599 VDD.n169 VDD.n163 0.0885
R600 VDD.n181 VDD.n149 0.0885
R601 VDD.n183 VDD.n146 0.0885
R602 VDD.n301 VDD.n133 0.0885
R603 VDD.n300 VDD.n130 0.0885
R604 VDD.n293 VDD.n118 0.0885
R605 VDD.n279 VDD.n263 0.0885
R606 VDD.n79 VDD.n234 0.0885
R607 VDD.n85 VDD.n228 0.0885
R608 VDD.n57 VDD.n201 0.0885
R609 VDD.n325 VDD.n324 0.0851056
R610 VDD.n384 VDD.n383 0.0851056
R611 VDD.n393 VDD.n392 0.0851056
R612 VDD.n452 VDD.n451 0.0851056
R613 VDD.n170 VDD.n162 0.0851056
R614 VDD.n184 VDD.n145 0.0851056
R615 VDD.n190 VDD.n134 0.0851056
R616 VDD.n294 VDD.n119 0.0851056
R617 VDD.n350 VDD.n349 0.0851056
R618 VDD.n359 VDD.n358 0.0851056
R619 VDD.n418 VDD.n417 0.0851056
R620 VDD.n427 VDD.n426 0.0851056
R621 VDD.n98 VDD.n264 0.0848333
R622 VDD.n251 VDD.n233 0.0848333
R623 VDD.n243 VDD.n229 0.0848333
R624 VDD.n60 VDD.n200 0.0848333
R625 VDD.n327 VDD.n326 0.0811667
R626 VDD.n348 VDD.n347 0.0811667
R627 VDD.n361 VDD.n360 0.0811667
R628 VDD.n382 VDD.n381 0.0811667
R629 VDD.n395 VDD.n394 0.0811667
R630 VDD.n416 VDD.n415 0.0811667
R631 VDD.n429 VDD.n428 0.0811667
R632 VDD.n450 VDD.n449 0.0811667
R633 VDD.n171 VDD.n161 0.0811667
R634 VDD.n180 VDD.n151 0.0811667
R635 VDD.n185 VDD.n144 0.0811667
R636 VDD.n305 VDD.n135 0.0811667
R637 VDD.n302 VDD.n128 0.0811667
R638 VDD.n297 VDD.n120 0.0811667
R639 VDD.n281 VDD.n265 0.0811667
R640 VDD.n252 VDD.n232 0.0811667
R641 VDD.n81 VDD.n230 0.0811667
R642 VDD.n62 VDD.n199 0.0811667
R643 VDD.n167 VDD.n166 0.0790081
R644 VDD.n346 VDD.n345 0.0777723
R645 VDD.n363 VDD.n362 0.0777723
R646 VDD.n414 VDD.n413 0.0777723
R647 VDD.n431 VDD.n430 0.0777723
R648 VDD.n179 VDD.n152 0.0777723
R649 VDD.n186 VDD.n143 0.0777723
R650 VDD.n304 VDD.n136 0.0777723
R651 VDD.n303 VDD.n127 0.0777723
R652 VDD.n329 VDD.n328 0.0777723
R653 VDD.n380 VDD.n379 0.0777723
R654 VDD.n397 VDD.n396 0.0777723
R655 VDD.n448 VDD.n447 0.0777723
R656 VDD.n292 VDD.n273 0.0775
R657 VDD.n280 VDD.n266 0.0775
R658 VDD.n244 VDD.n231 0.0775
R659 VDD.n220 VDD.n198 0.0775
R660 VDD.n22 VDD.n68 0.123145
R661 VDD.n318 VDD.n116 0.0744127
R662 VDD.n331 VDD.n330 0.0738333
R663 VDD.n344 VDD.n343 0.0738333
R664 VDD.n365 VDD.n364 0.0738333
R665 VDD.n378 VDD.n377 0.0738333
R666 VDD.n399 VDD.n398 0.0738333
R667 VDD.n412 VDD.n411 0.0738333
R668 VDD.n433 VDD.n432 0.0738333
R669 VDD.n446 VDD.n445 0.0738333
R670 VDD.n172 VDD.n159 0.0738333
R671 VDD.n178 VDD.n153 0.0738333
R672 VDD.n187 VDD.n6 0.0738333
R673 VDD.n306 VDD.n14 0.0738333
R674 VDD.n298 VDD.n126 0.0738333
R675 VDD.n295 VDD.n122 0.0738333
R676 VDD.n275 VDD.n272 0.0738333
R677 VDD.n286 VDD.n267 0.0738333
R678 VDD.n215 VDD.n197 0.0738333
R679 VDD.n68 VDD.n192 0.0738333
R680 VDD.n310 VDD.n309 0.0726311
R681 VDD.n333 VDD.n332 0.070439
R682 VDD.n376 VDD.n375 0.070439
R683 VDD.n401 VDD.n400 0.070439
R684 VDD.n444 VDD.n443 0.070439
R685 VDD.n173 VDD.n158 0.070439
R686 VDD.n342 VDD.n341 0.0704389
R687 VDD.n367 VDD.n366 0.0704389
R688 VDD.n410 VDD.n409 0.0704389
R689 VDD.n435 VDD.n434 0.0704389
R690 VDD.n89 VDD.n271 0.0701667
R691 VDD.n285 VDD.n268 0.0701667
R692 VDD.n216 VDD.n196 0.0701667
R693 VDD.n209 VDD.n193 0.0701667
R694 VDD.n458 VDD.n116 0.0667651
R695 VDD.n340 VDD.n339 0.0665655
R696 VDD.n335 VDD.n334 0.0665
R697 VDD.n369 VDD.n368 0.0665
R698 VDD.n374 VDD.n373 0.0665
R699 VDD.n403 VDD.n402 0.0665
R700 VDD.n408 VDD.n407 0.0665
R701 VDD.n437 VDD.n436 0.0665
R702 VDD.n442 VDD.n441 0.0665
R703 VDD.n174 VDD.n157 0.0665
R704 VDD.n177 VDD.n155 0.0665
R705 VDD.n8 VDD.n142 0.144957
R706 VDD.n13 VDD.n139 0.144957
R707 VDD.n16 VDD.n137 0.144957
R708 VDD.n18 VDD.n125 0.144957
R709 VDD.n93 VDD.n270 0.0665
R710 VDD.n290 VDD.n269 0.0665
R711 VDD.n210 VDD.n195 0.0665
R712 VDD.n65 VDD.n194 0.0665
R713 VDD.n191 VDD.n124 0.0631056
R714 VDD.n308 VDD.n138 0.0631056
R715 VDD.n176 VDD.n156 0.0631056
R716 VDD.n338 VDD.n337 0.0631056
R717 VDD.n406 VDD.n405 0.0631056
R718 VDD.n371 VDD.n370 0.0631056
R719 VDD.n439 VDD.n438 0.0631056
R720 VDD.n188 VDD.n141 0.0631056
R721 VDD.n95 VDD.n270 0.0628333
R722 VDD.n95 VDD.n269 0.0628333
R723 VDD.n211 VDD.n195 0.0628333
R724 VDD.n211 VDD.n194 0.0628333
R725 VDD.n336 VDD.n335 0.0591667
R726 VDD.n373 VDD.n372 0.0591667
R727 VDD.n404 VDD.n403 0.0591667
R728 VDD.n441 VDD.n440 0.0591667
R729 VDD.n175 VDD.n157 0.0591667
R730 VDD.n189 VDD.n140 0.0591667
R731 VDD.n307 VDD.n139 0.0591667
R732 VDD.n299 VDD.n125 0.0591667
R733 VDD.n93 VDD.n271 0.0591667
R734 VDD.n290 VDD.n268 0.0591667
R735 VDD.n210 VDD.n196 0.0591667
R736 VDD.n65 VDD.n193 0.0591667
R737 VDD.n89 VDD.n272 0.0555
R738 VDD.n285 VDD.n267 0.0555
R739 VDD.n216 VDD.n197 0.0555
R740 VDD.n209 VDD.n192 0.0555
R741 VDD.n109 VDD.n153 0.114439
R742 VDD.n296 VDD.n122 0.0518333
R743 VDD.n275 VDD.n273 0.0518333
R744 VDD.n286 VDD.n266 0.0518333
R745 VDD.n247 VDD.n231 0.0518333
R746 VDD.n215 VDD.n198 0.0518333
R747 VDD.n280 VDD.n265 0.0481667
R748 VDD.n248 VDD.n232 0.0481667
R749 VDD.n244 VDD.n230 0.0481667
R750 VDD.n220 VDD.n199 0.0481667
R751 VDD.n110 VDD.n161 0.107106
R752 VDD.n53 VDD.n120 0.107106
R753 VDD.n281 VDD.n264 0.0445
R754 VDD.n252 VDD.n233 0.0445
R755 VDD.n81 VDD.n229 0.0445
R756 VDD.n62 VDD.n200 0.0445
R757 VDD.n98 VDD.n263 0.0408333
R758 VDD.n251 VDD.n234 0.0408333
R759 VDD.n243 VDD.n228 0.0408333
R760 VDD.n60 VDD.n201 0.0408333
R761 VDD.n108 VDD.n149 0.0997723
R762 VDD.n279 VDD.n262 0.0371667
R763 VDD.n79 VDD.n235 0.0371667
R764 VDD.n85 VDD.n227 0.0371667
R765 VDD.n57 VDD.n202 0.0371667
R766 VDD.n102 VDD.n261 0.0335
R767 VDD.n76 VDD.n236 0.0335
R768 VDD.n242 VDD.n226 0.0335
R769 VDD.n55 VDD.n203 0.0335
R770 VDD.n467 VDD.n111 0.0300385
R771 VDD.n466 VDD.n465 0.0300385
R772 VDD.n466 VDD.n113 0.0300385
R773 VDD.n461 VDD.n113 0.0300385
R774 VDD.n464 VDD.n114 0.0300385
R775 VDD.n463 VDD.n5 0.0156729
R776 VDD.n463 VDD.n462 0.0300385
R777 VDD.n126 VDD.n17 0.184378
R778 VDD.n15 VDD.n14 0.184378
R779 VDD.n12 VDD.n9 0.184378
R780 VDD.n7 VDD.n6 0.184378
R781 VDD.t0 VDD.n21 0.165524
R782 VDD.n140 VDD.n11 0.129106
R783 VDD.n1 VDD.n0 0.753026
R784 VDD.n1 VDD.n115 0.0473987
R785 VDD.n52 VDD.n131 0.0924389
R786 VDD.n107 VDD.n117 0.0924389
R787 VDD.n107 VDD.n19 0.0924389
R788 VDD.n24 VDD.n23 0.0225763
R789 VDD.n278 VDD.n260 0.0298333
R790 VDD.n72 VDD.n237 0.0298333
R791 VDD.n39 VDD.n225 0.0298333
R792 VDD.n35 VDD.n204 0.0298333
R793 VDD.n46 VDD.n259 0.0261667
R794 VDD.n239 VDD.n238 0.0261667
R795 VDD.n241 VDD.n224 0.0261667
R796 VDD.n31 VDD.n205 0.0261667
R797 VDD.n108 VDD.n150 0.0851056
R798 VDD.n26 VDD.n129 0.0851056
R799 VDD.n277 VDD.n258 0.0225
R800 VDD.n207 VDD.n206 0.0225
R801 VDD.n4 VDD.n3 0.020089
R802 VDD.n309 VDD.n166 0.019522
R803 VDD.t16 VDD.n460 0.0157923
R804 VDD.n467 VDD.n112 0.0155551
R805 VDD.n460 VDD.n111 0.0155551
R806 VDD.n110 VDD.n160 0.0777723
R807 VDD.n53 VDD.n121 0.0777723
R808 VDD.n459 VDD.n0 0.0686096
R809 VDD.n464 VDD.n2 2.28457
R810 VDD VDD.n0 0.0005
R811 GND.n309 GND.n94 41.1048
R812 GND.n308 GND.n95 41.1048
R813 GND.n307 GND.n96 41.1048
R814 GND.n306 GND.n97 41.1048
R815 GND.n305 GND.n98 41.1048
R816 GND.n303 GND.n100 41.1048
R817 GND.n302 GND.n101 41.1048
R818 GND.n301 GND.n102 41.1048
R819 GND.n300 GND.n103 41.1048
R820 GND.n299 GND.n104 41.1048
R821 GND.n298 GND.n105 41.1048
R822 GND.n296 GND.n107 41.1048
R823 GND.n295 GND.n108 41.1048
R824 GND.n294 GND.n109 41.1048
R825 GND.n293 GND.n110 41.1048
R826 GND.n292 GND.n111 41.1048
R827 GND.n291 GND.n112 41.1048
R828 GND.n324 GND.n80 39.8778
R829 GND.n323 GND.n81 39.8778
R830 GND.n321 GND.n83 39.8778
R831 GND.n320 GND.n84 39.8778
R832 GND.n319 GND.n85 39.8778
R833 GND.n317 GND.n87 39.8778
R834 GND.n316 GND.n88 39.8778
R835 GND.n315 GND.n89 39.8778
R836 GND.n314 GND.n90 39.8778
R837 GND.n313 GND.n91 39.8778
R838 GND.n312 GND.n92 39.8778
R839 GND.n310 GND.n94 39.8778
R840 GND.t0 GND.n50 40.989
R841 GND.t7 GND.n99 33.7428
R842 GND.t9 GND.n113 33.7428
R843 GND.t14 GND.n106 33.1293
R844 GND.t10 GND.n82 31.9023
R845 GND.n318 GND.t5 31.9023
R846 GND.n311 GND.t6 31.9023
R847 GND.n184 GND.n66 25.1539
R848 GND.n336 GND.n67 25.1539
R849 GND.n337 GND.n68 25.1539
R850 GND.n335 GND.n69 25.1539
R851 GND.n334 GND.n70 25.1539
R852 GND.n333 GND.n71 25.1539
R853 GND.n332 GND.n72 25.1539
R854 GND.n331 GND.n73 25.1539
R855 GND.n330 GND.n74 25.1539
R856 GND.n329 GND.n75 25.1539
R857 GND.n328 GND.n76 25.1539
R858 GND.n327 GND.n77 25.1539
R859 GND.n326 GND.n78 25.1539
R860 GND.n325 GND.n79 25.1539
R861 GND.n0 GND.n2 11.8798
R862 GND.n14 GND.n13 23.7796
R863 GND.n6 GND.n2 0.023407
R864 GND.n48 GND.n542 17.0005
R865 GND.n48 GND.n119 17.0005
R866 GND.n48 GND.n124 17.0005
R867 GND.n48 GND.n121 17.0005
R868 GND.n48 GND.n115 17.0005
R869 GND.n48 GND.n126 17.0005
R870 GND.n48 GND.n128 17.0005
R871 GND.n48 GND.n53 0.529683
R872 GND.n48 GND.n130 17.0005
R873 GND.n48 GND.n113 8.49847
R874 GND.n48 GND.n132 17.0005
R875 GND.n48 GND.n108 8.49822
R876 GND.n48 GND.n134 17.0005
R877 GND.n48 GND.n107 8.49797
R878 GND.n48 GND.n106 8.49772
R879 GND.n48 GND.n105 8.49747
R880 GND.n48 GND.n136 17.0005
R881 GND.n48 GND.n104 8.49723
R882 GND.n48 GND.n103 8.50022
R883 GND.n48 GND.n102 8.49698
R884 GND.n48 GND.n138 17.0005
R885 GND.n48 GND.n101 8.49673
R886 GND.n48 GND.n100 8.49648
R887 GND.n48 GND.n99 8.49624
R888 GND.n48 GND.n140 17.0005
R889 GND.n48 GND.n98 8.49599
R890 GND.n48 GND.n97 8.49574
R891 GND.n48 GND.n96 8.4955
R892 GND.n48 GND.n142 17.0005
R893 GND.n48 GND.n143 17.0005
R894 GND.n48 GND.n94 8.49525
R895 GND.n48 GND.n93 8.495
R896 GND.n48 GND.n92 8.49476
R897 GND.n48 GND.n145 17.0005
R898 GND.n48 GND.n91 8.49451
R899 GND.n48 GND.n147 17.0005
R900 GND.n48 GND.n87 8.49427
R901 GND.n48 GND.n86 8.49402
R902 GND.n48 GND.n149 17.0005
R903 GND.n48 GND.n85 8.49378
R904 GND.n48 GND.n84 8.49354
R905 GND.n48 GND.n83 8.49329
R906 GND.n48 GND.n151 17.0005
R907 GND.n48 GND.n81 8.49305
R908 GND.n48 GND.n153 17.0005
R909 GND.n48 GND.n79 8.49281
R910 GND.n48 GND.n154 17.0005
R911 GND.n48 GND.n78 8.49257
R912 GND.n48 GND.n77 8.49233
R913 GND.n48 GND.n76 8.49209
R914 GND.n48 GND.n156 17.0005
R915 GND.n48 GND.n75 8.49184
R916 GND.n48 GND.n74 8.49094
R917 GND.n48 GND.n73 8.49161
R918 GND.n48 GND.n158 17.0005
R919 GND.n48 GND.n72 8.49137
R920 GND.n48 GND.n70 8.49113
R921 GND.n48 GND.n160 17.0005
R922 GND.n48 GND.n68 8.49089
R923 GND.n48 GND.n162 17.0005
R924 GND.n48 GND.n66 8.49065
R925 GND.n48 GND.n164 17.0005
R926 GND.n48 GND.n165 17.0005
R927 GND.n48 GND.n167 17.0005
R928 GND.n48 GND.n169 17.0005
R929 GND.n48 GND.n171 17.0005
R930 GND.n49 GND.t1 40.9875
R931 GND.n48 GND.n50 0.00113071
R932 GND.n440 GND.n15 17.0005
R933 GND.n442 GND.n15 17.0005
R934 GND.n446 GND.n15 17.0005
R935 GND.n450 GND.n15 17.0005
R936 GND.n454 GND.n15 17.0005
R937 GND.n458 GND.n15 17.0005
R938 GND.n462 GND.n15 17.0005
R939 GND.n466 GND.n15 17.0005
R940 GND.n470 GND.n15 17.0005
R941 GND.n474 GND.n15 17.0005
R942 GND.n476 GND.n15 17.0005
R943 GND.n478 GND.n15 17.0005
R944 GND.n480 GND.n15 17.0005
R945 GND.n484 GND.n15 17.0005
R946 GND.n488 GND.n15 17.0005
R947 GND.n492 GND.n15 17.0005
R948 GND.n496 GND.n15 17.0005
R949 GND.n500 GND.n15 17.0005
R950 GND.n504 GND.n15 17.0005
R951 GND.n508 GND.n15 17.0005
R952 GND.n512 GND.n15 17.0005
R953 GND.n514 GND.n15 17.0005
R954 GND.n48 GND.n112 8.49987
R955 GND.n48 GND.n111 8.50047
R956 GND.n48 GND.n110 8.50014
R957 GND.n48 GND.n109 8.50053
R958 GND.n48 GND.n95 8.5006
R959 GND.n48 GND.n90 8.4983
R960 GND.n48 GND.n89 8.50064
R961 GND.n48 GND.n88 8.49953
R962 GND.n48 GND.n82 8.49585
R963 GND.n48 GND.n80 8.49724
R964 GND.n48 GND.n71 8.50044
R965 GND.n48 GND.n69 8.49899
R966 GND.n48 GND.n67 8.50067
R967 GND.n48 GND.n51 0.00163354
R968 GND.n48 GND.n52 0.00104342
R969 GND.n436 GND.n15 17.0005
R970 GND.n29 GND.n15 8.46995
R971 GND.n32 GND.n29 0.0631056
R972 GND.n20 GND.n21 0.120598
R973 GND.n21 GND.n15 8.46995
R974 GND.n432 GND.n15 17.0005
R975 GND.n430 GND.n15 17.0005
R976 GND.n428 GND.n15 17.0005
R977 GND.n426 GND.n15 17.0005
R978 GND.n424 GND.n15 17.0005
R979 GND.n422 GND.n15 17.0005
R980 GND.n420 GND.n15 17.0005
R981 GND.n418 GND.n15 17.0005
R982 GND.n416 GND.n15 17.0005
R983 GND.n414 GND.n15 17.0005
R984 GND.n410 GND.n15 17.0005
R985 GND.n408 GND.n15 17.0005
R986 GND.n406 GND.n15 17.0005
R987 GND.n404 GND.n15 17.0005
R988 GND.n402 GND.n15 17.0005
R989 GND.n400 GND.n15 17.0005
R990 GND.n398 GND.n15 17.0005
R991 GND.n396 GND.n15 17.0005
R992 GND.n394 GND.n15 17.0005
R993 GND.n392 GND.n15 17.0005
R994 GND.n28 GND.n15 8.46995
R995 GND.n27 GND.n28 0.121411
R996 GND.n19 GND.n17 0.0631056
R997 GND.n17 GND.n15 8.46995
R998 GND.n388 GND.n15 17.0005
R999 GND.n56 GND.n114 17.0005
R1000 GND.n56 GND.n26 8.47177
R1001 GND.n56 GND.n196 17.0005
R1002 GND.n56 GND.n65 17.0005
R1003 GND.n197 GND.n56 17.0005
R1004 GND.n56 GND.n25 8.47177
R1005 GND.n56 GND.n203 17.0005
R1006 GND.n56 GND.t12 31.4034
R1007 GND.t13 GND.n201 17.0005
R1008 GND.t13 GND.n193 17.0005
R1009 GND.n208 GND.t13 17.0005
R1010 GND.t11 GND.n47 5.58843
R1011 GND.n60 GND.n62 0.122162
R1012 GND.t11 GND.n60 8.44042
R1013 GND.n35 GND.n45 0.425351
R1014 GND.t11 GND.n35 4.13124
R1015 GND.t15 GND.n37 5.58956
R1016 GND.t15 GND.n64 3.30615
R1017 GND.n64 GND.n377 0.194829
R1018 GND.n40 GND.n63 0.122162
R1019 GND.t15 GND.n40 8.44042
R1020 GND.n42 GND.n41 0.243036
R1021 GND.n51 GND.n184 23.81
R1022 GND.n337 GND.n67 16.5649
R1023 GND.n335 GND.n68 16.5649
R1024 GND.n334 GND.n69 16.5649
R1025 GND.n333 GND.n70 16.5649
R1026 GND.n332 GND.n71 16.5649
R1027 GND.n331 GND.n72 16.5649
R1028 GND.n329 GND.n74 16.5649
R1029 GND.n328 GND.n75 16.5649
R1030 GND.n327 GND.n76 16.5649
R1031 GND.n326 GND.n77 16.5649
R1032 GND.n325 GND.n78 16.5649
R1033 GND.n324 GND.n79 16.5649
R1034 GND.t2 GND.n51 40.9865
R1035 GND.n336 GND.t3 8.58946
R1036 GND.n330 GND.t4 8.58946
R1037 GND.n15 GND.n337 8.50125
R1038 GND.n15 GND.n53 0.487778
R1039 GND.n53 GND.t9 11.167
R1040 GND.n15 GND.n291 8.5005
R1041 GND.n15 GND.n292 8.5005
R1042 GND.n15 GND.n293 8.5005
R1043 GND.n15 GND.n294 8.5005
R1044 GND.n15 GND.n295 8.5005
R1045 GND.n15 GND.n296 8.5005
R1046 GND.n15 GND.n297 8.5005
R1047 GND.n15 GND.n298 8.5005
R1048 GND.n15 GND.n299 8.5005
R1049 GND.n15 GND.n300 8.5005
R1050 GND.n15 GND.n301 8.5005
R1051 GND.n15 GND.n302 8.5005
R1052 GND.n15 GND.n303 8.5005
R1053 GND.n15 GND.n304 8.5005
R1054 GND.n15 GND.n305 8.5005
R1055 GND.n15 GND.n306 8.5005
R1056 GND.n15 GND.n307 8.5005
R1057 GND.n15 GND.n308 8.5005
R1058 GND.n15 GND.n309 8.5005
R1059 GND.n15 GND.n310 8.5005
R1060 GND.n15 GND.n311 8.5005
R1061 GND.n15 GND.n312 8.5005
R1062 GND.n15 GND.n313 8.5005
R1063 GND.n15 GND.n314 8.5005
R1064 GND.n15 GND.n315 8.5005
R1065 GND.n15 GND.n316 8.5005
R1066 GND.n15 GND.n317 8.5005
R1067 GND.n15 GND.n318 8.5005
R1068 GND.n15 GND.n319 8.5005
R1069 GND.n15 GND.n320 8.5005
R1070 GND.n15 GND.n321 8.5005
R1071 GND.n15 GND.n322 8.5005
R1072 GND.n15 GND.n323 8.5005
R1073 GND.n15 GND.n324 8.5005
R1074 GND.n15 GND.n325 8.5005
R1075 GND.n15 GND.n326 8.5005
R1076 GND.n15 GND.n327 8.5005
R1077 GND.n15 GND.n328 8.5005
R1078 GND.n15 GND.n329 8.5005
R1079 GND.n15 GND.n330 8.5005
R1080 GND.n15 GND.n331 8.5005
R1081 GND.n15 GND.n332 8.5005
R1082 GND.n15 GND.n333 8.5005
R1083 GND.n15 GND.n334 8.5005
R1084 GND.n15 GND.n335 8.5005
R1085 GND.n15 GND.n336 8.5005
R1086 GND.n210 GND.n56 8.48544
R1087 GND.n516 GND.n15 8.47683
R1088 GND.n48 GND.n118 8.46995
R1089 GND.n48 GND.n125 8.46995
R1090 GND.n48 GND.n120 8.46995
R1091 GND.n48 GND.n123 8.46995
R1092 GND.n48 GND.n127 8.46995
R1093 GND.n48 GND.n131 8.46995
R1094 GND.n48 GND.n135 8.46995
R1095 GND.n48 GND.n139 8.46995
R1096 GND.n48 GND.n146 8.46995
R1097 GND.n48 GND.n150 8.46995
R1098 GND.n48 GND.n157 8.46995
R1099 GND.n48 GND.n161 8.46995
R1100 GND.n48 GND.n168 8.46995
R1101 GND.n48 GND.n172 8.46995
R1102 GND.n448 GND.n15 8.46995
R1103 GND.n456 GND.n15 8.46995
R1104 GND.n464 GND.n15 8.46995
R1105 GND.n472 GND.n15 8.46995
R1106 GND.n482 GND.n15 8.46995
R1107 GND.n490 GND.n15 8.46995
R1108 GND.n498 GND.n15 8.46995
R1109 GND.n506 GND.n15 8.46995
R1110 GND.n434 GND.n15 8.46995
R1111 GND.n390 GND.n15 8.46995
R1112 GND.n48 GND.n129 8.46995
R1113 GND.n48 GND.n133 8.46995
R1114 GND.n48 GND.n137 8.46995
R1115 GND.n48 GND.n141 8.46995
R1116 GND.n48 GND.n144 8.46995
R1117 GND.n48 GND.n148 8.46995
R1118 GND.n48 GND.n152 8.46995
R1119 GND.n48 GND.n155 8.46995
R1120 GND.n48 GND.n159 8.46995
R1121 GND.n48 GND.n163 8.46995
R1122 GND.n48 GND.n166 8.46995
R1123 GND.n48 GND.n170 8.46995
R1124 GND.n444 GND.n15 8.46995
R1125 GND.n452 GND.n15 8.46995
R1126 GND.n460 GND.n15 8.46995
R1127 GND.n468 GND.n15 8.46995
R1128 GND.n486 GND.n15 8.46995
R1129 GND.n494 GND.n15 8.46995
R1130 GND.n502 GND.n15 8.46995
R1131 GND.n510 GND.n15 8.46995
R1132 GND.t13 GND.n207 8.46676
R1133 GND.t13 GND.n200 8.46676
R1134 GND.t13 GND.n192 8.46676
R1135 GND.t13 GND.n189 8.46676
R1136 GND.t15 GND.n376 8.44469
R1137 GND.n386 GND.t11 8.44383
R1138 GND.t11 GND.n43 8.44298
R1139 GND.n42 GND.t15 5.56135
R1140 GND.t11 GND.n384 8.44042
R1141 GND.t11 GND.n385 8.44042
R1142 GND.t15 GND.n380 8.44042
R1143 GND.n52 GND.t0 15.2203
R1144 GND.n50 GND.t1 15.2202
R1145 GND.t3 GND.n66 7.97596
R1146 GND.t4 GND.n73 7.97596
R1147 GND.n322 GND.t10 7.97596
R1148 GND.t5 GND.n86 7.97596
R1149 GND.t6 GND.n93 7.97596
R1150 GND.n304 GND.t7 7.36246
R1151 GND.n297 GND.t8 7.36246
R1152 GND.n242 GND.t21 4.34814
R1153 GND.n256 GND.t20 4.34814
R1154 GND.n255 GND.t21 4.34781
R1155 GND.t20 GND.n219 4.34781
R1156 GND.n270 GND.n269 4.31983
R1157 GND.n49 GND.t2 15.2222
R1158 GND.n48 GND.n49 0.00109387
R1159 GND.n52 GND.n56 19285.1
R1160 GND.n226 GND.t25 2.72677
R1161 GND.t16 GND.n239 2.72636
R1162 GND.n227 GND.t23 2.72636
R1163 GND.n268 GND.t22 2.72614
R1164 GND.n244 GND.t17 2.72614
R1165 GND.n240 GND.t18 2.72572
R1166 GND.n267 GND.t24 2.7255
R1167 GND.n243 GND.t19 2.7255
R1168 GND.n268 GND.t24 2.72505
R1169 GND.n244 GND.t19 2.72505
R1170 GND.n240 GND.t16 2.72497
R1171 GND.t23 GND.n226 2.72497
R1172 GND.n239 GND.t18 2.72319
R1173 GND.t22 GND.n267 2.72319
R1174 GND.n227 GND.t25 2.72319
R1175 GND.t17 GND.n243 2.72319
R1176 GND.n239 GND.n219 2.4713
R1177 GND.n243 GND.n242 2.4713
R1178 GND.n275 GND.n274 2.32663
R1179 GND.n13 GND.n10 0.0157673
R1180 GND.n14 GND.n8 0.0157673
R1181 GND.n12 GND.n11 1.12531
R1182 GND.n22 GND.n33 2.2505
R1183 GND.n33 GND.n117 2.2505
R1184 GND.n544 GND.n543 2.2505
R1185 GND.n9 GND.n116 2.2505
R1186 GND.n543 GND.n24 2.2505
R1187 GND.n12 GND.n116 0.0155868
R1188 GND.n212 GND.n211 2.2505
R1189 GND.n282 GND.n281 2.2505
R1190 GND.n279 GND.n278 2.2505
R1191 GND.n7 GND.n212 2.2505
R1192 GND.n281 GND.n280 2.2505
R1193 GND.n1 GND.n0 1.11866
R1194 GND.n1 GND.n279 0.0156729
R1195 GND.n8 GND.n7 2.2505
R1196 GND.n280 GND.n14 2.2505
R1197 GND.n6 GND.n544 2.2505
R1198 GND.n10 GND.n9 2.2505
R1199 GND.n545 GND.n13 2.2505
R1200 GND.n275 GND.n213 1.9937
R1201 GND.n412 GND.n15 1.94493
R1202 GND.n323 GND.n80 1.84099
R1203 GND.n322 GND.n81 1.84099
R1204 GND.n321 GND.n82 1.84099
R1205 GND.n320 GND.n83 1.84099
R1206 GND.n319 GND.n84 1.84099
R1207 GND.n318 GND.n85 1.84099
R1208 GND.n317 GND.n86 1.84099
R1209 GND.n316 GND.n87 1.84099
R1210 GND.n315 GND.n88 1.84099
R1211 GND.n314 GND.n89 1.84099
R1212 GND.n313 GND.n90 1.84099
R1213 GND.n312 GND.n91 1.84099
R1214 GND.n311 GND.n92 1.84099
R1215 GND.n310 GND.n93 1.84099
R1216 GND.n269 GND.n219 1.5713
R1217 GND.n242 GND.n213 1.5713
R1218 GND.n276 GND.n275 1.21766
R1219 GND.n438 GND.n437 1.19415
R1220 GND.n274 GND.n214 1.1885
R1221 GND.n273 GND.n215 1.1885
R1222 GND.n272 GND.n216 1.1885
R1223 GND.n271 GND.n217 1.1885
R1224 GND.n270 GND.n218 1.1885
R1225 GND.n277 GND.n211 1.16442
R1226 GND.n387 GND.n183 1.14337
R1227 GND.n411 GND.n43 1.10362
R1228 GND.n437 GND.n376 1.10193
R1229 GND.n387 GND.n386 1.10192
R1230 GND.n439 GND.n438 1.08054
R1231 GND.n283 GND.n282 1.06455
R1232 GND.n517 GND.n183 1.03259
R1233 GND.n15 GND.n184 1.0005
R1234 GND.n201 GND.n185 0.983625
R1235 GND.n193 GND.n65 0.983625
R1236 GND.n209 GND.n208 0.983625
R1237 GND.n409 GND.n44 0.983625
R1238 GND.n407 GND.n44 0.983625
R1239 GND.n405 GND.n47 0.983625
R1240 GND.n403 GND.n47 0.983625
R1241 GND.n393 GND.n62 0.983625
R1242 GND.n391 GND.n45 0.983625
R1243 GND.n27 GND.n45 0.46366
R1244 GND.n390 GND.n27 0.123244
R1245 GND.n389 GND.n45 0.983625
R1246 GND.n19 GND.n18 0.983625
R1247 GND.n16 GND.n34 0.983625
R1248 GND.n395 GND.n61 0.983625
R1249 GND.n397 GND.n383 0.983625
R1250 GND.n399 GND.n382 0.983625
R1251 GND.n401 GND.n381 0.983625
R1252 GND.n435 GND.n38 0.983625
R1253 GND.n32 GND.n31 0.983625
R1254 GND.n30 GND.n36 0.983625
R1255 GND.n434 GND.n20 0.124265
R1256 GND.n20 GND.n39 0.464066
R1257 GND.n433 GND.n46 0.983625
R1258 GND.n431 GND.n46 0.983625
R1259 GND.n429 GND.n46 0.983625
R1260 GND.n419 GND.n41 0.983625
R1261 GND.n417 GND.n41 0.983625
R1262 GND.n415 GND.n41 0.983625
R1263 GND.n421 GND.n63 0.983625
R1264 GND.n423 GND.n379 0.983625
R1265 GND.n425 GND.n378 0.983625
R1266 GND.n427 GND.n377 0.983625
R1267 GND.n203 GND.n202 0.928625
R1268 GND.n199 GND.n198 0.928625
R1269 GND.n188 GND.n114 0.928625
R1270 GND.n195 GND.n194 0.928625
R1271 GND.n191 GND.n190 0.928625
R1272 GND.n4 GND.n3 0.928625
R1273 GND.n205 GND.n204 0.928625
R1274 GND.n206 GND.n5 0.928625
R1275 GND.n269 GND.n268 0.9005
R1276 GND.n241 GND.n240 0.9005
R1277 GND.n245 GND.n244 0.9005
R1278 GND.n228 GND.n227 0.9005
R1279 GND.n267 GND.n266 0.9005
R1280 GND.n226 GND.n213 0.9005
R1281 GND.n246 GND.n238 0.6825
R1282 GND.n248 GND.n247 0.6825
R1283 GND.n249 GND.n237 0.6825
R1284 GND.n250 GND.n236 0.6825
R1285 GND.n252 GND.n251 0.6825
R1286 GND.n253 GND.n235 0.6825
R1287 GND.n254 GND.n234 0.6825
R1288 GND.n256 GND.n255 0.6825
R1289 GND.n257 GND.n233 0.6825
R1290 GND.n258 GND.n232 0.6825
R1291 GND.n260 GND.n259 0.6825
R1292 GND.n261 GND.n231 0.6825
R1293 GND.n262 GND.n230 0.6825
R1294 GND.n264 GND.n263 0.6825
R1295 GND.n265 GND.n229 0.6825
R1296 GND.n225 GND.n220 0.6825
R1297 GND.n224 GND.n223 0.6825
R1298 GND.n222 GND.n221 0.6825
R1299 GND.n309 GND.n95 0.613997
R1300 GND.n308 GND.n96 0.613997
R1301 GND.n307 GND.n97 0.613997
R1302 GND.n306 GND.n98 0.613997
R1303 GND.n305 GND.n99 0.613997
R1304 GND.n304 GND.n100 0.613997
R1305 GND.n303 GND.n101 0.613997
R1306 GND.n302 GND.n102 0.613997
R1307 GND.n301 GND.n103 0.613997
R1308 GND.n300 GND.n104 0.613997
R1309 GND.n299 GND.n105 0.613997
R1310 GND.n298 GND.n106 0.613997
R1311 GND.t8 GND.t14 0.613997
R1312 GND.n297 GND.n107 0.613997
R1313 GND.n296 GND.n108 0.613997
R1314 GND.n295 GND.n109 0.613997
R1315 GND.n294 GND.n110 0.613997
R1316 GND.n293 GND.n111 0.613997
R1317 GND.n292 GND.n112 0.613997
R1318 GND.n291 GND.n113 0.613997
R1319 GND.n412 GND.n411 0.530652
R1320 GND.n413 GND.n412 0.527983
R1321 GND.n539 GND.n528 0.48175
R1322 GND.n541 GND.n540 0.48175
R1323 GND.n439 GND.n55 0.491052
R1324 GND.n515 GND.n338 0.48175
R1325 GND.n513 GND.n339 0.48175
R1326 GND.n511 GND.n340 0.48175
R1327 GND.n509 GND.n341 0.48175
R1328 GND.n507 GND.n342 0.48175
R1329 GND.n505 GND.n343 0.48175
R1330 GND.n503 GND.n344 0.48175
R1331 GND.n501 GND.n345 0.48175
R1332 GND.n499 GND.n346 0.48175
R1333 GND.n497 GND.n347 0.48175
R1334 GND.n495 GND.n348 0.48175
R1335 GND.n493 GND.n349 0.48175
R1336 GND.n491 GND.n350 0.48175
R1337 GND.n489 GND.n351 0.48175
R1338 GND.n487 GND.n352 0.48175
R1339 GND.n485 GND.n353 0.48175
R1340 GND.n483 GND.n354 0.48175
R1341 GND.n481 GND.n355 0.48175
R1342 GND.n479 GND.n356 0.48175
R1343 GND.n477 GND.n357 0.48175
R1344 GND.n475 GND.n358 0.48175
R1345 GND.n473 GND.n359 0.48175
R1346 GND.n471 GND.n360 0.48175
R1347 GND.n469 GND.n361 0.48175
R1348 GND.n467 GND.n362 0.48175
R1349 GND.n465 GND.n363 0.48175
R1350 GND.n463 GND.n364 0.48175
R1351 GND.n461 GND.n365 0.48175
R1352 GND.n459 GND.n366 0.48175
R1353 GND.n457 GND.n367 0.48175
R1354 GND.n455 GND.n368 0.48175
R1355 GND.n453 GND.n369 0.48175
R1356 GND.n451 GND.n370 0.48175
R1357 GND.n449 GND.n371 0.48175
R1358 GND.n447 GND.n372 0.48175
R1359 GND.n445 GND.n373 0.48175
R1360 GND.n443 GND.n374 0.48175
R1361 GND.n441 GND.n375 0.48175
R1362 GND.n518 GND.n182 0.48175
R1363 GND.n519 GND.n181 0.48175
R1364 GND.n520 GND.n180 0.48175
R1365 GND.n521 GND.n179 0.48175
R1366 GND.n522 GND.n178 0.48175
R1367 GND.n523 GND.n177 0.48175
R1368 GND.n524 GND.n176 0.48175
R1369 GND.n525 GND.n175 0.48175
R1370 GND.n526 GND.n174 0.48175
R1371 GND.n537 GND.n530 0.48175
R1372 GND.n538 GND.n529 0.48175
R1373 GND.n534 GND.n533 0.48175
R1374 GND.n535 GND.n532 0.48175
R1375 GND.n536 GND.n531 0.48175
R1376 GND.n122 GND.n22 0.48175
R1377 GND.n24 GND.n23 0.48175
R1378 GND.n527 GND.n173 0.47837
R1379 GND.n245 GND.n241 0.430671
R1380 GND.n15 GND.n183 0.413262
R1381 GND.n290 GND.n59 0.233626
R1382 GND.n288 GND.n65 0.350667
R1383 GND.n285 GND.n209 0.350667
R1384 GND.n284 GND.n57 0.350667
R1385 GND.n438 GND.n15 0.346995
R1386 GND.n56 GND.n58 1.16248
R1387 GND.n48 GND.n54 1.25115
R1388 GND.n56 GND.n59 1.12983
R1389 GND.n286 GND.n4 0.295667
R1390 GND.n287 GND.n187 0.295667
R1391 GND.n289 GND.n186 0.295667
R1392 GND.n290 GND.n5 0.295667
R1393 GND.n62 GND.n61 0.244562
R1394 GND.n383 GND.n382 0.244562
R1395 GND.n381 GND.n47 0.244562
R1396 GND.n63 GND.n379 0.244562
R1397 GND.n378 GND.n377 0.244562
R1398 GND.n35 GND.n18 0.299556
R1399 GND.n37 GND.n36 0.0789727
R1400 GND.n215 GND.n214 0.171
R1401 GND.n216 GND.n215 0.171
R1402 GND.n217 GND.n216 0.171
R1403 GND.n218 GND.n217 0.171
R1404 GND.n202 GND.n201 0.138
R1405 GND.n194 GND.n193 0.138
R1406 GND.n199 GND.n193 0.138
R1407 GND.n208 GND.n188 0.138
R1408 GND.n191 GND.n3 0.138
R1409 GND.n206 GND.n205 0.138
R1410 GND.n274 GND.n273 0.1369
R1411 GND.n273 GND.n272 0.1369
R1412 GND.n272 GND.n271 0.1369
R1413 GND.n271 GND.n270 0.1369
R1414 GND.n386 GND.n34 0.125624
R1415 GND.n38 GND.n376 0.125612
R1416 GND.n54 GND.n11 0.491283
R1417 GND.n180 GND.n165 0.123333
R1418 GND.n357 GND.n143 0.123333
R1419 GND.n374 GND.n126 0.123333
R1420 GND.n32 GND.n30 0.123333
R1421 GND.n384 GND.n381 0.122162
R1422 GND.n385 GND.n383 0.122162
R1423 GND.n385 GND.n61 0.122162
R1424 GND.n384 GND.n382 0.122162
R1425 GND.n380 GND.n378 0.122162
R1426 GND.n380 GND.n379 0.122162
R1427 GND.n515 GND.n514 0.1215
R1428 GND.n512 GND.n511 0.1215
R1429 GND.n481 GND.n480 0.1215
R1430 GND.n478 GND.n477 0.1215
R1431 GND.n477 GND.n476 0.1215
R1432 GND.n474 GND.n473 0.1215
R1433 GND.n443 GND.n442 0.1215
R1434 GND.n440 GND.n439 0.1215
R1435 GND.n389 GND.n19 0.1215
R1436 GND.n373 GND.n127 0.119939
R1437 GND.n179 GND.n166 0.119939
R1438 GND.n356 GND.n144 0.119939
R1439 GND.n122 GND.n115 0.119667
R1440 GND.n182 GND.n164 0.119667
R1441 GND.n359 GND.n142 0.119667
R1442 GND.n483 GND.n482 0.118106
R1443 GND.n472 GND.n471 0.118106
R1444 GND.n510 GND.n509 0.118106
R1445 GND.n445 GND.n444 0.118106
R1446 GND.n533 GND.n123 0.116272
R1447 GND.n338 GND.n163 0.116272
R1448 GND.n360 GND.n141 0.116272
R1449 GND.n178 GND.n167 0.116
R1450 GND.n355 GND.n145 0.116
R1451 GND.n372 GND.n128 0.116
R1452 GND.n508 GND.n507 0.114167
R1453 GND.n485 GND.n484 0.114167
R1454 GND.n470 GND.n469 0.114167
R1455 GND.n447 GND.n446 0.114167
R1456 GND.n177 GND.n168 0.112606
R1457 GND.n354 GND.n146 0.112606
R1458 GND.n371 GND.n129 0.112606
R1459 GND.n532 GND.n121 0.112333
R1460 GND.n339 GND.n162 0.112333
R1461 GND.n361 GND.n140 0.112333
R1462 GND.n392 GND.n391 0.112333
R1463 GND.n436 GND.n435 0.112333
R1464 GND.n506 GND.n505 0.110772
R1465 GND.n487 GND.n486 0.110772
R1466 GND.n468 GND.n467 0.110772
R1467 GND.n449 GND.n448 0.110772
R1468 GND.n16 GND.n388 0.1105
R1469 GND.n433 GND.n432 0.1105
R1470 GND.n531 GND.n120 0.108939
R1471 GND.n340 GND.n161 0.108939
R1472 GND.n362 GND.n139 0.108939
R1473 GND.n176 GND.n169 0.108667
R1474 GND.n353 GND.n147 0.108667
R1475 GND.n370 GND.n130 0.108667
R1476 GND.n504 GND.n503 0.106833
R1477 GND.n489 GND.n488 0.106833
R1478 GND.n466 GND.n465 0.106833
R1479 GND.n451 GND.n450 0.106833
R1480 GND.n394 GND.n393 0.106833
R1481 GND.n247 GND.n246 0.1061
R1482 GND.n248 GND.n238 0.1061
R1483 GND.n249 GND.n248 0.1061
R1484 GND.n247 GND.n237 0.1061
R1485 GND.n237 GND.n236 0.1061
R1486 GND.n250 GND.n249 0.1061
R1487 GND.n251 GND.n250 0.1061
R1488 GND.n252 GND.n236 0.1061
R1489 GND.n253 GND.n252 0.1061
R1490 GND.n251 GND.n235 0.1061
R1491 GND.n235 GND.n234 0.1061
R1492 GND.n254 GND.n253 0.1061
R1493 GND.n255 GND.n254 0.1061
R1494 GND.n257 GND.n256 0.1061
R1495 GND.n256 GND.n234 0.1061
R1496 GND.n255 GND.n233 0.1061
R1497 GND.n233 GND.n232 0.1061
R1498 GND.n258 GND.n257 0.1061
R1499 GND.n259 GND.n258 0.1061
R1500 GND.n260 GND.n232 0.1061
R1501 GND.n261 GND.n260 0.1061
R1502 GND.n259 GND.n231 0.1061
R1503 GND.n231 GND.n230 0.1061
R1504 GND.n262 GND.n261 0.1061
R1505 GND.n263 GND.n262 0.1061
R1506 GND.n264 GND.n230 0.1061
R1507 GND.n265 GND.n264 0.1061
R1508 GND.n263 GND.n229 0.1061
R1509 GND.n223 GND.n220 0.1061
R1510 GND.n225 GND.n224 0.1061
R1511 GND.n224 GND.n221 0.1061
R1512 GND.n223 GND.n222 0.1061
R1513 GND.n222 GND.n218 0.1061
R1514 GND.n221 GND.n214 0.1061
R1515 GND.n175 GND.n170 0.105272
R1516 GND.n352 GND.n148 0.105272
R1517 GND.n369 GND.n131 0.105272
R1518 GND.n530 GND.n124 0.105
R1519 GND.n341 GND.n160 0.105
R1520 GND.n363 GND.n138 0.105
R1521 GND.n431 GND.n430 0.105
R1522 GND.n491 GND.n490 0.103439
R1523 GND.n464 GND.n463 0.103439
R1524 GND.n502 GND.n501 0.103439
R1525 GND.n453 GND.n452 0.103439
R1526 GND.n529 GND.n125 0.101606
R1527 GND.n342 GND.n159 0.101606
R1528 GND.n364 GND.n137 0.101606
R1529 GND.n174 GND.n171 0.101333
R1530 GND.n346 GND.n154 0.101333
R1531 GND.n351 GND.n149 0.101333
R1532 GND.n368 GND.n132 0.101333
R1533 GND.n396 GND.n395 0.101333
R1534 GND.n290 GND.n289 0.101263
R1535 GND.n289 GND.n288 0.101263
R1536 GND.n288 GND.n287 0.101263
R1537 GND.n287 GND.n286 0.101263
R1538 GND.n286 GND.n285 0.101263
R1539 GND.n285 GND.n284 0.101263
R1540 GND.n284 GND.n283 0.101263
R1541 GND.n500 GND.n499 0.0995
R1542 GND.n493 GND.n492 0.0995
R1543 GND.n462 GND.n461 0.0995
R1544 GND.n455 GND.n454 0.0995
R1545 GND.n429 GND.n428 0.0995
R1546 GND.n173 GND.n172 0.0981012
R1547 GND.n350 GND.n150 0.0979389
R1548 GND.n345 GND.n155 0.0979389
R1549 GND.n367 GND.n133 0.0979389
R1550 GND.n528 GND.n119 0.0976667
R1551 GND.n343 GND.n158 0.0976667
R1552 GND.n348 GND.n153 0.0976667
R1553 GND.n365 GND.n136 0.0976667
R1554 GND.n498 GND.n497 0.0961056
R1555 GND.n457 GND.n456 0.0961056
R1556 GND.n495 GND.n494 0.0961056
R1557 GND.n460 GND.n459 0.0961056
R1558 GND.n398 GND.n397 0.0958333
R1559 GND.n541 GND.n118 0.0942723
R1560 GND.n344 GND.n157 0.0942723
R1561 GND.n366 GND.n135 0.0942723
R1562 GND.n349 GND.n152 0.0942723
R1563 GND.n542 GND.n541 0.094
R1564 GND.n344 GND.n156 0.094
R1565 GND.n349 GND.n151 0.094
R1566 GND.n366 GND.n134 0.094
R1567 GND.n427 GND.n426 0.094
R1568 GND.n497 GND.n496 0.0921667
R1569 GND.n496 GND.n495 0.0921667
R1570 GND.n459 GND.n458 0.0921667
R1571 GND.n458 GND.n457 0.0921667
R1572 GND.n526 GND.n525 0.0914091
R1573 GND.n525 GND.n524 0.0914091
R1574 GND.n524 GND.n523 0.0914091
R1575 GND.n523 GND.n522 0.0914091
R1576 GND.n522 GND.n521 0.0914091
R1577 GND.n521 GND.n520 0.0914091
R1578 GND.n520 GND.n519 0.0914091
R1579 GND.n519 GND.n518 0.0914091
R1580 GND.n542 GND.n173 0.0907851
R1581 GND.n528 GND.n118 0.0906056
R1582 GND.n343 GND.n157 0.0906056
R1583 GND.n365 GND.n135 0.0906056
R1584 GND.n348 GND.n152 0.0906056
R1585 GND.n345 GND.n156 0.0903333
R1586 GND.n350 GND.n151 0.0903333
R1587 GND.n367 GND.n134 0.0903333
R1588 GND.n400 GND.n399 0.0903333
R1589 GND.n527 GND.n526 0.0888902
R1590 GND.n499 GND.n498 0.0887723
R1591 GND.n456 GND.n455 0.0887723
R1592 GND.n494 GND.n493 0.0887723
R1593 GND.n461 GND.n460 0.0887723
R1594 GND.n203 GND.n5 0.0885
R1595 GND.n114 GND.n4 0.0885
R1596 GND.n425 GND.n424 0.0885
R1597 GND.n174 GND.n172 0.0869389
R1598 GND.n351 GND.n150 0.0869389
R1599 GND.n346 GND.n155 0.0869389
R1600 GND.n368 GND.n133 0.0869389
R1601 GND.n529 GND.n119 0.0866667
R1602 GND.n342 GND.n158 0.0866667
R1603 GND.n347 GND.n153 0.0866667
R1604 GND.n364 GND.n136 0.0866667
R1605 GND.n501 GND.n500 0.0848333
R1606 GND.n492 GND.n491 0.0848333
R1607 GND.n463 GND.n462 0.0848333
R1608 GND.n454 GND.n453 0.0848333
R1609 GND.n402 GND.n401 0.0848333
R1610 GND.n530 GND.n125 0.0832723
R1611 GND.n341 GND.n159 0.0832723
R1612 GND.n363 GND.n137 0.0832723
R1613 GND.n175 GND.n171 0.083
R1614 GND.n347 GND.n154 0.083
R1615 GND.n352 GND.n149 0.083
R1616 GND.n369 GND.n132 0.083
R1617 GND.n423 GND.n422 0.083
R1618 GND.n490 GND.n489 0.081439
R1619 GND.n465 GND.n464 0.081439
R1620 GND.n503 GND.n502 0.0814389
R1621 GND.n452 GND.n451 0.0814389
R1622 GND.n185 GND.n59 0.0617308
R1623 GND.n57 GND.n210 0.0797763
R1624 GND.n370 GND.n131 0.0796056
R1625 GND.n176 GND.n170 0.0796056
R1626 GND.n353 GND.n148 0.0796056
R1627 GND.n531 GND.n124 0.0793333
R1628 GND.n340 GND.n160 0.0793333
R1629 GND.n362 GND.n138 0.0793333
R1630 GND.n404 GND.n403 0.0793333
R1631 GND.n505 GND.n504 0.0775
R1632 GND.n488 GND.n487 0.0775
R1633 GND.n467 GND.n466 0.0775
R1634 GND.n450 GND.n449 0.0775
R1635 GND.n203 GND.n185 0.0775
R1636 GND.n198 GND.n65 0.0775
R1637 GND.n195 GND.n65 0.0775
R1638 GND.n209 GND.n114 0.0775
R1639 GND.n421 GND.n420 0.0775
R1640 GND.n532 GND.n120 0.0759389
R1641 GND.n339 GND.n161 0.0759389
R1642 GND.n361 GND.n139 0.0759389
R1643 GND.n177 GND.n169 0.0756667
R1644 GND.n354 GND.n147 0.0756667
R1645 GND.n371 GND.n130 0.0756667
R1646 GND.n507 GND.n506 0.0741056
R1647 GND.n448 GND.n447 0.0741056
R1648 GND.n486 GND.n485 0.0741056
R1649 GND.n469 GND.n468 0.0741056
R1650 GND.n406 GND.n405 0.0738333
R1651 GND.n178 GND.n168 0.0722723
R1652 GND.n355 GND.n146 0.0722723
R1653 GND.n372 GND.n129 0.0722723
R1654 GND.n533 GND.n121 0.072
R1655 GND.n338 GND.n162 0.072
R1656 GND.n360 GND.n140 0.072
R1657 GND.n419 GND.n418 0.072
R1658 GND.n509 GND.n508 0.0701667
R1659 GND.n484 GND.n483 0.0701667
R1660 GND.n471 GND.n470 0.0701667
R1661 GND.n446 GND.n445 0.0701667
R1662 GND.n414 GND.n413 0.0701667
R1663 GND.n207 GND.n202 0.0694731
R1664 GND.n200 GND.n199 0.0694731
R1665 GND.n194 GND.n192 0.0694731
R1666 GND.n3 GND.n189 0.0694731
R1667 GND.n189 GND.n188 0.0694731
R1668 GND.n192 GND.n191 0.0694731
R1669 GND.n205 GND.n200 0.0694731
R1670 GND.n207 GND.n206 0.0694731
R1671 GND.n123 GND.n122 0.0686056
R1672 GND.n55 GND.n48 1.25668
R1673 GND.n47 GND.n44 0.486679
R1674 GND.n46 GND.n39 0.486679
R1675 GND.n413 GND.n42 1.22429
R1676 GND.n44 GND.n43 0.367943
R1677 GND.n60 GND.n45 0.366224
R1678 GND.n41 GND.n40 0.366224
R1679 GND.n182 GND.n163 0.0686056
R1680 GND.n359 GND.n141 0.0686056
R1681 GND.n179 GND.n167 0.0683333
R1682 GND.n356 GND.n145 0.0683333
R1683 GND.n373 GND.n128 0.0683333
R1684 GND.n408 GND.n407 0.0683333
R1685 GND.n411 GND.n410 0.0683333
R1686 GND.n540 GND.n527 0.0677202
R1687 GND.n540 GND.n539 0.0671667
R1688 GND.n482 GND.n481 0.0667723
R1689 GND.n473 GND.n472 0.0667723
R1690 GND.n390 GND.n389 0.0667723
R1691 GND.n511 GND.n510 0.0667723
R1692 GND.n444 GND.n443 0.0667723
R1693 GND.n228 GND.n225 0.0665
R1694 GND.n266 GND.n220 0.0665
R1695 GND.n197 GND.n186 0.0665
R1696 GND.n196 GND.n187 0.0665
R1697 GND.n417 GND.n416 0.0665
R1698 GND.n283 GND.n58 0.360009
R1699 GND.n64 GND.n46 0.290977
R1700 GND.n37 GND.n39 0.408961
R1701 GND.n31 GND.n38 0.244562
R1702 GND.n18 GND.n34 0.244562
R1703 GND.n36 GND.n31 0.243919
R1704 GND.n374 GND.n127 0.0649389
R1705 GND.n30 GND.n434 0.0649389
R1706 GND.n180 GND.n166 0.0649389
R1707 GND.n357 GND.n144 0.0649389
R1708 GND.n23 GND.n115 0.0646667
R1709 GND.n181 GND.n164 0.0646667
R1710 GND.n358 GND.n142 0.0646667
R1711 GND.n375 GND.n55 0.174763
R1712 GND.n416 GND.n415 0.0646667
R1713 GND.n514 GND.n513 0.0628333
R1714 GND.n513 GND.n512 0.0628333
R1715 GND.n480 GND.n479 0.0628333
R1716 GND.n479 GND.n478 0.0628333
R1717 GND.n476 GND.n475 0.0628333
R1718 GND.n475 GND.n474 0.0628333
R1719 GND.n442 GND.n441 0.0628333
R1720 GND.n441 GND.n440 0.0628333
R1721 GND.n409 GND.n408 0.0628333
R1722 GND.n410 GND.n409 0.0628333
R1723 GND.n23 GND.n54 0.174484
R1724 GND.n17 GND.n16 0.0777723
R1725 GND.n21 GND.n433 0.0777723
R1726 GND.n181 GND.n165 0.061
R1727 GND.n358 GND.n143 0.061
R1728 GND.n375 GND.n126 0.061
R1729 GND.n415 GND.n414 0.061
R1730 GND.n418 GND.n417 0.0591667
R1731 GND.n539 GND.n538 0.0576823
R1732 GND.n407 GND.n406 0.0573333
R1733 GND.n538 GND.n537 0.0546872
R1734 GND.n420 GND.n419 0.0536667
R1735 GND.n516 GND.n515 0.0529986
R1736 GND.n405 GND.n404 0.0518333
R1737 GND.n537 GND.n536 0.0509226
R1738 GND.n517 GND.n516 0.0493319
R1739 GND.n422 GND.n421 0.0481667
R1740 GND.n58 GND.n57 0.10249
R1741 GND.n403 GND.n402 0.0463333
R1742 GND.n535 GND.n534 0.0450344
R1743 GND.n536 GND.n535 0.0450344
R1744 GND.n204 GND.n186 0.0445
R1745 GND.n190 GND.n187 0.0445
R1746 GND.n424 GND.n423 0.0426667
R1747 GND.n401 GND.n400 0.0408333
R1748 GND.n241 GND.n238 0.0401
R1749 GND.n246 GND.n245 0.0401
R1750 GND.n229 GND.n228 0.0401
R1751 GND.n266 GND.n265 0.0401
R1752 GND.n282 GND.n211 0.0371667
R1753 GND.n426 GND.n425 0.0371667
R1754 GND.n24 GND.n22 0.0371667
R1755 GND.n399 GND.n398 0.0353333
R1756 GND.n534 GND.n22 0.0351796
R1757 GND.n210 GND.n209 0.0321096
R1758 GND.n428 GND.n427 0.0316667
R1759 GND.n543 GND.n116 0.0300385
R1760 GND.n543 GND.n33 0.0300385
R1761 GND.n281 GND.n212 0.0300385
R1762 GND.n278 GND.n212 0.0300385
R1763 GND.n280 GND.n7 0.0300385
R1764 GND.n279 GND.n7 0.0300385
R1765 GND.n1 GND.n276 2.26567
R1766 GND.n545 GND.n9 0.0300385
R1767 GND.n544 GND.n9 0.0300385
R1768 GND.n544 GND.n117 0.0300385
R1769 GND.n545 GND.n12 2.26576
R1770 GND.n25 GND.n5 0.103465
R1771 GND.n26 GND.n4 0.103465
R1772 GND.n397 GND.n396 0.0298333
R1773 GND.n10 GND.n6 0.0300873
R1774 GND.n518 GND.n517 0.0277727
R1775 GND.n430 GND.n429 0.0261667
R1776 GND.n395 GND.n394 0.0243333
R1777 GND.n198 GND.n197 0.0225
R1778 GND.n196 GND.n195 0.0225
R1779 GND.n388 GND.n387 0.0206667
R1780 GND.n432 GND.n431 0.0206667
R1781 GND.n393 GND.n392 0.0188333
R1782 GND.n437 GND.n436 0.0188333
R1783 GND.n277 GND.n276 0.0157923
R1784 GND.n278 GND.n277 0.0155551
R1785 GND.n204 GND.n25 0.0741316
R1786 GND.n190 GND.n26 0.0741316
R1787 GND.n391 GND.n28 0.075939
R1788 GND.n435 GND.n29 0.075939
R1789 GND.n8 GND.n0 0.0749419
R1790 GND.n24 GND.n11 0.0470972
R1791 GND.n117 GND.n2 2.27341
R1792 GND GND.n0 0.0005
R1793 a_n11685_3060.t2 a_n11685_3060.n4 2.59741
R1794 a_n11685_3060.t62 a_n11685_3060.n110 3.75442
R1795 a_n11685_3060.t60 a_n11685_3060.n8 2.54375
R1796 a_n11685_3060.t60 a_n11685_3060.n5 2.55888
R1797 a_n11685_3060.n98 a_n11685_3060.n6 0.206782
R1798 a_n11685_3060.t59 a_n11685_3060.n9 2.54386
R1799 a_n11685_3060.t58 a_n11685_3060.n112 3.75442
R1800 a_n11685_3060.n99 a_n11685_3060.n14 0.206782
R1801 a_n11685_3060.t4 a_n11685_3060.n17 2.54375
R1802 a_n11685_3060.t56 a_n11685_3060.n18 2.54386
R1803 a_n11685_3060.t56 a_n11685_3060.n12 2.59752
R1804 a_n11685_3060.t55 a_n11685_3060.n13 2.55888
R1805 a_n11685_3060.n113 a_n11685_3060.t54 3.75442
R1806 a_n11685_3060.n100 a_n11685_3060.n23 0.206782
R1807 a_n11685_3060.t6 a_n11685_3060.n26 2.54375
R1808 a_n11685_3060.t52 a_n11685_3060.n27 2.54386
R1809 a_n11685_3060.t52 a_n11685_3060.n20 2.59752
R1810 a_n11685_3060.t51 a_n11685_3060.n21 2.55888
R1811 a_n11685_3060.t50 a_n11685_3060.n115 3.75442
R1812 a_n11685_3060.n101 a_n11685_3060.n32 0.206782
R1813 a_n11685_3060.t8 a_n11685_3060.n35 2.54375
R1814 a_n11685_3060.t48 a_n11685_3060.n36 2.54386
R1815 a_n11685_3060.t48 a_n11685_3060.n30 2.59752
R1816 a_n11685_3060.t47 a_n11685_3060.n31 2.55888
R1817 a_n11685_3060.n116 a_n11685_3060.t46 3.75442
R1818 a_n11685_3060.n102 a_n11685_3060.n41 0.206782
R1819 a_n11685_3060.t10 a_n11685_3060.n44 2.54375
R1820 a_n11685_3060.t44 a_n11685_3060.n45 2.54386
R1821 a_n11685_3060.t44 a_n11685_3060.n38 2.59752
R1822 a_n11685_3060.t43 a_n11685_3060.n39 2.55888
R1823 a_n11685_3060.t42 a_n11685_3060.n0 2.58153
R1824 a_n11685_3060.n117 a_n11685_3060.t42 3.75442
R1825 a_n11685_3060.n103 a_n11685_3060.n47 0.206782
R1826 a_n11685_3060.t12 a_n11685_3060.n50 2.54375
R1827 a_n11685_3060.t40 a_n11685_3060.n51 2.54386
R1828 a_n11685_3060.t41 a_n11685_3060.n0 2.57845
R1829 a_n11685_3060.t39 a_n11685_3060.n1 2.55114
R1830 a_n11685_3060.t14 a_n11685_3060.n54 2.59741
R1831 a_n11685_3060.t38 a_n11685_3060.n120 3.75442
R1832 a_n11685_3060.t36 a_n11685_3060.n58 2.54375
R1833 a_n11685_3060.t36 a_n11685_3060.n55 2.55888
R1834 a_n11685_3060.n104 a_n11685_3060.n56 0.206782
R1835 a_n11685_3060.t35 a_n11685_3060.n59 2.54386
R1836 a_n11685_3060.t16 a_n11685_3060.n62 2.59741
R1837 a_n11685_3060.t34 a_n11685_3060.n123 3.75442
R1838 a_n11685_3060.t32 a_n11685_3060.n66 2.54375
R1839 a_n11685_3060.t32 a_n11685_3060.n63 2.55888
R1840 a_n11685_3060.n105 a_n11685_3060.n64 0.206782
R1841 a_n11685_3060.t31 a_n11685_3060.n67 2.54386
R1842 a_n11685_3060.t18 a_n11685_3060.n70 2.59741
R1843 a_n11685_3060.t30 a_n11685_3060.n126 3.75442
R1844 a_n11685_3060.t28 a_n11685_3060.n74 2.54375
R1845 a_n11685_3060.t28 a_n11685_3060.n71 2.55888
R1846 a_n11685_3060.n106 a_n11685_3060.n72 0.206782
R1847 a_n11685_3060.t27 a_n11685_3060.n75 2.54386
R1848 a_n11685_3060.t20 a_n11685_3060.n77 2.59741
R1849 a_n11685_3060.t26 a_n11685_3060.n129 3.75442
R1850 a_n11685_3060.t24 a_n11685_3060.n81 2.54375
R1851 a_n11685_3060.t24 a_n11685_3060.n78 2.55888
R1852 a_n11685_3060.n107 a_n11685_3060.n79 0.206782
R1853 a_n11685_3060.t23 a_n11685_3060.n82 2.54386
R1854 a_n11685_3060.t62 a_n11685_3060.n108 7.46848
R1855 a_n11685_3060.t61 a_n11685_3060.n98 2.4252
R1856 a_n11685_3060.t58 a_n11685_3060.n111 7.46848
R1857 a_n11685_3060.n99 a_n11685_3060.t3 2.4252
R1858 a_n11685_3060.t54 a_n11685_3060.n130 7.46848
R1859 a_n11685_3060.n100 a_n11685_3060.t5 2.4252
R1860 a_n11685_3060.t50 a_n11685_3060.n114 7.46848
R1861 a_n11685_3060.n101 a_n11685_3060.t7 2.4252
R1862 a_n11685_3060.t46 a_n11685_3060.n131 7.46848
R1863 a_n11685_3060.n102 a_n11685_3060.t9 2.4252
R1864 a_n11685_3060.t42 a_n11685_3060.n132 7.46848
R1865 a_n11685_3060.n103 a_n11685_3060.t11 2.4252
R1866 a_n11685_3060.t38 a_n11685_3060.n118 7.46848
R1867 a_n11685_3060.t37 a_n11685_3060.n104 2.4252
R1868 a_n11685_3060.t34 a_n11685_3060.n121 7.46848
R1869 a_n11685_3060.t33 a_n11685_3060.n105 2.4252
R1870 a_n11685_3060.t30 a_n11685_3060.n124 7.46848
R1871 a_n11685_3060.t29 a_n11685_3060.n106 2.4252
R1872 a_n11685_3060.t26 a_n11685_3060.n127 7.46848
R1873 a_n11685_3060.t25 a_n11685_3060.n107 2.4252
R1874 a_n11685_3060.n110 a_n11685_3060.n6 0.422632
R1875 a_n11685_3060.n5 a_n11685_3060.n3 0.0952789
R1876 a_n11685_3060.n7 a_n11685_3060.n9 0.0908122
R1877 a_n11685_3060.n16 a_n11685_3060.n18 0.0908122
R1878 a_n11685_3060.n13 a_n11685_3060.n11 0.0952789
R1879 a_n11685_3060.n27 a_n11685_3060.n25 0.0908122
R1880 a_n11685_3060.n19 a_n11685_3060.n21 0.0952789
R1881 a_n11685_3060.n34 a_n11685_3060.n36 0.0908122
R1882 a_n11685_3060.n31 a_n11685_3060.n29 0.0952789
R1883 a_n11685_3060.n45 a_n11685_3060.n43 0.0908122
R1884 a_n11685_3060.n37 a_n11685_3060.n39 0.0952789
R1885 a_n11685_3060.n51 a_n11685_3060.n49 0.0908122
R1886 a_n11685_3060.n120 a_n11685_3060.n56 0.422632
R1887 a_n11685_3060.n55 a_n11685_3060.n53 0.0952789
R1888 a_n11685_3060.n57 a_n11685_3060.n59 0.0908122
R1889 a_n11685_3060.n123 a_n11685_3060.n64 0.422632
R1890 a_n11685_3060.n63 a_n11685_3060.n61 0.0952789
R1891 a_n11685_3060.n65 a_n11685_3060.n67 0.0908122
R1892 a_n11685_3060.n126 a_n11685_3060.n72 0.422632
R1893 a_n11685_3060.n71 a_n11685_3060.n69 0.0952789
R1894 a_n11685_3060.n73 a_n11685_3060.n75 0.0908122
R1895 a_n11685_3060.n129 a_n11685_3060.n79 0.422632
R1896 a_n11685_3060.n78 a_n11685_3060.n76 0.0952789
R1897 a_n11685_3060.n80 a_n11685_3060.n82 0.0908122
R1898 a_n11685_3060.n3 a_n11685_3060.n4 0.0269108
R1899 a_n11685_3060.n7 a_n11685_3060.n8 0.0908103
R1900 a_n11685_3060.n16 a_n11685_3060.n17 0.0908103
R1901 a_n11685_3060.n25 a_n11685_3060.n26 0.0908103
R1902 a_n11685_3060.n34 a_n11685_3060.n35 0.0908103
R1903 a_n11685_3060.n43 a_n11685_3060.n44 0.0908103
R1904 a_n11685_3060.n49 a_n11685_3060.n50 0.0908103
R1905 a_n11685_3060.n53 a_n11685_3060.n54 0.0269108
R1906 a_n11685_3060.n57 a_n11685_3060.n58 0.0908103
R1907 a_n11685_3060.n61 a_n11685_3060.n62 0.0269108
R1908 a_n11685_3060.n65 a_n11685_3060.n66 0.0908103
R1909 a_n11685_3060.n69 a_n11685_3060.n70 0.0269108
R1910 a_n11685_3060.n73 a_n11685_3060.n74 0.0908103
R1911 a_n11685_3060.n76 a_n11685_3060.n77 0.0269108
R1912 a_n11685_3060.n80 a_n11685_3060.n81 0.0908103
R1913 a_n11685_3060.n138 a_n11685_3060.t22 3.98203
R1914 a_n11685_3060.n150 a_n11685_3060.n87 2.86295
R1915 a_n11685_3060.t21 a_n11685_3060.n150 2.19356
R1916 a_n11685_3060.n87 a_n11685_3060.n149 2.00358
R1917 a_n11685_3060.n68 a_n11685_3060.n90 0.93557
R1918 a_n11685_3060.n89 a_n11685_3060.n60 0.93557
R1919 a_n11685_3060.n52 a_n11685_3060.n88 2.00358
R1920 a_n11685_3060.n133 a_n11685_3060.n147 2.00358
R1921 a_n11685_3060.n146 a_n11685_3060.n46 2.00358
R1922 a_n11685_3060.n145 a_n11685_3060.n144 2.00358
R1923 a_n11685_3060.n40 a_n11685_3060.n136 2.00358
R1924 a_n11685_3060.n140 a_n11685_3060.n139 2.00358
R1925 a_n11685_3060.n95 a_n11685_3060.n134 2.00358
R1926 a_n11685_3060.n22 a_n11685_3060.n96 0.93557
R1927 a_n11685_3060.n86 a_n11685_3060.n85 0.93557
R1928 a_n11685_3060.n2 a_n11685_3060.n138 2.00358
R1929 a_n11685_3060.n149 a_n11685_3060.n148 1.75761
R1930 a_n11685_3060.n91 a_n11685_3060.n68 0.813207
R1931 a_n11685_3060.n91 a_n11685_3060.n93 0.133701
R1932 a_n11685_3060.n94 a_n11685_3060.n60 0.813207
R1933 a_n11685_3060.n92 a_n11685_3060.n52 1.75761
R1934 a_n11685_3060.n133 a_n11685_3060.n135 1.75761
R1935 a_n11685_3060.n137 a_n11685_3060.n46 1.75761
R1936 a_n11685_3060.n144 a_n11685_3060.n143 1.75761
R1937 a_n11685_3060.n142 a_n11685_3060.n40 1.75761
R1938 a_n11685_3060.n141 a_n11685_3060.n140 1.75761
R1939 a_n11685_3060.n134 a_n11685_3060.n28 1.75761
R1940 a_n11685_3060.n97 a_n11685_3060.n22 0.813207
R1941 a_n11685_3060.n97 a_n11685_3060.n84 0.133701
R1942 a_n11685_3060.n10 a_n11685_3060.n85 0.813207
R1943 a_n11685_3060.n83 a_n11685_3060.n2 1.75761
R1944 a_n11685_3060.n150 a_n11685_3060.t1 1.14884
R1945 a_n11685_3060.t21 a_n11685_3060.t1 1.0397
R1946 a_n11685_3060.n60 a_n11685_3060.n52 0.574664
R1947 a_n11685_3060.n22 a_n11685_3060.n85 0.574664
R1948 a_n11685_3060.n68 a_n11685_3060.n60 0.574664
R1949 a_n11685_3060.n85 a_n11685_3060.n2 0.574664
R1950 a_n11685_3060.t0 a_n11685_3060.n4 2.62112
R1951 a_n11685_3060.n109 a_n11685_3060.n7 0.259027
R1952 a_n11685_3060.n108 a_n11685_3060.n109 0.076197
R1953 a_n11685_3060.n16 a_n11685_3060.n15 0.259027
R1954 a_n11685_3060.n111 a_n11685_3060.n15 0.076197
R1955 a_n11685_3060.n12 a_n11685_3060.t58 2.62112
R1956 a_n11685_3060.n25 a_n11685_3060.n24 0.259027
R1957 a_n11685_3060.n130 a_n11685_3060.n24 0.076197
R1958 a_n11685_3060.n20 a_n11685_3060.t54 2.62112
R1959 a_n11685_3060.n34 a_n11685_3060.n33 0.259027
R1960 a_n11685_3060.n114 a_n11685_3060.n33 0.076197
R1961 a_n11685_3060.n30 a_n11685_3060.t50 2.62112
R1962 a_n11685_3060.n43 a_n11685_3060.n42 0.259027
R1963 a_n11685_3060.n131 a_n11685_3060.n42 0.076197
R1964 a_n11685_3060.n38 a_n11685_3060.t46 2.62112
R1965 a_n11685_3060.n49 a_n11685_3060.n48 0.259027
R1966 a_n11685_3060.n132 a_n11685_3060.n48 0.076197
R1967 a_n11685_3060.n1 a_n11685_3060.n0 0.147902
R1968 a_n11685_3060.t13 a_n11685_3060.n54 2.62112
R1969 a_n11685_3060.n119 a_n11685_3060.n57 0.259027
R1970 a_n11685_3060.n118 a_n11685_3060.n119 0.076197
R1971 a_n11685_3060.t15 a_n11685_3060.n62 2.62112
R1972 a_n11685_3060.n122 a_n11685_3060.n65 0.259027
R1973 a_n11685_3060.n121 a_n11685_3060.n122 0.076197
R1974 a_n11685_3060.t17 a_n11685_3060.n70 2.62112
R1975 a_n11685_3060.n125 a_n11685_3060.n73 0.259027
R1976 a_n11685_3060.n124 a_n11685_3060.n125 0.076197
R1977 a_n11685_3060.t19 a_n11685_3060.n77 2.62112
R1978 a_n11685_3060.n128 a_n11685_3060.n80 0.259027
R1979 a_n11685_3060.n127 a_n11685_3060.n128 0.076197
R1980 a_n11685_3060.n149 a_n11685_3060.n76 0.495943
R1981 a_n11685_3060.n3 a_n11685_3060.n2 0.495943
R1982 a_n11685_3060.n83 a_n11685_3060.n7 0.495943
R1983 a_n11685_3060.n148 a_n11685_3060.n80 0.495943
R1984 a_n11685_3060.n69 a_n11685_3060.n68 0.4505
R1985 a_n11685_3060.n61 a_n11685_3060.n60 0.4505
R1986 a_n11685_3060.n53 a_n11685_3060.n52 0.4505
R1987 a_n11685_3060.n49 a_n11685_3060.n46 0.4505
R1988 a_n11685_3060.n137 a_n11685_3060.n0 0.4505
R1989 a_n11685_3060.n43 a_n11685_3060.n40 0.4505
R1990 a_n11685_3060.n142 a_n11685_3060.n37 0.4505
R1991 a_n11685_3060.n134 a_n11685_3060.n34 0.4505
R1992 a_n11685_3060.n25 a_n11685_3060.n22 0.4505
R1993 a_n11685_3060.n85 a_n11685_3060.n16 0.4505
R1994 a_n11685_3060.n11 a_n11685_3060.n10 0.4505
R1995 a_n11685_3060.n84 a_n11685_3060.n19 0.4505
R1996 a_n11685_3060.n29 a_n11685_3060.n28 0.4505
R1997 a_n11685_3060.n92 a_n11685_3060.n57 0.4505
R1998 a_n11685_3060.n94 a_n11685_3060.n65 0.4505
R1999 a_n11685_3060.n93 a_n11685_3060.n73 0.4505
R2000 a_n11685_3060.n82 a_n11685_3060.n107 0.55231
R2001 a_n11685_3060.n75 a_n11685_3060.n106 0.55231
R2002 a_n11685_3060.n67 a_n11685_3060.n105 0.55231
R2003 a_n11685_3060.n59 a_n11685_3060.n104 0.55231
R2004 a_n11685_3060.n50 a_n11685_3060.n103 0.552312
R2005 a_n11685_3060.n149 a_n11685_3060.n68 0.287582
R2006 a_n11685_3060.n90 a_n11685_3060.n87 0.422025
R2007 a_n11685_3060.n90 a_n11685_3060.n89 0.556467
R2008 a_n11685_3060.n89 a_n11685_3060.n88 0.422025
R2009 a_n11685_3060.n147 a_n11685_3060.n88 0.287582
R2010 a_n11685_3060.n133 a_n11685_3060.n46 0.287582
R2011 a_n11685_3060.n147 a_n11685_3060.n146 0.287582
R2012 a_n11685_3060.n146 a_n11685_3060.n145 0.287582
R2013 a_n11685_3060.n144 a_n11685_3060.n46 0.287582
R2014 a_n11685_3060.n144 a_n11685_3060.n40 0.287582
R2015 a_n11685_3060.n145 a_n11685_3060.n136 0.287582
R2016 a_n11685_3060.n139 a_n11685_3060.n136 0.287582
R2017 a_n11685_3060.n140 a_n11685_3060.n40 0.287582
R2018 a_n11685_3060.n139 a_n11685_3060.n95 0.287582
R2019 a_n11685_3060.n134 a_n11685_3060.n22 0.287582
R2020 a_n11685_3060.n96 a_n11685_3060.n95 0.422025
R2021 a_n11685_3060.n96 a_n11685_3060.n86 0.556467
R2022 a_n11685_3060.n86 a_n11685_3060.n138 0.422025
R2023 a_n11685_3060.n10 a_n11685_3060.n83 0.420782
R2024 a_n11685_3060.n28 a_n11685_3060.n97 0.420782
R2025 a_n11685_3060.n142 a_n11685_3060.n141 0.287582
R2026 a_n11685_3060.n143 a_n11685_3060.n142 0.287582
R2027 a_n11685_3060.n143 a_n11685_3060.n137 0.287582
R2028 a_n11685_3060.n137 a_n11685_3060.n135 0.287582
R2029 a_n11685_3060.n94 a_n11685_3060.n92 0.420782
R2030 a_n11685_3060.n148 a_n11685_3060.n91 0.420782
R2031 a_n11685_3060.n92 a_n11685_3060.n135 0.287582
R2032 a_n11685_3060.n141 a_n11685_3060.n28 0.287582
R2033 a_n11685_3060.n140 a_n11685_3060.n134 0.287582
R2034 a_n11685_3060.n52 a_n11685_3060.n133 0.287582
R2035 a_n11685_3060.n128 a_n11685_3060.n129 0.266703
R2036 a_n11685_3060.n125 a_n11685_3060.n126 0.266703
R2037 a_n11685_3060.n122 a_n11685_3060.n123 0.266703
R2038 a_n11685_3060.n119 a_n11685_3060.n120 0.266703
R2039 a_n11685_3060.n117 a_n11685_3060.n48 0.266703
R2040 a_n11685_3060.n116 a_n11685_3060.n42 0.266703
R2041 a_n11685_3060.n115 a_n11685_3060.n33 0.266703
R2042 a_n11685_3060.n113 a_n11685_3060.n24 0.266703
R2043 a_n11685_3060.n112 a_n11685_3060.n15 0.266703
R2044 a_n11685_3060.n109 a_n11685_3060.n110 0.266703
R2045 a_n11685_3060.n8 a_n11685_3060.n108 0.331003
R2046 a_n11685_3060.n18 a_n11685_3060.n111 0.331001
R2047 a_n11685_3060.n130 a_n11685_3060.n27 0.331001
R2048 a_n11685_3060.n36 a_n11685_3060.n114 0.331001
R2049 a_n11685_3060.n131 a_n11685_3060.n45 0.331001
R2050 a_n11685_3060.n132 a_n11685_3060.n51 0.331001
R2051 a_n11685_3060.n58 a_n11685_3060.n118 0.331003
R2052 a_n11685_3060.n66 a_n11685_3060.n121 0.331003
R2053 a_n11685_3060.n74 a_n11685_3060.n124 0.331003
R2054 a_n11685_3060.n81 a_n11685_3060.n127 0.331003
R2055 a_n11685_3060.n112 a_n11685_3060.n14 0.422632
R2056 a_n11685_3060.n12 a_n11685_3060.n11 0.0269113
R2057 a_n11685_3060.n113 a_n11685_3060.n23 0.422632
R2058 a_n11685_3060.n20 a_n11685_3060.n19 0.0269113
R2059 a_n11685_3060.n115 a_n11685_3060.n32 0.422632
R2060 a_n11685_3060.n30 a_n11685_3060.n29 0.0269113
R2061 a_n11685_3060.n116 a_n11685_3060.n41 0.422632
R2062 a_n11685_3060.n38 a_n11685_3060.n37 0.0269113
R2063 a_n11685_3060.n117 a_n11685_3060.n47 0.422632
R2064 a_n11685_3060.n44 a_n11685_3060.n102 0.552312
R2065 a_n11685_3060.n35 a_n11685_3060.n101 0.552312
R2066 a_n11685_3060.n26 a_n11685_3060.n100 0.552312
R2067 a_n11685_3060.n17 a_n11685_3060.n99 0.552312
R2068 a_n11685_3060.n9 a_n11685_3060.n98 0.55231
R2069 a_n11685_3060.n94 a_n11685_3060.n93 0.420782
R2070 a_n11685_3060.n10 a_n11685_3060.n84 0.420782
R2071 a_n11685_3060.n80 a_n11685_3060.n79 0.378931
R2072 a_n11685_3060.t26 a_n11685_3060.n78 2.70757
R2073 a_n11685_3060.n73 a_n11685_3060.n72 0.378931
R2074 a_n11685_3060.t30 a_n11685_3060.n71 2.70757
R2075 a_n11685_3060.n65 a_n11685_3060.n64 0.378931
R2076 a_n11685_3060.t34 a_n11685_3060.n63 2.70757
R2077 a_n11685_3060.n57 a_n11685_3060.n56 0.378931
R2078 a_n11685_3060.t38 a_n11685_3060.n55 2.70757
R2079 a_n11685_3060.n49 a_n11685_3060.n47 0.378931
R2080 a_n11685_3060.n43 a_n11685_3060.n41 0.378931
R2081 a_n11685_3060.n39 a_n11685_3060.t45 2.70757
R2082 a_n11685_3060.n34 a_n11685_3060.n32 0.378931
R2083 a_n11685_3060.n31 a_n11685_3060.t49 2.70757
R2084 a_n11685_3060.n25 a_n11685_3060.n23 0.378931
R2085 a_n11685_3060.n21 a_n11685_3060.t53 2.70757
R2086 a_n11685_3060.n16 a_n11685_3060.n14 0.378931
R2087 a_n11685_3060.n13 a_n11685_3060.t57 2.70757
R2088 a_n11685_3060.n7 a_n11685_3060.n6 0.378931
R2089 a_n11685_3060.t62 a_n11685_3060.n5 2.70757
R2090 a_n11685_3060.t40 a_n11685_3060.n1 2.56549
C20 DN GND 2.30464f
C21 VCP GND 2.4097f
C22 UP GND 0.73099f
C23 VBGR GND 2.15113f
C24 VDD GND 42.2594f
C25 a_n9131_334# GND 1.44503f ; **FLOATING
C26 a_n11917_334# GND 1.51275f ; **FLOATING
C27 a_n11849_145# GND 23.4173f ; **FLOATING
C28 a_n6777_3460# GND 0.32036f ; **FLOATING
C29 a_n9213_3460# GND 3.19862f ; **FLOATING
C30 a_n11649_3460# GND 3.29021f ; **FLOATING
C31 a_n11685_3060.n0 GND 0.44878f ; **FLOATING
C32 a_n11685_3060.n1 GND 0.26061f ; **FLOATING
C33 a_n11685_3060.n2 GND 1.17216f ; **FLOATING
C34 a_n11685_3060.n3 GND 0.5253f ; **FLOATING
C35 a_n11685_3060.n4 GND 0.10261f ; **FLOATING
C36 a_n11685_3060.n5 GND 0.09933f ; **FLOATING
C37 a_n11685_3060.n6 GND 0.10864f ; **FLOATING
C38 a_n11685_3060.n7 GND 0.3877f ; **FLOATING
C39 a_n11685_3060.n8 GND 0.04823f ; **FLOATING
C40 a_n11685_3060.n9 GND 0.05845f ; **FLOATING
C41 a_n11685_3060.n10 GND 1.03389f ; **FLOATING
C42 a_n11685_3060.n11 GND 0.51099f ; **FLOATING
C43 a_n11685_3060.n12 GND 0.10261f ; **FLOATING
C44 a_n11685_3060.n13 GND 0.09933f ; **FLOATING
C45 a_n11685_3060.n14 GND 0.10864f ; **FLOATING
C46 a_n11685_3060.n15 GND 0.01224f ; **FLOATING
C47 a_n11685_3060.n16 GND 0.37339f ; **FLOATING
C48 a_n11685_3060.n17 GND 0.05845f ; **FLOATING
C49 a_n11685_3060.n18 GND 0.04823f ; **FLOATING
C50 a_n11685_3060.n19 GND 0.51099f ; **FLOATING
C51 a_n11685_3060.n20 GND 0.10261f ; **FLOATING
C52 a_n11685_3060.n21 GND 0.09933f ; **FLOATING
C53 a_n11685_3060.n22 GND 2.18261f ; **FLOATING
C54 a_n11685_3060.n23 GND 0.10864f ; **FLOATING
C55 a_n11685_3060.n24 GND 0.01224f ; **FLOATING
C56 a_n11685_3060.n25 GND 0.37339f ; **FLOATING
C57 a_n11685_3060.n26 GND 0.05845f ; **FLOATING
C58 a_n11685_3060.n27 GND 0.04823f ; **FLOATING
C59 a_n11685_3060.n28 GND 0.80592f ; **FLOATING
C60 a_n11685_3060.n29 GND 0.51099f ; **FLOATING
C61 a_n11685_3060.n30 GND 0.10261f ; **FLOATING
C62 a_n11685_3060.n31 GND 0.09933f ; **FLOATING
C63 a_n11685_3060.n32 GND 0.10864f ; **FLOATING
C64 a_n11685_3060.n33 GND 0.01224f ; **FLOATING
C65 a_n11685_3060.n34 GND 0.37339f ; **FLOATING
C66 a_n11685_3060.n35 GND 0.05845f ; **FLOATING
C67 a_n11685_3060.n36 GND 0.04823f ; **FLOATING
C68 a_n11685_3060.n37 GND 0.51099f ; **FLOATING
C69 a_n11685_3060.n38 GND 0.10261f ; **FLOATING
C70 a_n11685_3060.n39 GND 0.09933f ; **FLOATING
C71 a_n11685_3060.n40 GND 1.0913f ; **FLOATING
C72 a_n11685_3060.n41 GND 0.10864f ; **FLOATING
C73 a_n11685_3060.n42 GND 0.01224f ; **FLOATING
C74 a_n11685_3060.n43 GND 0.37339f ; **FLOATING
C75 a_n11685_3060.n44 GND 0.05845f ; **FLOATING
C76 a_n11685_3060.n45 GND 0.04823f ; **FLOATING
C77 a_n11685_3060.n46 GND 1.0913f ; **FLOATING
C78 a_n11685_3060.n47 GND 0.10864f ; **FLOATING
C79 a_n11685_3060.n48 GND 0.01224f ; **FLOATING
C80 a_n11685_3060.n49 GND 0.37339f ; **FLOATING
C81 a_n11685_3060.n50 GND 0.05845f ; **FLOATING
C82 a_n11685_3060.n51 GND 0.04823f ; **FLOATING
C83 a_n11685_3060.n52 GND 1.1042f ; **FLOATING
C84 a_n11685_3060.n53 GND 0.51099f ; **FLOATING
C85 a_n11685_3060.n54 GND 0.10261f ; **FLOATING
C86 a_n11685_3060.n55 GND 0.09933f ; **FLOATING
C87 a_n11685_3060.n56 GND 0.10864f ; **FLOATING
C88 a_n11685_3060.n57 GND 0.37339f ; **FLOATING
C89 a_n11685_3060.n58 GND 0.04823f ; **FLOATING
C90 a_n11685_3060.n59 GND 0.05845f ; **FLOATING
C91 a_n11685_3060.n60 GND 2.18261f ; **FLOATING
C92 a_n11685_3060.n61 GND 0.51099f ; **FLOATING
C93 a_n11685_3060.n62 GND 0.10261f ; **FLOATING
C94 a_n11685_3060.n63 GND 0.09933f ; **FLOATING
C95 a_n11685_3060.n64 GND 0.10864f ; **FLOATING
C96 a_n11685_3060.n65 GND 0.37339f ; **FLOATING
C97 a_n11685_3060.n66 GND 0.04823f ; **FLOATING
C98 a_n11685_3060.n67 GND 0.05845f ; **FLOATING
C99 a_n11685_3060.n68 GND 2.18261f ; **FLOATING
C100 a_n11685_3060.n69 GND 0.51099f ; **FLOATING
C101 a_n11685_3060.n70 GND 0.10261f ; **FLOATING
C102 a_n11685_3060.n71 GND 0.09933f ; **FLOATING
C103 a_n11685_3060.n72 GND 0.10864f ; **FLOATING
C104 a_n11685_3060.n73 GND 0.37339f ; **FLOATING
C105 a_n11685_3060.n74 GND 0.04823f ; **FLOATING
C106 a_n11685_3060.n75 GND 0.05845f ; **FLOATING
C107 a_n11685_3060.n76 GND 0.5253f ; **FLOATING
C108 a_n11685_3060.n77 GND 0.10261f ; **FLOATING
C109 a_n11685_3060.n78 GND 0.09933f ; **FLOATING
C110 a_n11685_3060.n79 GND 0.10864f ; **FLOATING
C111 a_n11685_3060.n80 GND 0.3877f ; **FLOATING
C112 a_n11685_3060.n81 GND 0.04823f ; **FLOATING
C113 a_n11685_3060.n82 GND 0.05845f ; **FLOATING
C114 a_n11685_3060.n83 GND 0.87434f ; **FLOATING
C115 a_n11685_3060.n84 GND 0.638f ; **FLOATING
C116 a_n11685_3060.n85 GND 2.18261f ; **FLOATING
C117 a_n11685_3060.n86 GND 1.12808f ; **FLOATING
C118 a_n11685_3060.n87 GND 1.50679f ; **FLOATING
C119 a_n11685_3060.n88 GND 0.88508f ; **FLOATING
C120 a_n11685_3060.n89 GND 1.12808f ; **FLOATING
C121 a_n11685_3060.n90 GND 1.12808f ; **FLOATING
C122 a_n11685_3060.n91 GND 0.39734f ; **FLOATING
C123 a_n11685_3060.n92 GND 0.80592f ; **FLOATING
C124 a_n11685_3060.n93 GND 0.63655f ; **FLOATING
C125 a_n11685_3060.n94 GND 1.03435f ; **FLOATING
C126 a_n11685_3060.n95 GND 0.88508f ; **FLOATING
C127 a_n11685_3060.n96 GND 1.12808f ; **FLOATING
C128 a_n11685_3060.n97 GND 0.39635f ; **FLOATING
C129 a_n11685_3060.n98 GND 0.03565f ; **FLOATING
C130 a_n11685_3060.n99 GND 0.03565f ; **FLOATING
C131 a_n11685_3060.n100 GND 0.03565f ; **FLOATING
C132 a_n11685_3060.n101 GND 0.03565f ; **FLOATING
C133 a_n11685_3060.n102 GND 0.03565f ; **FLOATING
C134 a_n11685_3060.n103 GND 0.03565f ; **FLOATING
C135 a_n11685_3060.n104 GND 0.03565f ; **FLOATING
C136 a_n11685_3060.n105 GND 0.03565f ; **FLOATING
C137 a_n11685_3060.n106 GND 0.03565f ; **FLOATING
C138 a_n11685_3060.n107 GND 0.03565f ; **FLOATING
C139 a_n11685_3060.t0 GND 2.22801f ; **FLOATING
C140 a_n11685_3060.n108 GND 0.02549f ; **FLOATING
C141 a_n11685_3060.n109 GND 0.01224f ; **FLOATING
C142 a_n11685_3060.n110 GND 0.06073f ; **FLOATING
C143 a_n11685_3060.n111 GND 0.02549f ; **FLOATING
C144 a_n11685_3060.n112 GND 0.06073f ; **FLOATING
C145 a_n11685_3060.n113 GND 0.06073f ; **FLOATING
C146 a_n11685_3060.n114 GND 0.02549f ; **FLOATING
C147 a_n11685_3060.n115 GND 0.06073f ; **FLOATING
C148 a_n11685_3060.n116 GND 0.06073f ; **FLOATING
C149 a_n11685_3060.n117 GND 0.06073f ; **FLOATING
C150 a_n11685_3060.t13 GND 2.22801f ; **FLOATING
C151 a_n11685_3060.n118 GND 0.02549f ; **FLOATING
C152 a_n11685_3060.n119 GND 0.01224f ; **FLOATING
C153 a_n11685_3060.n120 GND 0.06073f ; **FLOATING
C154 a_n11685_3060.t15 GND 2.22801f ; **FLOATING
C155 a_n11685_3060.n121 GND 0.02549f ; **FLOATING
C156 a_n11685_3060.n122 GND 0.01224f ; **FLOATING
C157 a_n11685_3060.n123 GND 0.06073f ; **FLOATING
C158 a_n11685_3060.t17 GND 2.22801f ; **FLOATING
C159 a_n11685_3060.n124 GND 0.02549f ; **FLOATING
C160 a_n11685_3060.n125 GND 0.01224f ; **FLOATING
C161 a_n11685_3060.n126 GND 0.06073f ; **FLOATING
C162 a_n11685_3060.t19 GND 2.22801f ; **FLOATING
C163 a_n11685_3060.n127 GND 0.02549f ; **FLOATING
C164 a_n11685_3060.n128 GND 0.01224f ; **FLOATING
C165 a_n11685_3060.n129 GND 0.06073f ; **FLOATING
C166 a_n11685_3060.n130 GND 0.02549f ; **FLOATING
C167 a_n11685_3060.n131 GND 0.02549f ; **FLOATING
C168 a_n11685_3060.n132 GND 0.02549f ; **FLOATING
C169 a_n11685_3060.n133 GND 1.07841f ; **FLOATING
C170 a_n11685_3060.n134 GND 1.1042f ; **FLOATING
C171 a_n11685_3060.n135 GND 0.59623f ; **FLOATING
C172 a_n11685_3060.t1 GND 6.52029f ; **FLOATING
C173 a_n11685_3060.t23 GND 2.22627f ; **FLOATING
C174 a_n11685_3060.t25 GND 2.2249f ; **FLOATING
C175 a_n11685_3060.t26 GND 2.42072f ; **FLOATING
C176 a_n11685_3060.t20 GND 2.22747f ; **FLOATING
C177 a_n11685_3060.t24 GND 2.41909f ; **FLOATING
C178 a_n11685_3060.t27 GND 2.22627f ; **FLOATING
C179 a_n11685_3060.t31 GND 2.22627f ; **FLOATING
C180 a_n11685_3060.t33 GND 2.2249f ; **FLOATING
C181 a_n11685_3060.t34 GND 2.42072f ; **FLOATING
C182 a_n11685_3060.t16 GND 2.22747f ; **FLOATING
C183 a_n11685_3060.t32 GND 2.41909f ; **FLOATING
C184 a_n11685_3060.t35 GND 2.22627f ; **FLOATING
C185 a_n11685_3060.n136 GND 0.67105f ; **FLOATING
C186 a_n11685_3060.t39 GND 2.22674f ; **FLOATING
C187 a_n11685_3060.t41 GND 2.22688f ; **FLOATING
C188 a_n11685_3060.t42 GND 2.41802f ; **FLOATING
C189 a_n11685_3060.t11 GND 2.2249f ; **FLOATING
C190 a_n11685_3060.t12 GND 2.22627f ; **FLOATING
C191 a_n11685_3060.t40 GND 2.42718f ; **FLOATING
C192 a_n11685_3060.n137 GND 0.60913f ; **FLOATING
C193 a_n11685_3060.t47 GND 2.22686f ; **FLOATING
C194 a_n11685_3060.t7 GND 2.2249f ; **FLOATING
C195 a_n11685_3060.t50 GND 2.41886f ; **FLOATING
C196 a_n11685_3060.t49 GND 2.22987f ; **FLOATING
C197 a_n11685_3060.t48 GND 2.41969f ; **FLOATING
C198 a_n11685_3060.t8 GND 2.22627f ; **FLOATING
C199 a_n11685_3060.t51 GND 2.22686f ; **FLOATING
C200 a_n11685_3060.t22 GND 1.12398f ; **FLOATING
C201 a_n11685_3060.n138 GND 2.17956f ; **FLOATING
C202 a_n11685_3060.t59 GND 2.22627f ; **FLOATING
C203 a_n11685_3060.t61 GND 2.2249f ; **FLOATING
C204 a_n11685_3060.t62 GND 2.42072f ; **FLOATING
C205 a_n11685_3060.t2 GND 2.22747f ; **FLOATING
C206 a_n11685_3060.t60 GND 2.41909f ; **FLOATING
C207 a_n11685_3060.t55 GND 2.22686f ; **FLOATING
C208 a_n11685_3060.t3 GND 2.2249f ; **FLOATING
C209 a_n11685_3060.t58 GND 2.41886f ; **FLOATING
C210 a_n11685_3060.t57 GND 2.22987f ; **FLOATING
C211 a_n11685_3060.t56 GND 2.41969f ; **FLOATING
C212 a_n11685_3060.t4 GND 2.22627f ; **FLOATING
C213 a_n11685_3060.t53 GND 2.22987f ; **FLOATING
C214 a_n11685_3060.t54 GND 2.41886f ; **FLOATING
C215 a_n11685_3060.t5 GND 2.2249f ; **FLOATING
C216 a_n11685_3060.t6 GND 2.22627f ; **FLOATING
C217 a_n11685_3060.t52 GND 2.41969f ; **FLOATING
C218 a_n11685_3060.n139 GND 0.67105f ; **FLOATING
C219 a_n11685_3060.n140 GND 1.07841f ; **FLOATING
C220 a_n11685_3060.n141 GND 0.59623f ; **FLOATING
C221 a_n11685_3060.t43 GND 2.22686f ; **FLOATING
C222 a_n11685_3060.t45 GND 2.22987f ; **FLOATING
C223 a_n11685_3060.t46 GND 2.41886f ; **FLOATING
C224 a_n11685_3060.t9 GND 2.2249f ; **FLOATING
C225 a_n11685_3060.t10 GND 2.22627f ; **FLOATING
C226 a_n11685_3060.t44 GND 2.41969f ; **FLOATING
C227 a_n11685_3060.n142 GND 0.60913f ; **FLOATING
C228 a_n11685_3060.n143 GND 0.60913f ; **FLOATING
C229 a_n11685_3060.n144 GND 1.0913f ; **FLOATING
C230 a_n11685_3060.n145 GND 0.67105f ; **FLOATING
C231 a_n11685_3060.n146 GND 0.67105f ; **FLOATING
C232 a_n11685_3060.n147 GND 0.67105f ; **FLOATING
C233 a_n11685_3060.t37 GND 2.2249f ; **FLOATING
C234 a_n11685_3060.t38 GND 2.42072f ; **FLOATING
C235 a_n11685_3060.t14 GND 2.22747f ; **FLOATING
C236 a_n11685_3060.t36 GND 2.41909f ; **FLOATING
C237 a_n11685_3060.t29 GND 2.2249f ; **FLOATING
C238 a_n11685_3060.t30 GND 2.42072f ; **FLOATING
C239 a_n11685_3060.t18 GND 2.22747f ; **FLOATING
C240 a_n11685_3060.t28 GND 2.41909f ; **FLOATING
C241 a_n11685_3060.n148 GND 0.87434f ; **FLOATING
C242 a_n11685_3060.n149 GND 1.17216f ; **FLOATING
C243 a_n11685_3060.n150 GND 0.48479f ; **FLOATING
C244 a_n11685_3060.t21 GND 0.35857f ; **FLOATING
C245 VDD.n0 GND 1.68427f ; **FLOATING
C246 VDD.n1 GND 0.09789f ; **FLOATING
C247 VDD.n2 GND 0.6826f ; **FLOATING
C248 VDD.n3 GND 0.69007f ; **FLOATING
C249 VDD.n4 GND 0.99318f ; **FLOATING
C250 VDD.n7 GND 0.01194f ; **FLOATING
C251 VDD.n9 GND 0.01164f ; **FLOATING
C252 VDD.n10 GND 0.01123f ; **FLOATING
C253 VDD.n12 GND 0.01194f ; **FLOATING
C254 VDD.n15 GND 0.01194f ; **FLOATING
C255 VDD.t0 GND 0.1538p ; **FLOATING
C256 VDD.n17 GND 0.01194f ; **FLOATING
C257 VDD.n19 GND 0.01139f ; **FLOATING
C258 VDD.n20 GND 0.08008f ; **FLOATING
C259 VDD.n21 GND 1.87019f ; **FLOATING
C260 VDD.n22 GND 0.07933f ; **FLOATING
C261 VDD.n23 GND 0.81402f ; **FLOATING
C262 VDD.n24 GND 0.18594f ; **FLOATING
C263 VDD.n25 GND 0.10963f ; **FLOATING
C264 VDD.n29 GND 0.02683f ; **FLOATING
C265 VDD.n31 GND 0.01016f ; **FLOATING
C266 VDD.n32 GND 0.01037f ; **FLOATING
C267 VDD.n33 GND 0.01047f ; **FLOATING
C268 VDD.n34 GND 0.01047f ; **FLOATING
C269 VDD.n35 GND 0.01016f ; **FLOATING
C270 VDD.n36 GND 0.01049f ; **FLOATING
C271 VDD.n37 GND 0.04179f ; **FLOATING
C272 VDD.n38 GND 0.01037f ; **FLOATING
C273 VDD.n39 GND 0.01016f ; **FLOATING
C274 VDD.n40 GND 0.01047f ; **FLOATING
C275 VDD.n42 GND 0.03517f ; **FLOATING
C276 VDD.n43 GND 0.04126f ; **FLOATING
C277 VDD.n45 GND 0.01037f ; **FLOATING
C278 VDD.n46 GND 0.01016f ; **FLOATING
C279 VDD.n47 GND 0.01047f ; **FLOATING
C280 VDD.n49 GND 0.03525f ; **FLOATING
C281 VDD.n50 GND 0.04126f ; **FLOATING
C282 VDD.n55 GND 0.01016f ; **FLOATING
C283 VDD.n56 GND 0.01047f ; **FLOATING
C284 VDD.n57 GND 0.01016f ; **FLOATING
C285 VDD.n58 GND 0.01047f ; **FLOATING
C286 VDD.n60 GND 0.01016f ; **FLOATING
C287 VDD.n61 GND 0.01047f ; **FLOATING
C288 VDD.n62 GND 0.01016f ; **FLOATING
C289 VDD.n63 GND 0.01049f ; **FLOATING
C290 VDD.n64 GND 0.01042f ; **FLOATING
C291 VDD.n65 GND 0.01016f ; **FLOATING
C292 VDD.n66 GND 0.01047f ; **FLOATING
C293 VDD.n68 GND 0.01204f ; **FLOATING
C294 VDD.n69 GND 0.01047f ; **FLOATING
C295 VDD.n72 GND 0.01016f ; **FLOATING
C296 VDD.n73 GND 0.01042f ; **FLOATING
C297 VDD.n74 GND 0.01047f ; **FLOATING
C298 VDD.n75 GND 0.01049f ; **FLOATING
C299 VDD.n76 GND 0.01016f ; **FLOATING
C300 VDD.n77 GND 0.01047f ; **FLOATING
C301 VDD.n79 GND 0.01016f ; **FLOATING
C302 VDD.n80 GND 0.01042f ; **FLOATING
C303 VDD.n81 GND 0.01016f ; **FLOATING
C304 VDD.n82 GND 0.01047f ; **FLOATING
C305 VDD.n84 GND 0.0104f ; **FLOATING
C306 VDD.n85 GND 0.01016f ; **FLOATING
C307 VDD.n86 GND 0.01047f ; **FLOATING
C308 VDD.n88 GND 0.01047f ; **FLOATING
C309 VDD.n89 GND 0.01016f ; **FLOATING
C310 VDD.n90 GND 0.01042f ; **FLOATING
C311 VDD.n91 GND 0.01047f ; **FLOATING
C312 VDD.n93 GND 0.01016f ; **FLOATING
C313 VDD.n94 GND 0.01047f ; **FLOATING
C314 VDD.n95 GND 0.01016f ; **FLOATING
C315 VDD.n96 GND 0.01049f ; **FLOATING
C316 VDD.n97 GND 0.01042f ; **FLOATING
C317 VDD.n98 GND 0.01016f ; **FLOATING
C318 VDD.n99 GND 0.01047f ; **FLOATING
C319 VDD.n101 GND 0.0104f ; **FLOATING
C320 VDD.n102 GND 0.01016f ; **FLOATING
C321 VDD.n103 GND 0.01047f ; **FLOATING
C322 VDD.n105 GND 0.12653f ; **FLOATING
C323 VDD.n106 GND 0.11907f ; **FLOATING
C324 VDD.n111 GND 0.04236f ; **FLOATING
C325 VDD.n112 GND 0.11062f ; **FLOATING
C326 VDD.n113 GND 0.04236f ; **FLOATING
C327 VDD.n114 GND 0.04236f ; **FLOATING
C328 VDD.n115 GND 0.05391f ; **FLOATING
C329 VDD.n116 GND 0.02955f ; **FLOATING
C330 VDD.n123 GND 0.01125f ; **FLOATING
C331 VDD.n137 GND 0.01151f ; **FLOATING
C332 VDD.n142 GND 0.01151f ; **FLOATING
C333 VDD.n207 GND 0.01016f ; **FLOATING
C334 VDD.t8 GND 0.17152f ; **FLOATING
C335 VDD.t10 GND 0.21924f ; **FLOATING
C336 VDD.n208 GND 0.13655f ; **FLOATING
C337 VDD.n209 GND 0.01016f ; **FLOATING
C338 VDD.n210 GND 0.01016f ; **FLOATING
C339 VDD.n211 GND 0.01016f ; **FLOATING
C340 VDD.n212 GND 0.01044f ; **FLOATING
C341 VDD.n213 GND 0.01047f ; **FLOATING
C342 VDD.n215 GND 0.01016f ; **FLOATING
C343 VDD.n216 GND 0.01016f ; **FLOATING
C344 VDD.n217 GND 0.01047f ; **FLOATING
C345 VDD.n218 GND 0.01047f ; **FLOATING
C346 VDD.n220 GND 0.01016f ; **FLOATING
C347 VDD.t7 GND 0.12422f ; **FLOATING
C348 VDD.n222 GND 0.03631f ; **FLOATING
C349 VDD.n223 GND 0.02649f ; **FLOATING
C350 VDD.n239 GND 0.01016f ; **FLOATING
C351 VDD.t2 GND 0.17152f ; **FLOATING
C352 VDD.t4 GND 0.21926f ; **FLOATING
C353 VDD.n240 GND 0.13652f ; **FLOATING
C354 VDD.n241 GND 0.01016f ; **FLOATING
C355 VDD.n242 GND 0.01016f ; **FLOATING
C356 VDD.n243 GND 0.01016f ; **FLOATING
C357 VDD.n244 GND 0.01016f ; **FLOATING
C358 VDD.n245 GND 0.01044f ; **FLOATING
C359 VDD.n246 GND 0.01047f ; **FLOATING
C360 VDD.n247 GND 0.01155f ; **FLOATING
C361 VDD.n248 GND 0.01145f ; **FLOATING
C362 VDD.n249 GND 0.01047f ; **FLOATING
C363 VDD.n251 GND 0.01016f ; **FLOATING
C364 VDD.n252 GND 0.01016f ; **FLOATING
C365 VDD.n253 GND 0.01047f ; **FLOATING
C366 VDD.n254 GND 0.01047f ; **FLOATING
C367 VDD.t14 GND 0.12422f ; **FLOATING
C368 VDD.n256 GND 0.03631f ; **FLOATING
C369 VDD.n257 GND 0.02643f ; **FLOATING
C370 VDD.n274 GND 0.44767f ; **FLOATING
C371 VDD.n275 GND 0.01016f ; **FLOATING
C372 VDD.t1 GND 0.17152f ; **FLOATING
C373 VDD.t3 GND 0.21926f ; **FLOATING
C374 VDD.n276 GND 0.13652f ; **FLOATING
C375 VDD.n277 GND 0.01016f ; **FLOATING
C376 VDD.n278 GND 0.01016f ; **FLOATING
C377 VDD.n279 GND 0.01016f ; **FLOATING
C378 VDD.n280 GND 0.01016f ; **FLOATING
C379 VDD.n281 GND 0.01016f ; **FLOATING
C380 VDD.n282 GND 0.01044f ; **FLOATING
C381 VDD.n283 GND 0.01047f ; **FLOATING
C382 VDD.n285 GND 0.01016f ; **FLOATING
C383 VDD.n286 GND 0.01016f ; **FLOATING
C384 VDD.n287 GND 0.01047f ; **FLOATING
C385 VDD.n288 GND 0.01047f ; **FLOATING
C386 VDD.n290 GND 0.01016f ; **FLOATING
C387 VDD.t13 GND 0.12422f ; **FLOATING
C388 VDD.n292 GND 0.03837f ; **FLOATING
C389 VDD.n309 GND 0.06781f ; **FLOATING
C390 VDD.n310 GND 0.0204f ; **FLOATING
C391 VDD.n311 GND 0.02228f ; **FLOATING
C392 VDD.n312 GND 0.02228f ; **FLOATING
C393 VDD.n313 GND 0.02228f ; **FLOATING
C394 VDD.n314 GND 0.02228f ; **FLOATING
C395 VDD.n315 GND 0.02228f ; **FLOATING
C396 VDD.n316 GND 0.02228f ; **FLOATING
C397 VDD.n317 GND 0.02228f ; **FLOATING
C398 VDD.n318 GND 0.02302f ; **FLOATING
C399 VDD.n319 GND 0.01138f ; **FLOATING
C400 VDD.n457 GND 0.01138f ; **FLOATING
C401 VDD.n458 GND 0.37259f ; **FLOATING
C402 VDD.n459 GND 0.69007f ; **FLOATING
C403 VDD.n460 GND 0.07632f ; **FLOATING
C404 VDD.t16 GND 1.91676f ; **FLOATING
C405 VDD.n461 GND 0.03398f ; **FLOATING
C406 VDD.n462 GND 0.03406f ; **FLOATING
C407 VDD.n463 GND 0.04236f ; **FLOATING
C408 VDD.n464 GND 0.04153f ; **FLOATING
C409 VDD.n465 GND 0.03421f ; **FLOATING
C410 VDD.n466 GND 0.04236f ; **FLOATING
C411 VDD.n467 GND 0.04236f ; **FLOATING
.ends
