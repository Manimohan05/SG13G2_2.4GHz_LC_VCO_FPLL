* Extracted by KLayout with SG13G2 LVS runset on : 25/09/2026 16:50

.SUBCKT CHARGE_PUMP DN GND SUB! UP VBGR VCP VDD
R$1 GND SUB! ptap1 A=47.808p P=318.72u
M$2 GND VBGR \$107 SUB! sg13_lv_nmos L=2u W=3.9u AS=1.326p AD=1.326p PS=8.48u
+ PD=8.48u rfmode=0
M$3 VDD GND \$132 \$I361 sg13_lv_pmos L=2u W=29.6u AS=6.512p AD=6.512p
+ PS=37.72u PD=37.72u rfmode=0
R$8 VDD \$I361 ntap1 A=79.08p P=527.2u
M$9 VDD UP \$134 \$I361 sg13_lv_pmos L=2u W=29.6u AS=6.512p AD=6.512p PS=37.72u
+ PD=37.72u rfmode=0
M$14 VDD GND \$130 \$I361 sg13_lv_pmos L=2u W=29.6u AS=6.512p AD=6.512p
+ PS=37.72u PD=37.72u rfmode=0
M$22 \$43 \$107 \$132 \$I361 sg13_lv_pmos L=2u W=163.6u AS=32.311p AD=32.311p
+ PS=179.68u PD=179.68u rfmode=0
M$42 \$44 VDD GND SUB! sg13_lv_nmos L=2u W=6u AS=2.04p AD=2.04p PS=12.68u
+ PD=12.68u rfmode=0
M$43 \$47 DN GND SUB! sg13_lv_nmos L=2u W=6u AS=2.04p AD=2.04p PS=12.68u
+ PD=12.68u rfmode=0
M$44 \$47 \$43 VCP SUB! sg13_lv_nmos L=2u W=40.7u AS=8.954p AD=8.954p PS=51.04u
+ PD=51.04u rfmode=0
M$49 \$44 \$43 \$43 SUB! sg13_lv_nmos L=2u W=40.7u AS=8.954p AD=8.954p
+ PS=51.04u PD=51.04u rfmode=0
M$54 VCP \$107 \$134 \$I361 sg13_lv_pmos L=2u W=163.6u AS=32.311p AD=32.311p
+ PS=179.68u PD=179.68u rfmode=0
M$74 \$107 \$107 \$130 \$I361 sg13_lv_pmos L=2u W=163.6u AS=32.311p AD=32.311p
+ PS=179.68u PD=179.68u rfmode=0
.ENDS CHARGE_PUMP
