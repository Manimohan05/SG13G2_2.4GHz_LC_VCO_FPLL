* Extracted by KLayout with SG13G2 LVS runset on : 25/09/2026 16:55

.SUBCKT LC_VCO FOUT GND VBGR VCTRL VDD
C$1 \$2 \$3 \$1 rfcmim w=21.9u l=21.9u A=479.61p P=87.6u m=1 wfeed=10u
C$2 \$3 VCTRL \$2 \$1 sg13_hv_svaricap w=9.74u l=0.8u Nx=7
C$3 \$3 VCTRL \$2 \$1 sg13_hv_svaricap w=9.74u l=0.8u Nx=7
R$4 GND \$1 ptap1 A=109.47p P=729.8u
M$5 \$I2 \$I2 GND \$1 sg13_lv_nmos L=1u W=64u AS=13.36p AD=13.36p PS=75.34u
+ PD=75.34u rfmode=0
M$13 \$I1 \$3 \$2 \$1 sg13_lv_nmos L=0.13u W=21.99u AS=5.2776p AD=5.2776p
+ PS=30.76u PD=30.76u rfmode=0
M$16 \$3 \$2 \$I1 \$1 sg13_lv_nmos L=0.13u W=21.99u AS=5.2776p AD=5.2776p
+ PS=30.76u PD=30.76u rfmode=0
M$19 \$I4 \$2 VDD \$I3 sg13_lv_pmos L=0.13u W=15u AS=3.075p AD=3.075p PS=20.6u
+ PD=20.6u rfmode=0
M$29 FOUT \$3 VDD \$I3 sg13_lv_pmos L=0.13u W=15u AS=3.075p AD=3.075p PS=20.6u
+ PD=20.6u rfmode=0
R$39 VDD \$I5 ntap1 A=12.144p P=80.96u
M$40 VDD VBGR \$I2 \$I5 sg13_lv_pmos L=1u W=38u AS=8.36p AD=8.36p PS=47.8u
+ PD=47.8u rfmode=0
R$45 VDD \$I3 ntap1 A=33.396p P=222.64u
M$51 GND \$3 FOUT \$1 sg13_lv_nmos L=0.13u W=1.5u AS=0.51p AD=0.51p PS=3.68u
+ PD=3.68u rfmode=0
M$52 GND \$2 \$I4 \$1 sg13_lv_nmos L=0.13u W=1.5u AS=0.51p AD=0.51p PS=3.68u
+ PD=3.68u rfmode=0
M$57 \$2 \$3 VDD \$I3 sg13_lv_pmos L=0.13u W=36u AS=7.92p AD=7.92p PS=45.4u
+ PD=45.4u rfmode=0
M$62 VDD \$2 \$3 \$I3 sg13_lv_pmos L=0.13u W=36u AS=7.92p AD=7.92p PS=45.4u
+ PD=45.4u rfmode=0
M$67 \$I1 \$I2 GND \$1 sg13_lv_nmos L=1u W=384u AS=74.4p AD=74.4p PS=409.1u
+ PD=409.1u rfmode=0
.ENDS LC_VCO
