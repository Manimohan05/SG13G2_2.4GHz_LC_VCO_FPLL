* Extracted by KLayout with SG13G2 LVS runset on : 25/09/2026 16:53

.SUBCKT DSM_N_FREQ_DIV GND VDD en freq_in freq_out rst sclk sdata
X$1 GND VDD \$156 \$161 \$149 sg13g2_nor2b_1
X$2 GND VDD \$154 \$143 \$144 sg13g2_nor2b_1
X$3 GND \$146 VDD \$145 \$137 \$143 \$129 \$144 sg13g2_a221oi_1
X$4 GND VDD \$141 \$129 \$125 sg13g2_nor2b_1
X$5 GND \$110 VDD \$133 \$108 \$105 sg13g2_o21ai_1
X$6 GND \$136 VDD \$113 \$133 \$120 sg13g2_o21ai_1
X$7 GND VDD \$65 \$64 \$63 \$71 sg13g2_nand3_1
X$8 GND VDD \$78 \$77 \$65 sg13g2_nor2b_1
X$9 GND VDD \$144 \$140 \$151 \$150 sg13g2_nand3_1
X$10 GND VDD \$125 \$122 \$121 \$119 sg13g2_nand3_1
X$11 VDD GND \$119 \$106 \$120 sg13g2_nand2_1
X$12 VDD GND \$150 \$134 \$120 sg13g2_nand2_1
X$13 VDD GND \$56 \$50 \$48 sg13g2_nand2_1
X$14 VDD GND \$71 \$53 \$6 sg13g2_nand2_1
X$15 VDD GND \$133 \$104 \$105 sg13g2_nand2_1
X$16 VDD GND \$94 \$78 \$93 sg13g2_nand2_1
X$17 VDD GND \$69 \$68 \$6 sg13g2_nand2_1
X$18 VDD GND \$85 \$75 \$70 sg13g2_nand2_1
X$19 VDD GND \$140 \$132 \$135 sg13g2_nand2_1
X$20 VDD GND \$122 \$107 \$116 sg13g2_nand2_1
X$21 GND \$47 sclk VDD sg13g2_buf_16
X$22 GND \$118 \$47 VDD sg13g2_buf_16
X$23 GND \$37 VDD \$62 sg13g2_buf_1
X$24 GND \$120 VDD \$161 sg13g2_buf_1
X$25 GND \$173 VDD \$127 sg13g2_buf_1
X$26 GND \$111 VDD \$32 sg13g2_buf_1
X$27 GND \$32 VDD \$127 sg13g2_buf_1
X$28 GND \$127 VDD rst sg13g2_buf_1
X$29 GND \$6 VDD \$120 sg13g2_buf_1
X$30 GND \$27 VDD en sg13g2_buf_1
X$31 GND \$23 VDD \$127 sg13g2_buf_1
X$32 GND \$40 VDD sdata sg13g2_buf_1
X$33 VDD GND \$147 \$148 \$136 sg13g2_and2_1
X$34 VDD GND \$146 \$141 \$154 sg13g2_and2_1
X$35 VDD GND \$44 \$38 \$120 sg13g2_and2_1
X$36 VDD GND \$66 \$45 \$51 sg13g2_and2_1
X$37 \$143 GND \$140 VDD \$150 \$151 sg13g2_a21oi_1
X$38 \$76 GND \$85 VDD \$69 \$87 sg13g2_a21oi_1
X$39 \$57 GND \$45 VDD \$72 \$60 sg13g2_a21oi_1
X$40 \$169 GND \$163 VDD \$162 \$156 sg13g2_a21oi_1
X$41 \$114 GND \$108 VDD \$105 \$110 sg13g2_a21oi_1
X$42 \$142 GND \$141 VDD \$137 \$129 sg13g2_a21oi_1
X$43 \$112 GND \$105 VDD \$104 \$108 sg13g2_a21oi_1
X$44 VDD GND \$99 \$113 \$109 \$108 sg13g2_nor3_1
X$45 \$129 GND \$122 VDD \$119 \$121 sg13g2_a21oi_1
X$46 \$90 GND \$88 VDD \$77 \$76 sg13g2_a21oi_1
X$47 \$96 GND \$108 VDD \$105 \$104 sg13g2_a21oi_1
X$48 \$91 GND \$78 VDD \$79 \$77 sg13g2_a21oi_1
X$49 \$50 GND \$24 VDD \$39 \$44 sg13g2_a21oi_1
X$50 \$77 GND \$64 VDD \$71 \$63 sg13g2_a21oi_1
X$51 \$100 GND \$105 VDD \$104 \$96 sg13g2_a21oi_1
X$52 GND VDD \$56 \$60 \$49 \$59 sg13g2_a21o_2
X$53 VDD GND \$105 \$104 \$99 sg13g2_nor2_1
X$54 VDD GND \$76 \$92 \$93 sg13g2_nor2_1
X$55 VDD GND \$16 \$7 \$8 sg13g2_nor2_1
X$56 VDD GND \$48 \$50 \$49 sg13g2_nor2_1
X$57 VDD GND \$33 \$19 \$60 sg13g2_nor2_1
X$58 GND \$135 VDD \$120 \$134 sg13g2_xor2_1
X$59 GND \$17 VDD \$6 \$5 sg13g2_xor2_1
X$60 GND \$45 VDD \$33 \$19 sg13g2_xor2_1
X$61 GND \$15 VDD \$16 \$7 sg13g2_xor2_1
X$62 GND \$70 VDD \$6 \$68 sg13g2_xor2_1
X$63 GND \$51 VDD \$48 \$50 sg13g2_xor2_1
X$64 GND \$138 VDD \$141 \$137 sg13g2_xor2_1
X$65 GND \$25 VDD \$45 \$72 sg13g2_xor2_1
X$66 GND \$54 VDD \$6 \$53 sg13g2_xor2_1
X$67 GND \$174 VDD \$169 \$176 sg13g2_xor2_1
X$68 GND \$116 VDD \$120 \$106 sg13g2_xor2_1
X$69 GND \$24 VDD \$120 \$38 sg13g2_xor2_1
X$70 VDD GND \$87 \$116 \$107 sg13g2_xnor2_1
X$71 VDD GND \$121 \$135 \$132 sg13g2_xnor2_1
X$72 VDD GND \$63 \$70 \$75 sg13g2_xnor2_1
X$73 VDD GND \$163 \$161 \$149 sg13g2_xnor2_1
X$74 VDD GND \$31 \$15 \$43 sg13g2_xnor2_1
X$75 VDD GND \$157 \$142 \$154 sg13g2_xnor2_1
X$76 VDD GND \$16 \$17 \$18 sg13g2_xnor2_1
X$77 VDD GND \$33 \$24 \$39 sg13g2_xnor2_1
X$78 VDD GND \$175 \$174 \$145 sg13g2_xnor2_1
X$79 VDD GND \$81 \$78 \$80 sg13g2_xnor2_1
X$80 VDD GND \$151 \$163 \$162 sg13g2_xnor2_1
X$81 VDD GND \$95 \$91 \$93 sg13g2_xnor2_1
X$82 VDD GND \$48 \$54 \$55 sg13g2_xnor2_1
X$83 VDD GND \$61 \$57 \$51 sg13g2_xnor2_1
X$84 GND \$166 \$148 \$172 \$158 VDD sg13g2_dfrbpq_1
X$85 GND \$36 \$39 \$25 \$37 VDD sg13g2_dfrbpq_1
X$86 GND \$101 \$104 \$100 \$109 VDD sg13g2_dfrbpq_1
X$87 GND \$130 \$134 \$131 \$118 VDD sg13g2_dfrbpq_1
X$88 GND \$42 \$38 \$41 \$11 VDD sg13g2_dfrbpq_1
X$89 GND \$73 \$55 \$61 \$37 VDD sg13g2_dfrbpq_1
X$90 GND \$155 \$159 \$147 \$158 VDD sg13g2_dfrbpq_1
X$91 GND \$164 \$162 \$157 \$62 VDD sg13g2_dfrbpq_1
X$92 GND \$67 \$53 \$58 \$11 VDD sg13g2_dfrbpq_1
X$93 GND \$160 \$176 \$168 \$118 VDD sg13g2_dfrbpq_1
X$94 GND \$178 \$165 \$180 freq_in VDD sg13g2_dfrbpq_1
X$95 GND \$167 \$149 \$153 \$118 VDD sg13g2_dfrbpq_1
X$96 GND \$152 \$109 \$148 \$158 VDD sg13g2_dfrbpq_1
X$97 GND \$34 \$18 \$31 \$37 VDD sg13g2_dfrbpq_1
X$98 \$19 GND \$17 VDD \$18 \$20 sg13g2_a21oi_1
X$99 VDD GND \$20 \$5 \$6 sg13g2_and2_1
X$100 GND \$82 \$75 \$81 \$37 VDD sg13g2_dfrbpq_1
X$101 VDD GND \$80 \$66 \$59 \$72 sg13g2_a21oi_2
X$102 VDD GND \$79 \$59 \$72 \$66 sg13g2_a21o_1
X$103 GND \$86 \$62 \$83 \$104 VDD sg13g2_dfrbpq_1
X$104 GND \$139 \$132 \$138 \$62 VDD sg13g2_dfrbpq_1
X$105 GND \$117 \$106 \$103 \$118 VDD sg13g2_dfrbpq_1
X$106 GND \$124 \$108 \$112 \$109 VDD sg13g2_dfrbpq_1
X$107 GND \$30 \$14 \$12 \$37 VDD sg13g2_dfrbpq_1
X$108 VDD GND \$14 \$6 \$7 sg13g2_nor2_1
X$109 GND VDD \$15 \$4 \$8 \$72 sg13g2_a21o_2
X$110 GND \$177 \$161 \$175 \$62 VDD sg13g2_dfrbpq_1
X$111 GND \$123 \$107 \$95 \$37 VDD sg13g2_dfrbpq_1
X$112 GND \$115 \$105 \$114 \$109 VDD sg13g2_dfrbpq_1
X$113 GND \$74 \$68 \$84 \$11 VDD sg13g2_dfrbpq_1
X$114 GND \$171 \$158 \$170 \$165 VDD sg13g2_dfrbpq_1
X$115 GND \$26 \$22 \$29 \$11 VDD sg13g2_dfrbpq_1
X$116 GND \$131 \$27 \$106 \$134 VDD sg13g2_mux2_1
X$117 GND \$153 \$27 \$134 \$149 VDD sg13g2_mux2_1
X$118 GND \$58 \$27 \$38 \$53 VDD sg13g2_mux2_1
X$119 GND \$29 \$27 \$40 \$22 VDD sg13g2_mux2_1
X$120 GND \$168 \$27 \$149 \$176 VDD sg13g2_mux2_1
X$121 GND \$84 \$27 \$53 \$68 VDD sg13g2_mux2_1
X$122 GND \$103 \$27 \$68 \$106 VDD sg13g2_mux2_1
X$123 GND \$41 \$27 \$5 \$38 VDD sg13g2_mux2_1
X$129 GND \$137 VDD \$90 \$94 \$80 sg13g2_o21ai_1
X$165 VDD GND \$111 \$178 sg13g2_inv_1
X$166 VDD GND \$32 \$34 sg13g2_inv_1
X$167 VDD GND \$173 \$160 sg13g2_inv_1
X$168 VDD GND \$118 \$I1121 sg13g2_inv_1
X$169 VDD GND \$111 \$115 sg13g2_inv_1
X$170 VDD GND \$159 \$172 sg13g2_inv_1
X$171 VDD GND \$32 \$73 sg13g2_inv_1
X$172 VDD GND \$32 \$86 sg13g2_inv_1
X$173 VDD GND \$32 \$166 sg13g2_inv_1
X$174 VDD GND \$173 \$167 sg13g2_inv_1
X$175 VDD GND \$23 \$67 sg13g2_inv_1
X$176 VDD GND \$111 \$171 sg13g2_inv_1
X$177 VDD GND \$165 \$180 sg13g2_inv_1
X$178 VDD GND \$158 \$170 sg13g2_inv_1
X$179 VDD GND \$32 \$82 sg13g2_inv_1
X$180 VDD GND \$23 \$130 sg13g2_inv_1
X$181 VDD GND \$111 \$155 sg13g2_inv_1
X$182 VDD GND \$111 \$139 sg13g2_inv_1
X$183 VDD GND \$111 \$123 sg13g2_inv_1
X$184 VDD GND \$37 \$83 sg13g2_inv_1
X$185 VDD GND \$23 \$74 sg13g2_inv_1
X$186 VDD GND \$23 \$42 sg13g2_inv_1
X$187 VDD GND \$111 \$124 sg13g2_inv_1
X$188 VDD GND \$23 \$26 sg13g2_inv_1
X$189 GND \$10 \$27 \$22 \$5 VDD sg13g2_mux2_1
X$190 VDD GND \$23 \$9 sg13g2_inv_1
X$191 VDD GND \$23 \$30 sg13g2_inv_1
X$192 VDD GND \$111 \$101 sg13g2_inv_1
X$193 VDD GND \$32 \$36 sg13g2_inv_1
X$194 VDD GND \$173 \$177 sg13g2_inv_1
X$195 VDD GND \$173 \$164 sg13g2_inv_1
X$196 VDD GND \$32 \$152 sg13g2_inv_1
X$197 VDD GND \$23 \$117 sg13g2_inv_1
X$251 VDD GND sg13g2_decap_4
X$252 VDD GND sg13g2_decap_4
X$253 VDD GND sg13g2_decap_4
X$254 VDD GND \$69 \$87 \$85 \$92 sg13g2_and3_1
X$255 GND VDD \$88 \$85 \$87 \$69 sg13g2_nand3_1
X$256 VDD GND sg13g2_decap_4
X$257 VDD GND sg13g2_decap_4
X$258 VDD GND sg13g2_decap_4
X$259 VDD GND sg13g2_decap_4
X$260 VDD GND sg13g2_decap_4
X$261 VDD GND sg13g2_decap_4
X$262 VDD GND sg13g2_decap_4
X$263 VDD GND sg13g2_decap_4
X$264 VDD GND sg13g2_decap_4
X$265 VDD GND sg13g2_decap_4
X$266 VDD GND sg13g2_decap_4
X$267 VDD GND sg13g2_decap_4
X$268 VDD GND sg13g2_decap_4
X$269 VDD GND sg13g2_decap_4
X$270 VDD GND sg13g2_decap_4
X$271 VDD GND sg13g2_decap_4
X$272 VDD GND sg13g2_decap_4
X$273 VDD GND sg13g2_decap_4
X$274 VDD GND sg13g2_decap_4
X$275 VDD GND sg13g2_decap_4
X$276 VDD GND sg13g2_decap_4
X$277 VDD GND sg13g2_decap_4
X$278 VDD GND sg13g2_decap_4
X$279 VDD GND sg13g2_decap_4
X$280 VDD GND sg13g2_decap_4
X$281 GND freq_out VDD \$37 sg13g2_buf_1
X$282 VDD GND sg13g2_decap_4
X$283 VDD GND sg13g2_decap_4
X$284 VDD GND sg13g2_decap_4
X$285 VDD GND sg13g2_decap_4
X$286 VDD GND sg13g2_decap_4
X$287 VDD GND sg13g2_decap_4
X$288 VDD GND sg13g2_decap_4
X$289 VDD GND sg13g2_decap_4
X$290 VDD GND sg13g2_decap_4
X$291 VDD GND sg13g2_decap_4
X$292 VDD GND sg13g2_decap_4
X$293 VDD GND sg13g2_decap_4
X$294 VDD GND sg13g2_decap_4
X$295 VDD GND sg13g2_decap_4
X$296 VDD GND sg13g2_decap_8
X$297 VDD GND sg13g2_decap_8
X$298 VDD GND sg13g2_decap_8
X$299 VDD GND sg13g2_decap_8
X$300 VDD GND sg13g2_decap_8
X$301 VDD GND sg13g2_decap_8
X$302 VDD GND sg13g2_decap_8
X$303 VDD GND sg13g2_decap_8
X$304 VDD GND sg13g2_decap_8
X$305 VDD GND sg13g2_decap_8
X$306 VDD GND sg13g2_decap_8
X$307 VDD GND sg13g2_decap_8
X$308 VDD GND sg13g2_decap_8
X$309 VDD GND sg13g2_decap_8
X$310 VDD GND sg13g2_decap_8
X$311 VDD GND sg13g2_decap_8
X$312 VDD GND sg13g2_decap_8
X$313 VDD GND sg13g2_decap_8
X$314 VDD GND sg13g2_decap_8
X$315 VDD GND sg13g2_decap_8
X$316 VDD GND sg13g2_decap_8
X$317 VDD GND sg13g2_decap_8
X$318 VDD GND sg13g2_decap_8
X$319 VDD GND sg13g2_decap_8
X$320 VDD GND sg13g2_decap_8
X$321 VDD GND sg13g2_decap_8
X$322 VDD GND sg13g2_decap_8
X$323 VDD GND sg13g2_decap_8
X$324 VDD GND sg13g2_decap_8
X$325 VDD GND sg13g2_decap_8
X$326 VDD GND sg13g2_decap_8
X$327 VDD GND sg13g2_decap_8
X$328 VDD GND sg13g2_decap_8
X$329 VDD GND sg13g2_decap_8
X$330 VDD GND sg13g2_decap_8
X$331 VDD GND sg13g2_decap_8
X$332 VDD GND sg13g2_decap_8
X$333 VDD GND sg13g2_decap_8
X$334 VDD GND sg13g2_decap_8
X$335 VDD GND sg13g2_decap_8
X$336 VDD GND sg13g2_decap_8
X$337 VDD GND sg13g2_decap_8
X$338 VDD GND sg13g2_decap_8
X$339 VDD GND sg13g2_decap_8
X$340 VDD GND sg13g2_decap_8
X$341 VDD GND sg13g2_decap_8
X$342 VDD GND sg13g2_decap_8
X$343 VDD GND sg13g2_decap_8
X$344 VDD GND sg13g2_decap_8
X$345 VDD GND sg13g2_decap_8
X$346 VDD GND sg13g2_decap_8
X$348 VDD GND sg13g2_decap_8
X$349 VDD GND sg13g2_decap_8
X$350 GND \$11 \$47 VDD sg13g2_buf_16
X$351 VDD GND sg13g2_decap_8
X$352 VDD GND sg13g2_decap_8
X$353 VDD GND sg13g2_decap_8
X$354 VDD GND sg13g2_decap_8
X$355 VDD GND sg13g2_decap_8
X$356 VDD GND sg13g2_decap_8
X$357 VDD GND sg13g2_decap_8
X$358 VDD GND sg13g2_decap_8
X$359 VDD GND sg13g2_decap_8
X$360 VDD GND sg13g2_decap_8
X$361 VDD GND sg13g2_decap_8
X$362 VDD GND sg13g2_decap_8
X$363 VDD GND sg13g2_decap_8
X$364 VDD GND sg13g2_decap_8
X$365 VDD GND sg13g2_decap_8
X$366 VDD GND sg13g2_decap_8
X$367 VDD GND sg13g2_decap_8
X$368 VDD GND sg13g2_decap_8
X$369 VDD GND sg13g2_decap_8
X$370 VDD GND sg13g2_decap_8
X$371 VDD GND sg13g2_decap_8
X$372 VDD GND sg13g2_decap_8
X$373 VDD GND sg13g2_decap_8
X$374 VDD GND sg13g2_decap_8
X$375 VDD GND sg13g2_decap_8
X$376 VDD GND sg13g2_decap_8
X$377 VDD GND sg13g2_decap_8
X$378 VDD GND sg13g2_decap_8
X$379 VDD GND sg13g2_decap_8
X$380 VDD GND sg13g2_decap_8
X$381 VDD GND sg13g2_decap_8
X$382 VDD GND sg13g2_decap_8
X$383 VDD GND sg13g2_decap_8
X$384 VDD GND sg13g2_decap_8
X$385 VDD GND sg13g2_decap_8
X$386 VDD GND sg13g2_decap_8
X$387 VDD GND sg13g2_decap_8
X$388 VDD GND sg13g2_decap_8
X$389 VDD GND sg13g2_decap_8
X$390 VDD GND sg13g2_decap_8
X$391 VDD GND sg13g2_decap_8
X$392 VDD GND sg13g2_decap_8
X$393 VDD GND sg13g2_decap_8
X$394 VDD GND sg13g2_decap_8
X$395 VDD GND sg13g2_decap_8
X$396 VDD GND sg13g2_decap_8
X$397 VDD GND sg13g2_decap_8
X$398 VDD GND sg13g2_decap_8
X$399 VDD GND sg13g2_decap_8
X$400 VDD GND sg13g2_decap_8
X$401 VDD GND sg13g2_decap_8
X$402 VDD GND sg13g2_decap_8
X$403 VDD GND sg13g2_decap_8
X$404 VDD GND sg13g2_decap_8
X$405 VDD GND sg13g2_decap_8
X$406 VDD GND sg13g2_decap_8
X$407 VDD GND sg13g2_decap_8
X$408 VDD GND sg13g2_decap_8
X$409 VDD GND sg13g2_decap_8
X$410 VDD GND sg13g2_decap_8
X$411 VDD GND sg13g2_decap_8
X$412 VDD GND sg13g2_decap_8
X$413 VDD GND sg13g2_decap_8
X$414 VDD GND sg13g2_decap_8
X$415 VDD GND sg13g2_decap_8
X$416 VDD GND sg13g2_decap_8
X$417 VDD GND sg13g2_decap_8
X$418 VDD GND sg13g2_decap_8
X$419 VDD GND sg13g2_decap_8
X$420 VDD GND sg13g2_decap_8
X$421 VDD GND sg13g2_decap_8
X$422 VDD GND sg13g2_decap_8
X$423 VDD GND sg13g2_decap_8
X$424 VDD GND sg13g2_decap_8
X$425 VDD GND sg13g2_decap_8
X$426 VDD GND sg13g2_decap_8
X$427 VDD GND \$64 \$55 \$54 sg13g2_nand2_1
X$428 VDD GND sg13g2_decap_8
X$429 VDD GND sg13g2_decap_8
X$430 VDD GND sg13g2_decap_8
X$431 VDD GND sg13g2_decap_8
X$432 VDD GND sg13g2_decap_8
X$433 VDD GND sg13g2_decap_8
X$434 VDD GND sg13g2_decap_8
X$435 VDD GND sg13g2_decap_8
X$436 VDD GND sg13g2_decap_8
X$437 VDD GND sg13g2_decap_8
X$438 VDD GND sg13g2_decap_8
X$439 VDD GND sg13g2_decap_8
X$440 VDD GND sg13g2_decap_8
X$441 VDD GND sg13g2_decap_8
X$442 VDD GND sg13g2_decap_8
X$443 VDD GND sg13g2_decap_8
X$444 VDD GND sg13g2_decap_8
X$445 VDD GND sg13g2_decap_8
X$446 VDD GND sg13g2_decap_8
X$447 VDD GND sg13g2_decap_8
X$448 VDD GND sg13g2_decap_8
X$449 VDD GND sg13g2_decap_8
X$450 VDD GND sg13g2_decap_8
X$451 VDD GND sg13g2_decap_8
X$452 VDD GND sg13g2_decap_8
X$453 VDD GND sg13g2_decap_8
X$454 VDD GND sg13g2_decap_8
X$455 VDD GND \$22 \$13 \$43 sg13g2_nand2b_1
X$456 VDD GND sg13g2_decap_8
X$457 VDD GND sg13g2_decap_4
X$459 VDD GND \$43 \$4 sg13g2_inv_1
X$460 VDD GND sg13g2_decap_8
X$461 VDD GND sg13g2_decap_8
X$462 VDD GND sg13g2_decap_8
X$463 VDD GND \$12 \$13 \$22 sg13g2_xnor2_1
X$464 GND \$13 VDD \$14 \$6 sg13g2_xor2_1
X$465 VDD GND sg13g2_decap_8
X$466 VDD GND sg13g2_decap_8
X$467 VDD GND sg13g2_decap_8
X$468 VDD GND sg13g2_decap_8
X$469 GND \$9 \$5 \$10 \$11 VDD sg13g2_dfrbpq_1
X$470 VDD GND sg13g2_decap_8
X$471 VDD GND sg13g2_decap_8
X$472 VDD GND sg13g2_decap_8
X$473 VDD GND sg13g2_decap_8
X$474 VDD GND sg13g2_decap_8
X$475 VDD GND sg13g2_decap_8
X$476 VDD GND sg13g2_decap_8
X$477 VDD GND sg13g2_decap_8
X$478 VDD GND sg13g2_decap_8
X$479 VDD GND sg13g2_decap_8
X$480 VDD GND sg13g2_decap_8
X$481 VDD GND sg13g2_decap_8
X$482 VDD GND sg13g2_decap_8
X$483 VDD GND sg13g2_decap_8
X$484 VDD GND sg13g2_decap_8
X$485 VDD GND sg13g2_decap_8
X$486 VDD GND sg13g2_decap_8
X$487 VDD GND sg13g2_decap_8
X$488 VDD GND sg13g2_decap_8
X$489 VDD GND sg13g2_decap_8
X$490 VDD GND sg13g2_decap_8
X$491 VDD GND sg13g2_decap_8
X$492 VDD GND sg13g2_decap_8
X$493 VDD GND sg13g2_decap_8
X$494 VDD GND sg13g2_decap_8
X$495 VDD GND sg13g2_decap_8
X$496 VDD GND sg13g2_decap_8
X$497 VDD GND sg13g2_decap_8
X$498 VDD GND sg13g2_decap_8
X$499 VDD GND sg13g2_decap_8
X$500 VDD GND sg13g2_decap_8
X$501 VDD GND sg13g2_decap_8
X$502 VDD GND sg13g2_decap_8
X$503 VDD GND sg13g2_decap_8
X$504 VDD GND sg13g2_decap_8
X$505 VDD GND sg13g2_decap_8
X$506 VDD GND sg13g2_decap_8
X$507 VDD GND sg13g2_decap_8
X$508 VDD GND sg13g2_decap_8
X$509 VDD GND sg13g2_decap_8
X$510 VDD GND sg13g2_decap_8
X$511 VDD GND sg13g2_decap_8
X$512 VDD GND sg13g2_decap_8
X$513 VDD GND sg13g2_decap_8
X$514 VDD GND sg13g2_decap_8
X$515 VDD GND sg13g2_decap_8
X$516 VDD GND sg13g2_decap_8
X$517 VDD GND sg13g2_decap_8
X$518 VDD GND sg13g2_decap_8
X$519 VDD GND sg13g2_decap_8
X$520 VDD GND sg13g2_decap_8
X$521 VDD GND sg13g2_decap_8
X$522 VDD GND sg13g2_decap_8
X$523 VDD GND sg13g2_decap_8
X$524 VDD GND sg13g2_decap_8
X$525 VDD GND sg13g2_decap_8
X$526 VDD GND sg13g2_decap_8
X$527 VDD GND sg13g2_decap_8
X$528 VDD GND sg13g2_decap_8
X$529 VDD GND sg13g2_decap_8
X$530 VDD GND sg13g2_decap_8
X$531 VDD GND sg13g2_decap_8
X$532 VDD GND sg13g2_decap_8
X$533 VDD GND sg13g2_decap_8
X$534 VDD GND sg13g2_decap_8
X$535 VDD GND sg13g2_decap_8
X$536 VDD GND sg13g2_decap_8
X$537 VDD GND sg13g2_decap_8
X$538 VDD GND sg13g2_decap_8
X$539 VDD GND sg13g2_decap_8
X$540 VDD GND sg13g2_decap_8
X$541 VDD GND sg13g2_decap_8
X$542 VDD GND sg13g2_decap_8
.ENDS DSM_N_FREQ_DIV

.SUBCKT sg13g2_a21o_1 VDD VSS X B1 A1 A2
M$1 X \$4 VSS VSS sg13_lv_nmos L=0.13u W=0.74u AS=0.2351p AD=0.15745p PS=2.16u
+ PD=1.175u rfmode=0
M$2 VSS B1 \$4 VSS sg13_lv_nmos L=0.13u W=0.64u AS=0.15745p AD=0.1216p
+ PS=1.175u PD=1.02u rfmode=0
M$3 \$4 A1 \$9 VSS sg13_lv_nmos L=0.13u W=0.64u AS=0.1216p AD=0.0816p PS=1.02u
+ PD=0.895u rfmode=0
M$4 \$9 A2 VSS VSS sg13_lv_nmos L=0.13u W=0.64u AS=0.0816p AD=0.2176p PS=0.895u
+ PD=1.96u rfmode=0
M$5 \$4 B1 \$6 VDD sg13_lv_pmos L=0.13u W=1u AS=0.35p AD=0.2125p PS=2.7u
+ PD=1.425u rfmode=0
M$6 \$6 A1 VDD VDD sg13_lv_pmos L=0.13u W=1u AS=0.2125p AD=0.19p PS=1.425u
+ PD=1.38u rfmode=0
M$7 VDD A2 \$6 VDD sg13_lv_pmos L=0.13u W=1u AS=0.19p AD=0.34p PS=1.38u
+ PD=2.68u rfmode=0
M$8 X \$4 VDD VDD sg13_lv_pmos L=0.13u W=1.12u AS=0.3808p AD=0.3808p PS=2.92u
+ PD=2.92u rfmode=0
.ENDS sg13g2_a21o_1

.SUBCKT sg13g2_a21oi_2 VDD VSS Y A2 B1 A1
M$1 VSS A2 \$2 VSS sg13_lv_nmos L=0.13u W=1.48u AS=0.3922p AD=0.2812p PS=3.28u
+ PD=2.24u rfmode=0
M$2 \$2 A1 Y VSS sg13_lv_nmos L=0.13u W=1.48u AS=0.2812p AD=0.2812p PS=2.24u
+ PD=2.24u rfmode=0
M$5 VSS B1 Y VSS sg13_lv_nmos L=0.13u W=1.48u AS=0.2812p AD=0.3922p PS=2.24u
+ PD=3.28u rfmode=0
M$7 \$4 A2 VDD VDD sg13_lv_pmos L=0.13u W=2.24u AS=0.5936p AD=0.4256p PS=4.42u
+ PD=3u rfmode=0
M$8 VDD A1 \$4 VDD sg13_lv_pmos L=0.13u W=2.24u AS=0.4256p AD=0.4256p PS=3u
+ PD=3u rfmode=0
M$11 \$4 B1 Y VDD sg13_lv_pmos L=0.13u W=2.24u AS=0.4256p AD=0.5936p PS=3u
+ PD=4.42u rfmode=0
.ENDS sg13g2_a21oi_2

.SUBCKT sg13g2_a21o_2 VSS VDD A2 A1 B1 X
M$1 VSS B1 \$6 VSS sg13_lv_nmos L=0.13u W=0.74u AS=0.3811p AD=0.1406p PS=2.51u
+ PD=1.12u rfmode=0
M$2 \$6 A1 \$9 VSS sg13_lv_nmos L=0.13u W=0.74u AS=0.1406p AD=0.09435p PS=1.12u
+ PD=0.995u rfmode=0
M$3 \$9 A2 VSS VSS sg13_lv_nmos L=0.13u W=0.74u AS=0.09435p AD=0.2516p
+ PS=0.995u PD=2.16u rfmode=0
M$4 VSS \$6 X VSS sg13_lv_nmos L=0.13u W=1.48u AS=0.3922p AD=0.3922p PS=3.28u
+ PD=3.28u rfmode=0
M$6 VDD \$6 X VDD sg13_lv_pmos L=0.13u W=2.24u AS=0.5936p AD=0.5936p PS=4.42u
+ PD=4.42u rfmode=0
M$8 \$6 B1 \$3 VDD sg13_lv_pmos L=0.13u W=1u AS=0.35p AD=0.2125p PS=2.7u
+ PD=1.425u rfmode=0
M$9 \$3 A1 VDD VDD sg13_lv_pmos L=0.13u W=1u AS=0.2125p AD=0.19p PS=1.425u
+ PD=1.38u rfmode=0
M$10 VDD A2 \$3 VDD sg13_lv_pmos L=0.13u W=1u AS=0.19p AD=0.34p PS=1.38u
+ PD=2.68u rfmode=0
.ENDS sg13g2_a21o_2

.SUBCKT sg13g2_nand2b_1 VDD VSS B A_N Y
M$1 VSS A_N \$6 VSS sg13_lv_nmos L=0.13u W=0.55u AS=0.14505p AD=0.187p PS=1.15u
+ PD=1.78u rfmode=0
M$2 VSS B \$7 VSS sg13_lv_nmos L=0.13u W=0.74u AS=0.14505p AD=0.1406p PS=1.15u
+ PD=1.12u rfmode=0
M$3 \$7 \$6 Y VSS sg13_lv_nmos L=0.13u W=0.74u AS=0.1406p AD=0.333p PS=1.12u
+ PD=2.38u rfmode=0
M$4 \$6 A_N VDD VDD sg13_lv_pmos L=0.13u W=0.84u AS=0.2856p AD=0.2198p PS=2.36u
+ PD=1.53u rfmode=0
M$5 VDD B Y VDD sg13_lv_pmos L=0.13u W=1.12u AS=0.2198p AD=0.2128p PS=1.53u
+ PD=1.5u rfmode=0
M$6 Y \$6 VDD VDD sg13_lv_pmos L=0.13u W=1.12u AS=0.2128p AD=0.3808p PS=1.5u
+ PD=2.92u rfmode=0
.ENDS sg13g2_nand2b_1

.SUBCKT sg13g2_and3_1 VDD VSS A C B X
M$1 \$7 A \$9 VSS sg13_lv_nmos L=0.13u W=0.64u AS=0.2176p AD=0.1216p PS=1.96u
+ PD=1.02u rfmode=0
M$2 \$9 B \$8 VSS sg13_lv_nmos L=0.13u W=0.64u AS=0.1216p AD=0.1216p PS=1.02u
+ PD=1.02u rfmode=0
M$3 VSS C \$8 VSS sg13_lv_nmos L=0.13u W=0.64u AS=0.1371p AD=0.1216p PS=1.12u
+ PD=1.02u rfmode=0
M$4 VSS \$7 X VSS sg13_lv_nmos L=0.13u W=0.74u AS=0.1371p AD=0.2516p PS=1.12u
+ PD=2.16u rfmode=0
M$5 \$7 A VDD VDD sg13_lv_pmos L=0.13u W=0.84u AS=0.2856p AD=0.1596p PS=2.36u
+ PD=1.22u rfmode=0
M$6 VDD B \$7 VDD sg13_lv_pmos L=0.13u W=0.84u AS=0.1596p AD=0.1596p PS=1.22u
+ PD=1.22u rfmode=0
M$7 VDD C \$7 VDD sg13_lv_pmos L=0.13u W=0.84u AS=0.36195p AD=0.1596p PS=1.84u
+ PD=1.22u rfmode=0
M$8 VDD \$7 X VDD sg13_lv_pmos L=0.13u W=1.12u AS=0.36195p AD=0.3808p PS=1.84u
+ PD=2.92u rfmode=0
.ENDS sg13g2_and3_1

.SUBCKT sg13g2_mux2_1 VSS X S A1 A0 VDD
M$1 VSS S \$2 VSS sg13_lv_nmos L=0.13u W=0.55u AS=0.18945p AD=0.187p PS=1.27u
+ PD=1.78u rfmode=0
M$2 VSS S \$8 VSS sg13_lv_nmos L=0.13u W=0.74u AS=0.18945p AD=0.13135p PS=1.27u
+ PD=1.095u rfmode=0
M$3 \$8 A1 \$3 VSS sg13_lv_nmos L=0.13u W=0.74u AS=0.13135p AD=0.1628p
+ PS=1.095u PD=1.18u rfmode=0
M$4 \$3 A0 \$9 VSS sg13_lv_nmos L=0.13u W=0.74u AS=0.1628p AD=0.3367p PS=1.18u
+ PD=1.65u rfmode=0
M$5 \$9 \$2 VSS VSS sg13_lv_nmos L=0.13u W=0.74u AS=0.3367p AD=0.148p PS=1.65u
+ PD=1.14u rfmode=0
M$6 VSS \$3 X VSS sg13_lv_nmos L=0.13u W=0.74u AS=0.148p AD=0.4033p PS=1.14u
+ PD=2.57u rfmode=0
M$7 \$2 S VDD VDD sg13_lv_pmos L=0.13u W=0.84u AS=0.2856p AD=0.253p PS=2.36u
+ PD=1.53u rfmode=0
M$8 VDD S \$10 VDD sg13_lv_pmos L=0.13u W=1u AS=0.253p AD=0.3325p PS=1.53u
+ PD=1.665u rfmode=0
M$9 \$10 A0 \$3 VDD sg13_lv_pmos L=0.13u W=1u AS=0.3325p AD=0.2225p PS=1.665u
+ PD=1.445u rfmode=0
M$10 \$3 A1 \$11 VDD sg13_lv_pmos L=0.13u W=1u AS=0.2225p AD=0.2975p PS=1.445u
+ PD=1.595u rfmode=0
M$11 \$11 \$2 VDD VDD sg13_lv_pmos L=0.13u W=1u AS=0.2975p AD=0.2198p PS=1.595u
+ PD=1.52u rfmode=0
M$12 VDD \$3 X VDD sg13_lv_pmos L=0.13u W=1.12u AS=0.2198p AD=0.6048p PS=1.52u
+ PD=3.32u rfmode=0
.ENDS sg13g2_mux2_1

.SUBCKT sg13g2_nor2b_1 VSS VDD Y A B_N
M$1 VSS B_N \$5 VSS sg13_lv_nmos L=0.13u W=0.55u AS=0.17255p AD=0.187p PS=1.25u
+ PD=1.78u rfmode=0
M$2 VSS \$5 Y VSS sg13_lv_nmos L=0.13u W=0.74u AS=0.17255p AD=0.1406p PS=1.25u
+ PD=1.12u rfmode=0
M$3 Y A VSS VSS sg13_lv_nmos L=0.13u W=0.74u AS=0.1406p AD=0.2516p PS=1.12u
+ PD=2.16u rfmode=0
M$4 \$5 B_N VDD VDD sg13_lv_pmos L=0.13u W=0.84u AS=0.2856p AD=0.2618p PS=2.36u
+ PD=1.63u rfmode=0
M$5 VDD \$5 \$7 VDD sg13_lv_pmos L=0.13u W=1.12u AS=0.2618p AD=0.1176p PS=1.63u
+ PD=1.33u rfmode=0
M$6 \$7 A Y VDD sg13_lv_pmos L=0.13u W=1.12u AS=0.1176p AD=0.3808p PS=1.33u
+ PD=2.92u rfmode=0
.ENDS sg13g2_nor2b_1

.SUBCKT sg13g2_nand3_1 VSS VDD Y B C A
M$1 VSS C \$8 VSS sg13_lv_nmos L=0.13u W=0.74u AS=0.2886p AD=0.1406p PS=2.26u
+ PD=1.12u rfmode=0
M$2 \$8 B \$7 VSS sg13_lv_nmos L=0.13u W=0.74u AS=0.1406p AD=0.1406p PS=1.12u
+ PD=1.12u rfmode=0
M$3 \$7 A Y VSS sg13_lv_nmos L=0.13u W=0.74u AS=0.1406p AD=0.2516p PS=1.12u
+ PD=2.16u rfmode=0
M$4 VDD C Y VDD sg13_lv_pmos L=0.13u W=1.12u AS=0.3808p AD=0.2128p PS=2.92u
+ PD=1.5u rfmode=0
M$5 Y B VDD VDD sg13_lv_pmos L=0.13u W=1.12u AS=0.2128p AD=0.2128p PS=1.5u
+ PD=1.5u rfmode=0
M$6 VDD A Y VDD sg13_lv_pmos L=0.13u W=1.12u AS=0.2128p AD=0.3808p PS=1.5u
+ PD=2.92u rfmode=0
.ENDS sg13g2_nand3_1

.SUBCKT sg13g2_a221oi_1 VSS B1 VDD Y B2 C1 A1 A2
M$1 Y A1 \$11 VSS sg13_lv_nmos L=0.13u W=0.74u AS=0.2516p AD=0.1406p PS=2.16u
+ PD=1.12u rfmode=0
M$2 \$11 A2 VSS VSS sg13_lv_nmos L=0.13u W=0.74u AS=0.1406p AD=0.2516p PS=1.12u
+ PD=2.16u rfmode=0
M$3 Y C1 VSS VSS sg13_lv_nmos L=0.13u W=0.74u AS=0.2516p AD=0.1406p PS=2.16u
+ PD=1.12u rfmode=0
M$4 VSS B2 \$12 VSS sg13_lv_nmos L=0.13u W=0.74u AS=0.1406p AD=0.1406p PS=1.12u
+ PD=1.12u rfmode=0
M$5 \$12 B1 Y VSS sg13_lv_nmos L=0.13u W=0.74u AS=0.1406p AD=0.2516p PS=1.12u
+ PD=2.16u rfmode=0
M$6 VDD A1 \$9 VDD sg13_lv_pmos L=0.13u W=1.12u AS=0.3808p AD=0.2128p PS=2.92u
+ PD=1.5u rfmode=0
M$7 \$9 A2 VDD VDD sg13_lv_pmos L=0.13u W=1.12u AS=0.2128p AD=0.3808p PS=1.5u
+ PD=2.92u rfmode=0
M$8 Y C1 \$6 VDD sg13_lv_pmos L=0.13u W=1.12u AS=0.3808p AD=0.2128p PS=2.92u
+ PD=1.5u rfmode=0
M$9 \$6 B2 \$9 VDD sg13_lv_pmos L=0.13u W=1.12u AS=0.2128p AD=0.2128p PS=1.5u
+ PD=1.5u rfmode=0
M$10 \$9 B1 \$6 VDD sg13_lv_pmos L=0.13u W=1.12u AS=0.2128p AD=0.3808p PS=1.5u
+ PD=2.92u rfmode=0
.ENDS sg13g2_a221oi_1

.SUBCKT sg13g2_nor3_1 VDD VSS C Y B A
M$1 VSS A Y VSS sg13_lv_nmos L=0.13u W=0.77u AS=0.2618p AD=0.1694p PS=2.22u
+ PD=1.21u rfmode=0
M$2 Y B VSS VSS sg13_lv_nmos L=0.13u W=0.77u AS=0.1694p AD=0.1463p PS=1.21u
+ PD=1.15u rfmode=0
M$3 VSS C Y VSS sg13_lv_nmos L=0.13u W=0.77u AS=0.1463p AD=0.2618p PS=1.15u
+ PD=2.22u rfmode=0
M$4 VDD A \$8 VDD sg13_lv_pmos L=0.13u W=1.12u AS=0.3808p AD=0.2464p PS=2.92u
+ PD=1.56u rfmode=0
M$5 \$8 B \$7 VDD sg13_lv_pmos L=0.13u W=1.12u AS=0.2464p AD=0.2128p PS=1.56u
+ PD=1.5u rfmode=0
M$6 \$7 C Y VDD sg13_lv_pmos L=0.13u W=1.12u AS=0.2128p AD=0.3808p PS=1.5u
+ PD=2.92u rfmode=0
.ENDS sg13g2_nor3_1

.SUBCKT sg13g2_nand2_1 VDD VSS Y A B
M$1 VSS B \$6 VSS sg13_lv_nmos L=0.13u W=0.74u AS=0.2516p AD=0.1406p PS=2.16u
+ PD=1.12u rfmode=0
M$2 \$6 A Y VSS sg13_lv_nmos L=0.13u W=0.74u AS=0.1406p AD=0.2516p PS=1.12u
+ PD=2.16u rfmode=0
M$3 VDD B Y VDD sg13_lv_pmos L=0.13u W=1.12u AS=0.3808p AD=0.2128p PS=2.92u
+ PD=1.5u rfmode=0
M$4 Y A VDD VDD sg13_lv_pmos L=0.13u W=1.12u AS=0.2128p AD=0.3808p PS=1.5u
+ PD=2.92u rfmode=0
.ENDS sg13g2_nand2_1

.SUBCKT sg13g2_and2_1 VDD VSS X A B
M$1 \$4 A \$7 VSS sg13_lv_nmos L=0.13u W=0.64u AS=0.2176p AD=0.1216p PS=1.96u
+ PD=1.02u rfmode=0
M$2 VSS B \$7 VSS sg13_lv_nmos L=0.13u W=0.64u AS=0.1331p AD=0.1216p PS=1.12u
+ PD=1.02u rfmode=0
M$3 VSS \$4 X VSS sg13_lv_nmos L=0.13u W=0.74u AS=0.1331p AD=0.2516p PS=1.12u
+ PD=2.16u rfmode=0
M$4 VDD A \$4 VDD sg13_lv_pmos L=0.13u W=0.84u AS=0.2856p AD=0.1596p PS=2.36u
+ PD=1.22u rfmode=0
M$5 VDD B \$4 VDD sg13_lv_pmos L=0.13u W=0.84u AS=0.1918p AD=0.1596p PS=1.5u
+ PD=1.22u rfmode=0
M$6 VDD \$4 X VDD sg13_lv_pmos L=0.13u W=1.12u AS=0.1918p AD=0.3808p PS=1.5u
+ PD=2.92u rfmode=0
.ENDS sg13g2_and2_1

.SUBCKT sg13g2_o21ai_1 VSS Y VDD B1 A2 A1
M$1 \$2 A1 VSS VSS sg13_lv_nmos L=0.15u W=0.74u AS=0.2516p AD=0.1406p PS=2.16u
+ PD=1.12u rfmode=0
M$2 VSS A2 \$2 VSS sg13_lv_nmos L=0.15u W=0.74u AS=0.1406p AD=0.1406p PS=1.12u
+ PD=1.12u rfmode=0
M$3 \$2 B1 Y VSS sg13_lv_nmos L=0.15u W=0.74u AS=0.1406p AD=0.2516p PS=1.12u
+ PD=2.16u rfmode=0
M$4 VDD A1 \$8 VDD sg13_lv_pmos L=0.15u W=1.12u AS=0.3808p AD=0.2128p PS=2.92u
+ PD=1.5u rfmode=0
M$5 \$8 A2 Y VDD sg13_lv_pmos L=0.15u W=1.12u AS=0.2128p AD=0.2128p PS=1.5u
+ PD=1.5u rfmode=0
M$6 Y B1 VDD VDD sg13_lv_pmos L=0.15u W=1.12u AS=0.2128p AD=0.3808p PS=1.5u
+ PD=2.92u rfmode=0
.ENDS sg13g2_o21ai_1

.SUBCKT sg13g2_buf_1 VSS X VDD A
M$1 VSS A \$1 VSS sg13_lv_nmos L=0.13u W=0.55u AS=0.14875p AD=0.187p PS=1.16u
+ PD=1.78u rfmode=0
M$2 VSS \$1 X VSS sg13_lv_nmos L=0.13u W=0.74u AS=0.14875p AD=0.2886p PS=1.16u
+ PD=2.26u rfmode=0
M$3 VDD A \$1 VDD sg13_lv_pmos L=0.13u W=0.84u AS=0.2114p AD=0.2856p PS=1.54u
+ PD=2.36u rfmode=0
M$4 VDD \$1 X VDD sg13_lv_pmos L=0.13u W=1.12u AS=0.2114p AD=0.42p PS=1.54u
+ PD=2.99u rfmode=0
.ENDS sg13g2_buf_1

.SUBCKT sg13g2_inv_1 VDD VSS A Y
M$1 VSS A Y VSS sg13_lv_nmos L=0.13u W=0.74u AS=0.2516p AD=0.2516p PS=2.16u
+ PD=2.16u rfmode=0
M$2 VDD A Y VDD sg13_lv_pmos L=0.13u W=1.12u AS=0.3808p AD=0.3808p PS=2.92u
+ PD=2.92u rfmode=0
.ENDS sg13g2_inv_1

.SUBCKT sg13g2_a21oi_1 Y VSS A2 VDD A1 B1
M$1 VSS B1 Y VSS sg13_lv_nmos L=0.13u W=0.74u AS=0.2516p AD=0.1406p PS=2.16u
+ PD=1.12u rfmode=0
M$2 Y A1 \$8 VSS sg13_lv_nmos L=0.13u W=0.74u AS=0.1406p AD=0.1406p PS=1.12u
+ PD=1.12u rfmode=0
M$3 \$8 A2 VSS VSS sg13_lv_nmos L=0.13u W=0.74u AS=0.1406p AD=0.2516p PS=1.12u
+ PD=2.16u rfmode=0
M$4 Y B1 \$3 VDD sg13_lv_pmos L=0.13u W=1.12u AS=0.3808p AD=0.2128p PS=2.92u
+ PD=1.5u rfmode=0
M$5 \$3 A1 VDD VDD sg13_lv_pmos L=0.13u W=1.12u AS=0.2128p AD=0.2128p PS=1.5u
+ PD=1.5u rfmode=0
M$6 VDD A2 \$3 VDD sg13_lv_pmos L=0.13u W=1.12u AS=0.2128p AD=0.3808p PS=1.5u
+ PD=2.92u rfmode=0
.ENDS sg13g2_a21oi_1

.SUBCKT sg13g2_buf_16 VSS X A VDD
M$1 VSS \$3 X VSS sg13_lv_nmos L=0.13u W=11.84u AS=2.3606p AD=2.2496p PS=18.96u
+ PD=17.92u rfmode=0
M$17 VSS A \$3 VSS sg13_lv_nmos L=0.13u W=4.44u AS=0.8436p AD=0.9546p PS=6.72u
+ PD=7.76u rfmode=0
M$23 VDD \$3 X VDD sg13_lv_pmos L=0.13u W=17.92u AS=3.5896p AD=3.4048p
+ PS=25.45u PD=24u rfmode=0
M$39 VDD A \$3 VDD sg13_lv_pmos L=0.13u W=6.72u AS=1.2768p AD=1.4448p PS=9u
+ PD=10.42u rfmode=0
.ENDS sg13g2_buf_16

.SUBCKT sg13g2_decap_4 VDD VSS
M$1 VSS VDD VSS VSS sg13_lv_nmos L=1u W=0.42u AS=0.1428p AD=0.1428p PS=1.52u
+ PD=1.52u rfmode=0
M$2 VDD VSS VDD VDD sg13_lv_pmos L=1u W=1u AS=0.34p AD=0.34p PS=2.68u PD=2.68u
+ rfmode=0
.ENDS sg13g2_decap_4

.SUBCKT sg13g2_xnor2_1 VDD VSS Y B A
M$1 VSS A \$8 VSS sg13_lv_nmos L=0.13u W=0.64u AS=0.2272p AD=0.0784p PS=1.99u
+ PD=0.885u rfmode=0
M$2 \$8 B \$7 VSS sg13_lv_nmos L=0.13u W=0.64u AS=0.0784p AD=0.2176p PS=0.885u
+ PD=1.96u rfmode=0
M$3 VSS A \$3 VSS sg13_lv_nmos L=0.13u W=0.74u AS=0.1898p AD=0.2516p PS=1.36u
+ PD=2.16u rfmode=0
M$4 VSS B \$3 VSS sg13_lv_nmos L=0.13u W=0.74u AS=0.1898p AD=0.1406p PS=1.36u
+ PD=1.12u rfmode=0
M$5 \$3 \$7 Y VSS sg13_lv_nmos L=0.13u W=0.74u AS=0.1406p AD=0.2516p PS=1.12u
+ PD=2.16u rfmode=0
M$6 VDD A \$7 VDD sg13_lv_pmos L=0.13u W=0.84u AS=0.4536p AD=0.1596p PS=2.76u
+ PD=1.22u rfmode=0
M$7 VDD B \$7 VDD sg13_lv_pmos L=0.13u W=0.84u AS=0.2891p AD=0.1596p PS=1.695u
+ PD=1.22u rfmode=0
M$8 VDD A \$9 VDD sg13_lv_pmos L=0.13u W=1.12u AS=0.2891p AD=0.1428p PS=1.695u
+ PD=1.375u rfmode=0
M$9 \$9 B Y VDD sg13_lv_pmos L=0.13u W=1.12u AS=0.1428p AD=0.2408p PS=1.375u
+ PD=1.55u rfmode=0
M$10 Y \$7 VDD VDD sg13_lv_pmos L=0.13u W=1.12u AS=0.2408p AD=0.3808p PS=1.55u
+ PD=2.92u rfmode=0
.ENDS sg13g2_xnor2_1

.SUBCKT sg13g2_xor2_1 VSS X VDD B A
M$1 VSS A \$1 VSS sg13_lv_nmos L=0.13u W=0.55u AS=0.374p AD=0.174625p PS=2.46u
+ PD=1.185u rfmode=0
M$2 VSS B \$1 VSS sg13_lv_nmos L=0.13u W=0.55u AS=0.15245p AD=0.174625p
+ PS=1.17u PD=1.185u rfmode=0
M$3 VSS A \$8 VSS sg13_lv_nmos L=0.13u W=0.74u AS=0.15245p AD=0.0888p PS=1.17u
+ PD=0.98u rfmode=0
M$4 \$8 B X VSS sg13_lv_nmos L=0.13u W=0.74u AS=0.0888p AD=0.1628p PS=0.98u
+ PD=1.18u rfmode=0
M$5 X \$1 VSS VSS sg13_lv_nmos L=0.13u W=0.74u AS=0.1628p AD=0.3108p PS=1.18u
+ PD=2.32u rfmode=0
M$6 \$3 A VDD VDD sg13_lv_pmos L=0.13u W=1.12u AS=0.3808p AD=0.2128p PS=2.92u
+ PD=1.5u rfmode=0
M$7 VDD B \$3 VDD sg13_lv_pmos L=0.13u W=1.12u AS=0.2128p AD=0.2128p PS=1.5u
+ PD=1.5u rfmode=0
M$8 \$3 \$1 X VDD sg13_lv_pmos L=0.13u W=1.12u AS=0.2128p AD=0.3808p PS=1.5u
+ PD=2.92u rfmode=0
M$9 VDD A \$9 VDD sg13_lv_pmos L=0.13u W=1u AS=0.36p AD=0.1225p PS=2.72u
+ PD=1.245u rfmode=0
M$10 \$9 B \$1 VDD sg13_lv_pmos L=0.13u W=1u AS=0.1225p AD=0.34p PS=1.245u
+ PD=2.68u rfmode=0
.ENDS sg13g2_xor2_1

.SUBCKT sg13g2_dfrbpq_1 VSS RESET_B Q D CLK VDD
M$1 VSS \$4 \$19 VSS sg13_lv_nmos L=0.13u W=0.74u AS=0.317325p AD=0.2516p
+ PS=1.805u PD=2.16u rfmode=0
M$2 VSS CLK \$4 VSS sg13_lv_nmos L=0.13u W=0.74u AS=0.317325p AD=0.2516p
+ PS=1.805u PD=2.16u rfmode=0
M$3 \$14 \$4 \$7 VSS sg13_lv_nmos L=0.13u W=0.42u AS=0.12665p AD=0.1428p
+ PS=1.145u PD=1.52u rfmode=0
M$4 \$3 \$19 \$14 VSS sg13_lv_nmos L=0.13u W=0.74u AS=0.3473p AD=0.12665p
+ PS=2.71u PD=1.145u rfmode=0
M$5 \$7 \$8 VSS VSS sg13_lv_nmos L=0.13u W=0.42u AS=0.1428p AD=0.0798p PS=1.52u
+ PD=0.8u rfmode=0
M$6 VSS RESET_B \$17 VSS sg13_lv_nmos L=0.13u W=0.42u AS=0.0798p AD=0.0378p
+ PS=0.8u PD=0.6u rfmode=0
M$7 \$17 \$14 \$8 VSS sg13_lv_nmos L=0.13u W=0.42u AS=0.0378p AD=0.1428p
+ PS=0.6u PD=1.52u rfmode=0
M$8 \$9 \$14 VSS VSS sg13_lv_nmos L=0.13u W=0.74u AS=0.2516p AD=0.1406p
+ PS=2.16u PD=1.12u rfmode=0
M$9 VSS \$9 Q VSS sg13_lv_nmos L=0.13u W=0.74u AS=0.1406p AD=0.2516p PS=1.12u
+ PD=2.16u rfmode=0
M$10 \$5 D \$15 VSS sg13_lv_nmos L=0.13u W=0.42u AS=0.1428p AD=0.0609p PS=1.52u
+ PD=0.71u rfmode=0
M$11 \$15 RESET_B VSS VSS sg13_lv_nmos L=0.13u W=0.42u AS=0.0609p AD=0.1626p
+ PS=0.71u PD=1.415u rfmode=0
M$12 VSS \$12 \$3 VSS sg13_lv_nmos L=0.13u W=0.74u AS=0.1626p AD=0.2516p
+ PS=1.415u PD=2.16u rfmode=0
M$13 \$5 \$4 \$12 VSS sg13_lv_nmos L=0.13u W=0.42u AS=0.1296p AD=0.0798p
+ PS=1.52u PD=0.8u rfmode=0
M$14 \$12 \$19 \$6 VSS sg13_lv_nmos L=0.13u W=0.42u AS=0.0798p AD=0.2373p
+ PS=0.8u PD=1.97u rfmode=0
M$15 VSS RESET_B \$16 VSS sg13_lv_nmos L=0.13u W=0.42u AS=0.1701p AD=0.0378p
+ PS=1.65u PD=0.6u rfmode=0
M$16 \$16 \$3 \$6 VSS sg13_lv_nmos L=0.13u W=0.42u AS=0.0378p AD=0.1428p
+ PS=0.6u PD=1.52u rfmode=0
M$17 \$14 \$19 \$21 VDD sg13_lv_pmos L=0.13u W=0.42u AS=0.2048p AD=0.09345p
+ PS=1.63u PD=0.865u rfmode=0
M$18 \$21 \$8 VDD VDD sg13_lv_pmos L=0.13u W=0.42u AS=0.09345p AD=0.204p
+ PS=0.865u PD=1.835u rfmode=0
M$19 VDD RESET_B \$8 VDD sg13_lv_pmos L=0.13u W=0.42u AS=0.204p AD=0.0798p
+ PS=1.835u PD=0.8u rfmode=0
M$20 \$8 \$14 VDD VDD sg13_lv_pmos L=0.13u W=0.42u AS=0.0798p AD=0.4659p
+ PS=0.8u PD=3.65u rfmode=0
M$21 \$3 \$4 \$14 VDD sg13_lv_pmos L=0.13u W=1u AS=0.34p AD=0.2048p PS=2.68u
+ PD=1.63u rfmode=0
M$22 \$9 \$14 VDD VDD sg13_lv_pmos L=0.13u W=1.12u AS=0.3864p AD=0.2128p
+ PS=2.93u PD=1.5u rfmode=0
M$23 VDD \$9 Q VDD sg13_lv_pmos L=0.13u W=1.12u AS=0.2128p AD=0.3808p PS=1.5u
+ PD=2.92u rfmode=0
M$24 VDD D \$5 VDD sg13_lv_pmos L=0.13u W=0.42u AS=0.1428p AD=0.0798p PS=1.52u
+ PD=0.8u rfmode=0
M$25 VDD RESET_B \$5 VDD sg13_lv_pmos L=0.13u W=0.42u AS=0.3623875p AD=0.0798p
+ PS=2.605u PD=0.8u rfmode=0
M$26 VDD \$12 \$3 VDD sg13_lv_pmos L=0.13u W=1u AS=0.3623875p AD=0.34p
+ PS=2.605u PD=2.68u rfmode=0
M$27 \$19 \$4 VDD VDD sg13_lv_pmos L=0.13u W=1.12u AS=0.3864p AD=0.41165p
+ PS=2.93u PD=2.12u rfmode=0
M$28 VDD CLK \$4 VDD sg13_lv_pmos L=0.13u W=1.12u AS=0.41165p AD=0.4088p
+ PS=2.12u PD=2.97u rfmode=0
M$29 \$12 RESET_B VDD VDD sg13_lv_pmos L=0.13u W=0.42u AS=0.147p AD=0.1563p
+ PS=1.54u PD=1.22u rfmode=0
M$30 VDD \$3 \$20 VDD sg13_lv_pmos L=0.13u W=0.42u AS=0.1563p AD=0.063p
+ PS=1.22u PD=0.72u rfmode=0
M$31 \$20 \$4 \$12 VDD sg13_lv_pmos L=0.13u W=0.42u AS=0.063p AD=0.0798p
+ PS=0.72u PD=0.8u rfmode=0
M$32 \$12 \$19 \$5 VDD sg13_lv_pmos L=0.13u W=0.42u AS=0.0798p AD=0.1428p
+ PS=0.8u PD=1.52u rfmode=0
.ENDS sg13g2_dfrbpq_1

.SUBCKT sg13g2_decap_8 VDD VSS
M$1 VSS VDD VSS VSS sg13_lv_nmos L=1u W=0.84u AS=0.2226p AD=0.2226p PS=2.32u
+ PD=2.32u rfmode=0
M$3 VDD VSS VDD VDD sg13_lv_pmos L=1u W=2u AS=0.53p AD=0.53p PS=4.06u PD=4.06u
+ rfmode=0
.ENDS sg13g2_decap_8

.SUBCKT sg13g2_nor2_1 VDD VSS B A Y
M$1 VSS A Y VSS sg13_lv_nmos L=0.13u W=0.74u AS=0.2516p AD=0.1406p PS=2.16u
+ PD=1.12u rfmode=0
M$2 Y B VSS VSS sg13_lv_nmos L=0.13u W=0.74u AS=0.1406p AD=0.2516p PS=1.12u
+ PD=2.16u rfmode=0
M$3 VDD A \$6 VDD sg13_lv_pmos L=0.13u W=1.12u AS=0.4032p AD=0.1176p PS=2.96u
+ PD=1.33u rfmode=0
M$4 \$6 B Y VDD sg13_lv_pmos L=0.13u W=1.12u AS=0.1176p AD=0.3808p PS=1.33u
+ PD=2.92u rfmode=0
.ENDS sg13g2_nor2_1
