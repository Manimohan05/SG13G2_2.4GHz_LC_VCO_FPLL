* Extracted by KLayout with SG13G2 LVS runset on : 11/04/2026 05:13

.SUBCKT LC_VCO GND|OUTn|OUTp|VCTRL VDD OUT Vx Vgs VBGR
M$1 Vx GND|OUTn|OUTp|VCTRL GND|OUTn|OUTp|VCTRL GND|OUTn|OUTp|VCTRL sg13_lv_nmos
+ L=0.13u W=43.98u AS=10.5552p AD=10.5552p PS=61.52u PD=61.52u rfmode=0
M$4 GND|OUTn|OUTp|VCTRL GND|OUTn|OUTp|VCTRL \$73 GND|OUTn|OUTp|VCTRL
+ sg13_lv_nmos L=0.13u W=1.5u AS=0.51p AD=0.51p PS=3.68u PD=3.68u rfmode=0
M$8 OUT GND|OUTn|OUTp|VCTRL GND|OUTn|OUTp|VCTRL GND|OUTn|OUTp|VCTRL
+ sg13_lv_nmos L=0.13u W=1.5u AS=0.51p AD=0.51p PS=3.68u PD=3.68u rfmode=0
M$9 GND|OUTn|OUTp|VCTRL Vgs Vx GND|OUTn|OUTp|VCTRL sg13_lv_nmos L=1u W=384u
+ AS=74.16p AD=74.16p PS=410.54u PD=410.54u rfmode=0
M$57 GND|OUTn|OUTp|VCTRL Vgs Vgs GND|OUTn|OUTp|VCTRL sg13_lv_nmos L=1u W=64u
+ AS=13.36p AD=13.36p PS=75.34u PD=75.34u rfmode=0
M$65 VDD GND|OUTn|OUTp|VCTRL \$73 VDD sg13_lv_pmos L=0.13u W=15u AS=3.075p
+ AD=3.075p PS=20.6u PD=20.6u rfmode=0
M$75 VDD GND|OUTn|OUTp|VCTRL GND|OUTn|OUTp|VCTRL VDD sg13_lv_pmos L=0.13u W=72u
+ AS=15.84p AD=15.84p PS=90.8u PD=90.8u rfmode=0
M$80 VDD GND|OUTn|OUTp|VCTRL OUT VDD sg13_lv_pmos L=0.13u W=15u AS=3.075p
+ AD=3.075p PS=20.6u PD=20.6u rfmode=0
M$95 Vgs VBGR VDD VDD sg13_lv_pmos L=1u W=38u AS=8.36p AD=8.36p PS=47.8u
+ PD=47.8u rfmode=0
C$101 \$67 GND|OUTn|OUTp|VCTRL \$68 GND|OUTn|OUTp|VCTRL sg13_hv_svaricap
+ w=9.74u l=0.8u Nx=7
C$102 \$90 GND|OUTn|OUTp|VCTRL \$91 GND|OUTn|OUTp|VCTRL sg13_hv_svaricap
+ w=9.74u l=0.8u Nx=7
.ENDS LC_VCO
