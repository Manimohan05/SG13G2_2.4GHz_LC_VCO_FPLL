** sch_path: /home/designer/shared/LC_VCO_FPLL/xschem/PFD_CP_LF.sch
.subckt PFD_CP_LF CLK_IN VCTRL VDD VSS CLK_FB VBGR
*.PININFO CLK_IN:I VCTRL:O VDD:B VSS:B CLK_FB:I VBGR:B
x1 CLK_IN UP VDD VSS CLK_FB DN PHASE_FREQ_DET
x2 UP VDD VCP VBGR VSS DN VSS CHARGE_PUMP
x3 VCTRL VCP VSS VSS LOOP_FILTER
.ends

* expanding   symbol:  xschem/PHASE_FREQ_DET.sym # of pins=6
** sym_path: /home/designer/shared/LC_VCO_FPLL/xschem/PHASE_FREQ_DET.sym
** sch_path: /home/designer/shared/LC_VCO_FPLL/xschem/PHASE_FREQ_DET.sch
.subckt PHASE_FREQ_DET FREF UP VDD GND FDIV DN
*.PININFO UP:O FREF:I VDD:B GND:B DN:O FDIV:I
* noconn #net2
x1 net1 UP FREF VDD nRST VDD GND sg13g2_dfrbp_2
x2 DN net2 FDIV VDD nRST VDD GND sg13g2_dfrbp_2
x3 nRST net1 DN VDD GND sg13g2_nand2_2
.ends

* expanding   symbol:  xschem/CHARGE_PUMP.sym # of pins=7
** sym_path: /home/designer/shared/LC_VCO_FPLL/xschem/CHARGE_PUMP.sym
** sch_path: /home/designer/shared/LC_VCO_FPLL/xschem/CHARGE_PUMP.sch
.subckt CHARGE_PUMP UP VDD VCP VBGR GND DN SUB!
*.PININFO VCP:O UP:I DN:I GND:B VBGR:B VDD:B SUB!:B
MM2 Vbn Vbn net5 SUB! sg13_lv_nmos w=40.7u l=2u ng=5
MM8 net2 GND VDD NW sg13_lv_pmos w=29.6u l=2u ng=5
MM11 Vbp Vbp net2 NW sg13_lv_pmos w=163.6u l=2u ng=20
MM3 Vbn Vbp net1 NW sg13_lv_pmos w=163.6u l=2u ng=20
MM4 net1 GND VDD NW sg13_lv_pmos w=29.6u l=2u ng=5
MM7 net3 UP VDD NW sg13_lv_pmos w=29.6u l=2u ng=5
MM9 VCP Vbp net3 NW sg13_lv_pmos w=163.6u l=2u ng=20
MM10 net5 VDD GND SUB! sg13_lv_nmos w=6u l=2u ng=1
MM1 net4 DN GND SUB! sg13_lv_nmos w=6u l=2u ng=1
MM5 VCP Vbn net4 SUB! sg13_lv_nmos w=40.7u l=2u ng=5
MM6 Vbp VBGR GND SUB! sg13_lv_nmos w=3.9u l=2u ng=1
RR1 VDD NW ntap1 A=5.184e-11 P=0.0003456
RR2 VDD NW ntap1 A=2.724e-11 P=0.0001816
RR3 GND SUB! ptap1 A=7.404e-12 P=4.936e-05
RR4 GND SUB! ptap1 A=2.5164e-11 P=0.00016776
RR5 GND SUB! ptap1 A=1.524e-11 P=0.0001016
.ends

* expanding   symbol:  xschem/LOOP_FILTER.sym # of pins=4
** sym_path: /home/designer/shared/LC_VCO_FPLL/xschem/LOOP_FILTER.sym
** sch_path: /home/designer/shared/LC_VCO_FPLL/xschem/LOOP_FILTER.sch
.subckt LOOP_FILTER OUT IN GND SUB!
*.PININFO OUT:O GND:B IN:I SUB!:B
CC2 OUT GND cap_cmim w=18.63e-6 l=18.63e-6 m=4
CC1 net1 GND cap_cmim w=48.34e-6 l=48.34e-6 m=16
RR2 OUT IN 52.81k $SUB=SUB! $[rppd] w=2e-6 l=407.2e-6 b=0
RR1 net1 IN 52.81k $SUB=SUB! $[rppd] w=2e-6 l=407.2e-6 b=0
RR3 GND SUB! ptap1 A=4.6752e-11 P=0.00031168
RR4 GND SUB! ptap1 A=4.6752e-11 P=0.00031168
.ends

* expanding   symbol:  sg13g2_dfrbp_2.sym # of pins=5
** sym_path: /opt/pdks/ihp-sg13g2/libs.ref/sg13g2_stdcell/sym/xschem/sg13g2_dfrbp_2.sym
** sch_path: /opt/pdks/ihp-sg13g2/libs.ref/sg13g2_stdcell/sch/xschem/sg13g2_dfrbp_2.sch
.subckt sg13g2_dfrbp_2 Q Q_N CLK D RESET_B VDD VSS

*.PININFO D:I RESET_B:I CLK:I Q:O Q_N:O
MM1 Db D net12 VSS sg13_lv_nmos w=420.00n l=130.00n ng=1
MM2 net12 RESET_B VSS VSS sg13_lv_nmos w=420.00n l=130.00n ng=1
MM3 net2 clkneg net11 VSS sg13_lv_nmos w=420.00n l=130.00n ng=1
MM4 net11 net3 VSS VSS sg13_lv_nmos w=420.00n l=130.00n ng=1
MM5 net3 net2 net7 VSS sg13_lv_nmos w=420.00n l=130.00n ng=1
MM6 net7 RESET_B VSS VSS sg13_lv_nmos w=420.00n l=130.00n ng=1
MM7 Q_N net2 VSS VSS sg13_lv_nmos w=1.48u l=130.00n ng=2
MM8 net1 net2 VSS VSS sg13_lv_nmos w=640.00n l=130.00n ng=1
MM9 Q net1 VSS VSS sg13_lv_nmos w=1.48u l=130.00n ng=2
MM10 clkneg CLK VSS VSS sg13_lv_nmos w=740.00n l=130.00n ng=1
MM11 clkpos clkneg VSS VSS sg13_lv_nmos w=740.00n l=130.00n ng=1
MM12 Db clkneg net4 VSS sg13_lv_nmos w=420.00n l=130.00n ng=1
MM13 net4 clkpos net10 VSS sg13_lv_nmos w=420.00n l=130.00n ng=1
MM14 net10 net5 net6 VSS sg13_lv_nmos w=420.00n l=130.00n ng=1
MM15 net6 RESET_B VSS VSS sg13_lv_nmos w=420.00n l=130.00n ng=1
MM16 net5 net4 VSS VSS sg13_lv_nmos w=740.00n l=130.00n ng=1
MM17 net5 clkpos net2 VSS sg13_lv_nmos w=740.00n l=130.00n ng=1
MM18 Db RESET_B VDD VDD sg13_lv_pmos w=420.00n l=130.00n ng=1
MM19 Db D VDD VDD sg13_lv_pmos w=420.00n l=130.00n ng=1
MM20 net9 net3 VDD VDD sg13_lv_pmos w=420.00n l=130.00n ng=1
MM21 net2 clkpos net9 VDD sg13_lv_pmos w=420.00n l=130.00n ng=1
MM22 net3 net2 VDD VDD sg13_lv_pmos w=420.00n l=130.00n ng=1
MM23 net3 RESET_B VDD VDD sg13_lv_pmos w=420.00n l=130.00n ng=1
MM24 Q_N net2 VDD VDD sg13_lv_pmos w=2.24u l=130.00n ng=2
MM25 net1 net2 VDD VDD sg13_lv_pmos w=1.000u l=130.00n ng=1
MM26 Q net1 VDD VDD sg13_lv_pmos w=2.24u l=130.00n ng=2
MM27 clkneg CLK VDD VDD sg13_lv_pmos w=1.12u l=130.00n ng=1
MM28 clkpos clkneg VDD VDD sg13_lv_pmos w=1.12u l=130.00n ng=1
MM29 Db clkpos net4 VDD sg13_lv_pmos w=420.00n l=130.00n ng=1
MM30 net8 net5 VDD VDD sg13_lv_pmos w=420.00n l=130.00n ng=1
MM31 net4 clkneg net8 VDD sg13_lv_pmos w=420.00n l=130.00n ng=1
MM32 net4 RESET_B VDD VDD sg13_lv_pmos w=420.00n l=130.00n ng=1
MM33 net5 net4 VDD VDD sg13_lv_pmos w=1.000u l=130.00n ng=1
MM34 net5 clkneg net2 VDD sg13_lv_pmos w=1.000u l=130.00n ng=1
.ends

* expanding   symbol:  sg13g2_nand2_2.sym # of pins=3
** sym_path: /opt/pdks/ihp-sg13g2/libs.ref/sg13g2_stdcell/sym/xschem/sg13g2_nand2_2.sym
** sch_path: /opt/pdks/ihp-sg13g2/libs.ref/sg13g2_stdcell/sch/xschem/sg13g2_nand2_2.sch
.subckt sg13g2_nand2_2 Y A B VDD VSS

*.PININFO Y:O B:I A:I
MM1 Y A net1 VSS sg13_lv_nmos w=1.44u l=130.00n ng=2
MM2 net1 B VSS VSS sg13_lv_nmos w=1.44u l=130.00n ng=2
MM3 Y A VDD VDD sg13_lv_pmos w=2.24u l=130.00n ng=2
MM4 Y B VDD VDD sg13_lv_pmos w=2.24u l=130.00n ng=2
.ends

.GLOBAL VSS
.GLOBAL VDD
.GLOBAL GND
